* amp_dpc: magic R+C extraction of layout/amp_dpc.gds (layout/pex.sh)
.subckt amp_dpc inp inn nb outp outn VDD VSS
X0 outn inp sp VSS.t26 sky130_fd_pr__nfet_01v8 ad=0.75 pd=5.3 as=0.75 ps=5.3 w=5 l=0.15
X1 sp nb VSS.t4 VSS.t7 sky130_fd_pr__nfet_01v8 ad=0.45 pd=3.3 as=0.45 ps=3.3 w=3 l=0.5
X2 VSS.t13 nb sn VSS.t15 sky130_fd_pr__nfet_01v8 ad=0.45 pd=3.3 as=0.45 ps=3.3 w=3 l=0.5
X3 sp inp outn VSS.t27 sky130_fd_pr__nfet_01v8 ad=1.5 pd=10.6 as=0.75 ps=5.3 w=5 l=0.15
X4 VSS.t4 nb sp VSS.t3 sky130_fd_pr__nfet_01v8 ad=0.45 pd=3.3 as=0.45 ps=3.3 w=3 l=0.5
X5 sn nb VSS.t13 VSS.t16 sky130_fd_pr__nfet_01v8 ad=0.45 pd=3.3 as=0.45 ps=3.3 w=3 l=0.5
X6 sp sn sky130_fd_pr__cap_mim_m3_1 l=12.07 w=12.07
X7 sn nb VSS.t11 VSS.t10 sky130_fd_pr__nfet_01v8 ad=0.45 pd=3.3 as=0.9 ps=6.6 w=3 l=0.5
X8 sp nb VSS.t4 VSS.t5 sky130_fd_pr__nfet_01v8 ad=0.45 pd=3.3 as=0.45 ps=3.3 w=3 l=0.5
X9 VDD outp VSS.t0 sky130_fd_pr__res_high_po_0p69 l=7.38
X10 VSS.t9 nb sp VSS.t8 sky130_fd_pr__nfet_01v8 ad=0.9 pd=6.6 as=0.45 ps=3.3 w=3 l=0.5
X11 VSS.t18 nb sn VSS.t17 sky130_fd_pr__nfet_01v8 ad=0.9 pd=6.6 as=0.45 ps=3.3 w=3 l=0.5
X12 VSS.t13 nb sn VSS.t12 sky130_fd_pr__nfet_01v8 ad=0.45 pd=3.3 as=0.45 ps=3.3 w=3 l=0.5
X13 sn sp sky130_fd_pr__cap_mim_m3_1 l=12.07 w=12.07
X14 sp nb VSS.t2 VSS.t1 sky130_fd_pr__nfet_01v8 ad=0.45 pd=3.3 as=0.9 ps=6.6 w=3 l=0.5
X15 VDD outn VSS.t23 sky130_fd_pr__res_high_po_0p69 l=7.38
X16 outp inn sn VSS.t19 sky130_fd_pr__nfet_01v8 ad=0.75 pd=5.3 as=1.5 ps=10.6 w=5 l=0.15
X17 sn inn outp VSS.t20 sky130_fd_pr__nfet_01v8 ad=0.75 pd=5.3 as=0.75 ps=5.3 w=5 l=0.15
X18 sn nb VSS.t13 VSS.t14 sky130_fd_pr__nfet_01v8 ad=0.45 pd=3.3 as=0.45 ps=3.3 w=3 l=0.5
X19 VSS.t4 nb sp VSS.t6 sky130_fd_pr__nfet_01v8 ad=0.45 pd=3.3 as=0.45 ps=3.3 w=3 l=0.5
X20 outp inn sn VSS.t21 sky130_fd_pr__nfet_01v8 ad=0.75 pd=5.3 as=0.75 ps=5.3 w=5 l=0.15
X21 outn inp sp VSS.t24 sky130_fd_pr__nfet_01v8 ad=0.75 pd=5.3 as=1.5 ps=10.6 w=5 l=0.15
X22 sp inp outn VSS.t25 sky130_fd_pr__nfet_01v8 ad=0.75 pd=5.3 as=0.75 ps=5.3 w=5 l=0.15
X23 sn inn outp VSS.t22 sky130_fd_pr__nfet_01v8 ad=1.5 pd=10.6 as=0.75 ps=5.3 w=5 l=0.15
R0 VSS.n389 VSS.n388 585
R1 VSS.n390 VSS.n360 585
R2 VSS.n391 VSS.n359 585
R3 VSS.n372 VSS.n65 585
R4 VSS.n392 VSS.n358 585
R5 VSS.n393 VSS.n357 585
R6 VSS.n394 VSS.n356 585
R7 VSS.n374 VSS.n355 585
R8 VSS.n386 VSS.n354 585
R9 VSS.n395 VSS.n354 585
R10 VSS.n396 VSS.n353 585
R11 VSS.n397 VSS.n352 585
R12 VSS.n386 VSS.n369 585
R13 VSS.n369 VSS.n351 585
R14 VSS.n398 VSS.n350 585
R15 VSS.n399 VSS.n349 585
R16 VSS.n400 VSS.n348 585
R17 VSS.n366 VSS.n347 585
R18 VSS.n401 VSS.n346 585
R19 VSS.n402 VSS.n345 585
R20 VSS.n403 VSS.n344 585
R21 VSS.n377 VSS.n343 585
R22 VSS.n404 VSS.n342 585
R23 VSS.n405 VSS.n341 585
R24 VSS.n386 VSS.n340 585
R25 VSS.n406 VSS.n340 585
R26 VSS.n364 VSS.n339 585
R27 VSS.n407 VSS.n338 585
R28 VSS.n386 VSS.n337 585
R29 VSS.n408 VSS.n337 585
R30 VSS.n409 VSS.n336 585
R31 VSS.n380 VSS.n335 585
R32 VSS.n410 VSS.n334 585
R33 VSS.n411 VSS.n333 585
R34 VSS.n412 VSS.n332 585
R35 VSS.n382 VSS.n331 585
R36 VSS.n413 VSS.n330 585
R37 VSS.n414 VSS.n329 585
R38 VSS.n386 VSS.n328 585
R39 VSS.n415 VSS.n328 585
R40 VSS.n361 VSS.n327 585
R41 VSS.n416 VSS.n326 585
R42 VSS.n417 VSS.n325 585
R43 VSS.n418 VSS.n324 585
R44 VSS.n320 VSS.n319 585
R45 VSS.n319 VSS.n318 585
R46 VSS.n422 VSS.n421 585
R47 VSS.n423 VSS.n422 585
R48 VSS.n321 VSS.n316 585
R49 VSS.n317 VSS.n316 585
R50 VSS.n427 VSS.n425 585
R51 VSS.n425 VSS.n424 585
R52 VSS.n426 VSS.n310 585
R53 VSS.n310 VSS.n309 585
R54 VSS.n433 VSS.n432 585
R55 VSS.n434 VSS.n433 585
R56 VSS.n311 VSS.n307 585
R57 VSS.n308 VSS.n307 585
R58 VSS.n438 VSS.n436 585
R59 VSS.n436 VSS.n435 585
R60 VSS.n437 VSS.n301 585
R61 VSS.n301 VSS.n300 585
R62 VSS.n444 VSS.n443 585
R63 VSS.n445 VSS.n444 585
R64 VSS.n302 VSS.n298 585
R65 VSS.n299 VSS.n298 585
R66 VSS.n448 VSS.n447 585
R67 VSS.n447 VSS.n446 585
R68 VSS.n293 VSS.n292 585
R69 VSS.n292 VSS.n291 585
R70 VSS.n454 VSS.n453 585
R71 VSS.n455 VSS.n454 585
R72 VSS.n289 VSS.n288 585
R73 VSS.n290 VSS.n289 585
R74 VSS.n458 VSS.n457 585
R75 VSS.n457 VSS.n456 585
R76 VSS.n283 VSS.n282 585
R77 VSS.n282 VSS.n281 585
R78 VSS.n464 VSS.n463 585
R79 VSS.n465 VSS.n464 585
R80 VSS.n279 VSS.n278 585
R81 VSS.n280 VSS.n279 585
R82 VSS.n468 VSS.n467 585
R83 VSS.n467 VSS.n466 585
R84 VSS.n273 VSS.n272 585
R85 VSS.n272 VSS.n271 585
R86 VSS.n474 VSS.n473 585
R87 VSS.n475 VSS.n474 585
R88 VSS.n269 VSS.n268 585
R89 VSS.n270 VSS.n269 585
R90 VSS.n478 VSS.n477 585
R91 VSS.n477 VSS.n476 585
R92 VSS.n263 VSS.n262 585
R93 VSS.n262 VSS.n261 585
R94 VSS.n484 VSS.n483 585
R95 VSS.n485 VSS.n484 585
R96 VSS.n259 VSS.n258 585
R97 VSS.n260 VSS.n259 585
R98 VSS.n488 VSS.n487 585
R99 VSS.n487 VSS.n486 585
R100 VSS.n253 VSS.n252 585
R101 VSS.n252 VSS.n251 585
R102 VSS.n494 VSS.n493 585
R103 VSS.n495 VSS.n494 585
R104 VSS.n249 VSS.n248 585
R105 VSS.n250 VSS.n249 585
R106 VSS.n498 VSS.n497 585
R107 VSS.n497 VSS.n496 585
R108 VSS.n242 VSS.n241 585
R109 VSS.n241 VSS.n240 585
R110 VSS.n504 VSS.n503 585
R111 VSS.n505 VSS.n504 585
R112 VSS.n243 VSS.n238 585
R113 VSS.n239 VSS.n238 585
R114 VSS.n508 VSS.n507 585
R115 VSS.n507 VSS.n506 585
R116 VSS.n233 VSS.n232 585
R117 VSS.n232 VSS.n231 585
R118 VSS.n514 VSS.n513 585
R119 VSS.n515 VSS.n514 585
R120 VSS.n229 VSS.n228 585
R121 VSS.n230 VSS.n229 585
R122 VSS.n518 VSS.n517 585
R123 VSS.n517 VSS.n516 585
R124 VSS.n223 VSS.n222 585
R125 VSS.n222 VSS.n221 585
R126 VSS.n524 VSS.n523 585
R127 VSS.n525 VSS.n524 585
R128 VSS.n219 VSS.n218 585
R129 VSS.n220 VSS.n219 585
R130 VSS.n528 VSS.n527 585
R131 VSS.n527 VSS.n526 585
R132 VSS.n213 VSS.n212 585
R133 VSS.n212 VSS.n211 585
R134 VSS.n534 VSS.n533 585
R135 VSS.n535 VSS.n534 585
R136 VSS.n209 VSS.n208 585
R137 VSS.n210 VSS.n209 585
R138 VSS.n538 VSS.n537 585
R139 VSS.n537 VSS.n536 585
R140 VSS.n203 VSS.n202 585
R141 VSS.n202 VSS.n201 585
R142 VSS.n544 VSS.n543 585
R143 VSS.n545 VSS.n544 585
R144 VSS.n199 VSS.n198 585
R145 VSS.n200 VSS.n199 585
R146 VSS.n548 VSS.n547 585
R147 VSS.n547 VSS.n546 585
R148 VSS.n193 VSS.n192 585
R149 VSS.n192 VSS.n191 585
R150 VSS.n554 VSS.n553 585
R151 VSS.n555 VSS.n554 585
R152 VSS.n189 VSS.n188 585
R153 VSS.n190 VSS.n189 585
R154 VSS.n558 VSS.n557 585
R155 VSS.n557 VSS.n556 585
R156 VSS.n182 VSS.n181 585
R157 VSS.n181 VSS.n180 585
R158 VSS.n564 VSS.n563 585
R159 VSS.n565 VSS.n564 585
R160 VSS.n183 VSS.n178 585
R161 VSS.n179 VSS.n178 585
R162 VSS.n568 VSS.n567 585
R163 VSS.n567 VSS.n566 585
R164 VSS.n173 VSS.n172 585
R165 VSS.n172 VSS.n171 585
R166 VSS.n574 VSS.n573 585
R167 VSS.n575 VSS.n574 585
R168 VSS.n167 VSS.n166 585
R169 VSS.n169 VSS.n167 585
R170 VSS.n578 VSS.n577 585
R171 VSS.n577 VSS.n576 585
R172 VSS.n168 VSS.n161 585
R173 VSS.n170 VSS.n168 585
R174 VSS.n583 VSS.n160 585
R175 VSS.n160 VSS.n159 585
R176 VSS.n585 VSS.n584 585
R177 VSS.n586 VSS.n585 585
R178 VSS.n590 VSS.n156 585
R179 VSS.n157 VSS.n156 585
R180 VSS.n589 VSS.n588 585
R181 VSS.n588 VSS.n587 585
R182 VSS.n595 VSS.n150 585
R183 VSS.n158 VSS.n150 585
R184 VSS.n597 VSS.n596 585
R185 VSS.n597 VSS.n151 585
R186 VSS.n599 VSS.n598 585
R187 VSS.n598 VSS.n122 585
R188 VSS.n126 VSS.n123 585
R189 VSS.n677 VSS.n123 585
R190 VSS.n673 VSS.n672 585
R191 VSS.n672 VSS.n671 585
R192 VSS.n147 VSS.n146 585
R193 VSS.n670 VSS.n602 585
R194 VSS.n669 VSS.n603 585
R195 VSS.n668 VSS.n604 585
R196 VSS.n606 VSS.n605 585
R197 VSS.n667 VSS.n607 585
R198 VSS.n666 VSS.n608 585
R199 VSS.n665 VSS.n609 585
R200 VSS.n611 VSS.n610 585
R201 VSS.n664 VSS.n612 585
R202 VSS.n663 VSS.n613 585
R203 VSS.n662 VSS.n614 585
R204 VSS.n616 VSS.n615 585
R205 VSS.n661 VSS.n617 585
R206 VSS.n660 VSS.n618 585
R207 VSS.n659 VSS.n619 585
R208 VSS.n621 VSS.n620 585
R209 VSS.n658 VSS.n622 585
R210 VSS.n657 VSS.n623 585
R211 VSS.n656 VSS.n624 585
R212 VSS.n626 VSS.n625 585
R213 VSS.n655 VSS.n627 585
R214 VSS.n654 VSS.n628 585
R215 VSS.n653 VSS.n629 585
R216 VSS.n631 VSS.n630 585
R217 VSS.n652 VSS.n632 585
R218 VSS.n651 VSS.n633 585
R219 VSS.n650 VSS.n634 585
R220 VSS.n636 VSS.n635 585
R221 VSS.n649 VSS.n637 585
R222 VSS.n648 VSS.n638 585
R223 VSS.n647 VSS.n639 585
R224 VSS.n121 VSS.n640 585
R225 VSS.n646 VSS.n641 585
R226 VSS.n645 VSS.n642 585
R227 VSS.n644 VSS.n643 585
R228 VSS.n125 VSS.n124 585
R229 VSS.n676 VSS.n675 585
R230 VSS.n145 VSS.n126 585
R231 VSS.n10 VSS.n145 585
R232 VSS.n600 VSS.n599 585
R233 VSS.n601 VSS.n600 585
R234 VSS.n596 VSS.n149 585
R235 VSS.n149 VSS.n148 585
R236 VSS.n595 VSS.n594 585
R237 VSS.n594 VSS.n593 585
R238 VSS.n589 VSS.n152 585
R239 VSS.n153 VSS.n152 585
R240 VSS.n591 VSS.n590 585
R241 VSS.n592 VSS.n591 585
R242 VSS.n584 VSS.n155 585
R243 VSS.n155 VSS.n154 585
R244 VSS.n583 VSS.n582 585
R245 VSS.n582 VSS.n581 585
R246 VSS.n162 VSS.n161 585
R247 VSS.n163 VSS.n162 585
R248 VSS.n579 VSS.n578 585
R249 VSS.n580 VSS.n579 585
R250 VSS.n166 VSS.n165 585
R251 VSS.n165 VSS.n164 585
R252 VSS.n573 VSS.n572 585
R253 VSS.n572 VSS.n571 585
R254 VSS.n174 VSS.n173 585
R255 VSS.n175 VSS.n174 585
R256 VSS.n569 VSS.n568 585
R257 VSS.n570 VSS.n569 585
R258 VSS.n183 VSS.n177 585
R259 VSS.n177 VSS.n176 585
R260 VSS.n563 VSS.n562 585
R261 VSS.n562 VSS.n561 585
R262 VSS.n184 VSS.n182 585
R263 VSS.n185 VSS.n184 585
R264 VSS.n559 VSS.n558 585
R265 VSS.n560 VSS.n559 585
R266 VSS.n188 VSS.n187 585
R267 VSS.n187 VSS.n186 585
R268 VSS.n553 VSS.n552 585
R269 VSS.n552 VSS.n551 585
R270 VSS.n194 VSS.n193 585
R271 VSS.n195 VSS.n194 585
R272 VSS.n549 VSS.n548 585
R273 VSS.n550 VSS.n549 585
R274 VSS.n198 VSS.n197 585
R275 VSS.n197 VSS.n196 585
R276 VSS.n543 VSS.n542 585
R277 VSS.n542 VSS.n541 585
R278 VSS.n204 VSS.n203 585
R279 VSS.n205 VSS.n204 585
R280 VSS.n539 VSS.n538 585
R281 VSS.n540 VSS.n539 585
R282 VSS.n208 VSS.n207 585
R283 VSS.n207 VSS.n206 585
R284 VSS.n533 VSS.n532 585
R285 VSS.n532 VSS.n531 585
R286 VSS.n214 VSS.n213 585
R287 VSS.n215 VSS.n214 585
R288 VSS.n529 VSS.n528 585
R289 VSS.n530 VSS.n529 585
R290 VSS.n218 VSS.n217 585
R291 VSS.n217 VSS.n216 585
R292 VSS.n523 VSS.n522 585
R293 VSS.n522 VSS.n521 585
R294 VSS.n224 VSS.n223 585
R295 VSS.n225 VSS.n224 585
R296 VSS.n519 VSS.n518 585
R297 VSS.n520 VSS.n519 585
R298 VSS.n228 VSS.n227 585
R299 VSS.n227 VSS.n226 585
R300 VSS.n513 VSS.n512 585
R301 VSS.n512 VSS.n511 585
R302 VSS.n234 VSS.n233 585
R303 VSS.n235 VSS.n234 585
R304 VSS.n509 VSS.n508 585
R305 VSS.n510 VSS.n509 585
R306 VSS.n243 VSS.n237 585
R307 VSS.n237 VSS.n236 585
R308 VSS.n503 VSS.n502 585
R309 VSS.n502 VSS.n501 585
R310 VSS.n244 VSS.n242 585
R311 VSS.n245 VSS.n244 585
R312 VSS.n499 VSS.n498 585
R313 VSS.n500 VSS.n499 585
R314 VSS.n248 VSS.n247 585
R315 VSS.n247 VSS.n246 585
R316 VSS.n493 VSS.n492 585
R317 VSS.n492 VSS.n491 585
R318 VSS.n254 VSS.n253 585
R319 VSS.n255 VSS.n254 585
R320 VSS.n489 VSS.n488 585
R321 VSS.n490 VSS.n489 585
R322 VSS.n258 VSS.n257 585
R323 VSS.n257 VSS.n256 585
R324 VSS.n483 VSS.n482 585
R325 VSS.n482 VSS.n481 585
R326 VSS.n264 VSS.n263 585
R327 VSS.n265 VSS.n264 585
R328 VSS.n479 VSS.n478 585
R329 VSS.n480 VSS.n479 585
R330 VSS.n268 VSS.n267 585
R331 VSS.n267 VSS.n266 585
R332 VSS.n473 VSS.n472 585
R333 VSS.n472 VSS.n471 585
R334 VSS.n274 VSS.n273 585
R335 VSS.n275 VSS.n274 585
R336 VSS.n469 VSS.n468 585
R337 VSS.n470 VSS.n469 585
R338 VSS.n278 VSS.n277 585
R339 VSS.n277 VSS.n276 585
R340 VSS.n463 VSS.n462 585
R341 VSS.n462 VSS.n461 585
R342 VSS.n284 VSS.n283 585
R343 VSS.n285 VSS.n284 585
R344 VSS.n459 VSS.n458 585
R345 VSS.n460 VSS.n459 585
R346 VSS.n288 VSS.n287 585
R347 VSS.n287 VSS.n286 585
R348 VSS.n453 VSS.n452 585
R349 VSS.n452 VSS.n451 585
R350 VSS.n294 VSS.n293 585
R351 VSS.n295 VSS.n294 585
R352 VSS.n449 VSS.n448 585
R353 VSS.n450 VSS.n449 585
R354 VSS.n302 VSS.n297 585
R355 VSS.n297 VSS.n296 585
R356 VSS.n443 VSS.n442 585
R357 VSS.n442 VSS.n441 585
R358 VSS.n437 VSS.n303 585
R359 VSS.n304 VSS.n303 585
R360 VSS.n439 VSS.n438 585
R361 VSS.n440 VSS.n439 585
R362 VSS.n311 VSS.n306 585
R363 VSS.n306 VSS.n305 585
R364 VSS.n432 VSS.n431 585
R365 VSS.n431 VSS.n430 585
R366 VSS.n426 VSS.n312 585
R367 VSS.n313 VSS.n312 585
R368 VSS.n428 VSS.n427 585
R369 VSS.n429 VSS.n428 585
R370 VSS.n321 VSS.n315 585
R371 VSS.n315 VSS.n314 585
R372 VSS.n421 VSS.n420 585
R373 VSS.n420 VSS.n419 585
R374 VSS.n322 VSS.n320 585
R375 VSS.n323 VSS.n322 585
R376 VSS.n324 VSS.n322 504.812
R377 VSS.n388 VSS.n319 504.812
R378 VSS.n675 VSS.n123 504.812
R379 VSS.n672 VSS.n145 504.812
R380 VSS.n387 VSS.n386 254.01
R381 VSS.n386 VSS.n373 254.01
R382 VSS.n386 VSS.n371 254.01
R383 VSS.n386 VSS.n375 254.01
R384 VSS.n386 VSS.n370 254.01
R385 VSS.n386 VSS.n368 254.01
R386 VSS.n386 VSS.n367 254.01
R387 VSS.n386 VSS.n376 254.01
R388 VSS.n386 VSS.n378 254.01
R389 VSS.n386 VSS.n379 254.01
R390 VSS.n386 VSS.n365 254.01
R391 VSS.n386 VSS.n381 254.01
R392 VSS.n386 VSS.n363 254.01
R393 VSS.n386 VSS.n383 254.01
R394 VSS.n386 VSS.n384 254.01
R395 VSS.n386 VSS.n362 254.01
R396 VSS.n386 VSS.n385 254.01
R397 VSS.n673 VSS.n144 254.01
R398 VSS.n673 VSS.n143 254.01
R399 VSS.n673 VSS.n142 254.01
R400 VSS.n673 VSS.n141 254.01
R401 VSS.n673 VSS.n140 254.01
R402 VSS.n673 VSS.n139 254.01
R403 VSS.n673 VSS.n138 254.01
R404 VSS.n673 VSS.n137 254.01
R405 VSS.n673 VSS.n136 254.01
R406 VSS.n673 VSS.n135 254.01
R407 VSS.n673 VSS.n134 254.01
R408 VSS.n673 VSS.n133 254.01
R409 VSS.n673 VSS.n132 254.01
R410 VSS.n673 VSS.n131 254.01
R411 VSS.n673 VSS.n130 254.01
R412 VSS.n673 VSS.n129 254.01
R413 VSS.n673 VSS.n128 254.01
R414 VSS.n673 VSS.n127 254.01
R415 VSS.n674 VSS.n673 254.01
R416 VSS.n600 VSS.n145 177.3
R417 VSS.n600 VSS.n149 177.3
R418 VSS.n594 VSS.n149 177.3
R419 VSS.n594 VSS.n152 177.3
R420 VSS.n591 VSS.n152 177.3
R421 VSS.n591 VSS.n155 177.3
R422 VSS.n582 VSS.n155 177.3
R423 VSS.n582 VSS.n162 177.3
R424 VSS.n579 VSS.n162 177.3
R425 VSS.n579 VSS.n165 177.3
R426 VSS.n572 VSS.n165 177.3
R427 VSS.n572 VSS.n174 177.3
R428 VSS.n569 VSS.n174 177.3
R429 VSS.n569 VSS.n177 177.3
R430 VSS.n562 VSS.n177 177.3
R431 VSS.n562 VSS.n184 177.3
R432 VSS.n559 VSS.n184 177.3
R433 VSS.n559 VSS.n187 177.3
R434 VSS.n552 VSS.n187 177.3
R435 VSS.n552 VSS.n194 177.3
R436 VSS.n549 VSS.n194 177.3
R437 VSS.n549 VSS.n197 177.3
R438 VSS.n542 VSS.n197 177.3
R439 VSS.n542 VSS.n204 177.3
R440 VSS.n539 VSS.n204 177.3
R441 VSS.n539 VSS.n207 177.3
R442 VSS.n532 VSS.n207 177.3
R443 VSS.n532 VSS.n214 177.3
R444 VSS.n529 VSS.n214 177.3
R445 VSS.n529 VSS.n217 177.3
R446 VSS.n522 VSS.n217 177.3
R447 VSS.n522 VSS.n224 177.3
R448 VSS.n519 VSS.n224 177.3
R449 VSS.n519 VSS.n227 177.3
R450 VSS.n512 VSS.n227 177.3
R451 VSS.n512 VSS.n234 177.3
R452 VSS.n509 VSS.n234 177.3
R453 VSS.n509 VSS.n237 177.3
R454 VSS.n502 VSS.n237 177.3
R455 VSS.n502 VSS.n244 177.3
R456 VSS.n499 VSS.n244 177.3
R457 VSS.n499 VSS.n247 177.3
R458 VSS.n492 VSS.n247 177.3
R459 VSS.n492 VSS.n254 177.3
R460 VSS.n489 VSS.n254 177.3
R461 VSS.n489 VSS.n257 177.3
R462 VSS.n482 VSS.n257 177.3
R463 VSS.n482 VSS.n264 177.3
R464 VSS.n479 VSS.n264 177.3
R465 VSS.n479 VSS.n267 177.3
R466 VSS.n472 VSS.n267 177.3
R467 VSS.n472 VSS.n274 177.3
R468 VSS.n469 VSS.n274 177.3
R469 VSS.n469 VSS.n277 177.3
R470 VSS.n462 VSS.n277 177.3
R471 VSS.n462 VSS.n284 177.3
R472 VSS.n459 VSS.n284 177.3
R473 VSS.n459 VSS.n287 177.3
R474 VSS.n452 VSS.n287 177.3
R475 VSS.n452 VSS.n294 177.3
R476 VSS.n449 VSS.n294 177.3
R477 VSS.n449 VSS.n297 177.3
R478 VSS.n442 VSS.n297 177.3
R479 VSS.n442 VSS.n303 177.3
R480 VSS.n439 VSS.n303 177.3
R481 VSS.n439 VSS.n306 177.3
R482 VSS.n431 VSS.n306 177.3
R483 VSS.n431 VSS.n312 177.3
R484 VSS.n428 VSS.n312 177.3
R485 VSS.n428 VSS.n315 177.3
R486 VSS.n420 VSS.n315 177.3
R487 VSS.n420 VSS.n322 177.3
R488 VSS.n360 VSS.n359 177.3
R489 VSS.n372 VSS.n358 177.3
R490 VSS.n357 VSS.n356 177.3
R491 VSS.n374 VSS.n354 177.3
R492 VSS.n354 VSS.n353 177.3
R493 VSS.n369 VSS.n352 177.3
R494 VSS.n369 VSS.n350 177.3
R495 VSS.n349 VSS.n348 177.3
R496 VSS.n366 VSS.n346 177.3
R497 VSS.n345 VSS.n344 177.3
R498 VSS.n377 VSS.n342 177.3
R499 VSS.n341 VSS.n340 177.3
R500 VSS.n364 VSS.n340 177.3
R501 VSS.n338 VSS.n337 177.3
R502 VSS.n337 VSS.n336 177.3
R503 VSS.n380 VSS.n334 177.3
R504 VSS.n333 VSS.n332 177.3
R505 VSS.n382 VSS.n330 177.3
R506 VSS.n329 VSS.n328 177.3
R507 VSS.n361 VSS.n328 177.3
R508 VSS.n326 VSS.n325 177.3
R509 VSS.n598 VSS.n123 177.3
R510 VSS.n598 VSS.n597 177.3
R511 VSS.n597 VSS.n150 177.3
R512 VSS.n588 VSS.n150 177.3
R513 VSS.n588 VSS.n156 177.3
R514 VSS.n585 VSS.n156 177.3
R515 VSS.n585 VSS.n160 177.3
R516 VSS.n168 VSS.n160 177.3
R517 VSS.n577 VSS.n168 177.3
R518 VSS.n577 VSS.n167 177.3
R519 VSS.n574 VSS.n167 177.3
R520 VSS.n574 VSS.n172 177.3
R521 VSS.n567 VSS.n172 177.3
R522 VSS.n567 VSS.n178 177.3
R523 VSS.n564 VSS.n178 177.3
R524 VSS.n564 VSS.n181 177.3
R525 VSS.n557 VSS.n181 177.3
R526 VSS.n557 VSS.n189 177.3
R527 VSS.n554 VSS.n189 177.3
R528 VSS.n554 VSS.n192 177.3
R529 VSS.n547 VSS.n192 177.3
R530 VSS.n547 VSS.n199 177.3
R531 VSS.n544 VSS.n199 177.3
R532 VSS.n544 VSS.n202 177.3
R533 VSS.n537 VSS.n202 177.3
R534 VSS.n537 VSS.n209 177.3
R535 VSS.n534 VSS.n209 177.3
R536 VSS.n534 VSS.n212 177.3
R537 VSS.n527 VSS.n212 177.3
R538 VSS.n527 VSS.n219 177.3
R539 VSS.n524 VSS.n219 177.3
R540 VSS.n524 VSS.n222 177.3
R541 VSS.n517 VSS.n222 177.3
R542 VSS.n517 VSS.n229 177.3
R543 VSS.n514 VSS.n229 177.3
R544 VSS.n514 VSS.n232 177.3
R545 VSS.n507 VSS.n232 177.3
R546 VSS.n507 VSS.n238 177.3
R547 VSS.n504 VSS.n238 177.3
R548 VSS.n504 VSS.n241 177.3
R549 VSS.n497 VSS.n241 177.3
R550 VSS.n497 VSS.n249 177.3
R551 VSS.n494 VSS.n249 177.3
R552 VSS.n494 VSS.n252 177.3
R553 VSS.n487 VSS.n252 177.3
R554 VSS.n487 VSS.n259 177.3
R555 VSS.n484 VSS.n259 177.3
R556 VSS.n484 VSS.n262 177.3
R557 VSS.n477 VSS.n262 177.3
R558 VSS.n477 VSS.n269 177.3
R559 VSS.n474 VSS.n269 177.3
R560 VSS.n474 VSS.n272 177.3
R561 VSS.n467 VSS.n272 177.3
R562 VSS.n467 VSS.n279 177.3
R563 VSS.n464 VSS.n279 177.3
R564 VSS.n464 VSS.n282 177.3
R565 VSS.n457 VSS.n282 177.3
R566 VSS.n457 VSS.n289 177.3
R567 VSS.n454 VSS.n289 177.3
R568 VSS.n454 VSS.n292 177.3
R569 VSS.n447 VSS.n292 177.3
R570 VSS.n447 VSS.n298 177.3
R571 VSS.n444 VSS.n298 177.3
R572 VSS.n444 VSS.n301 177.3
R573 VSS.n436 VSS.n301 177.3
R574 VSS.n436 VSS.n307 177.3
R575 VSS.n433 VSS.n307 177.3
R576 VSS.n433 VSS.n310 177.3
R577 VSS.n425 VSS.n310 177.3
R578 VSS.n425 VSS.n316 177.3
R579 VSS.n422 VSS.n316 177.3
R580 VSS.n422 VSS.n319 177.3
R581 VSS.n643 VSS.n125 177.3
R582 VSS.n642 VSS.n641 177.3
R583 VSS.n640 VSS.n639 177.3
R584 VSS.n638 VSS.n637 177.3
R585 VSS.n635 VSS.n634 177.3
R586 VSS.n633 VSS.n632 177.3
R587 VSS.n630 VSS.n629 177.3
R588 VSS.n628 VSS.n627 177.3
R589 VSS.n625 VSS.n624 177.3
R590 VSS.n623 VSS.n622 177.3
R591 VSS.n620 VSS.n619 177.3
R592 VSS.n618 VSS.n617 177.3
R593 VSS.n615 VSS.n614 177.3
R594 VSS.n613 VSS.n612 177.3
R595 VSS.n610 VSS.n609 177.3
R596 VSS.n608 VSS.n607 177.3
R597 VSS.n605 VSS.n604 177.3
R598 VSS.n603 VSS.n602 177.3
R599 VSS.n672 VSS.n146 177.3
R600 VSS.n673 VSS.n126 105.799
R601 VSS.n386 VSS.n320 105.799
R602 VSS.n387 VSS.n360 76.985
R603 VSS.n373 VSS.n372 76.985
R604 VSS.n371 VSS.n358 76.985
R605 VSS.n375 VSS.n374 76.985
R606 VSS.n370 VSS.n352 76.985
R607 VSS.n368 VSS.n350 76.985
R608 VSS.n367 VSS.n348 76.985
R609 VSS.n376 VSS.n345 76.985
R610 VSS.n378 VSS.n377 76.985
R611 VSS.n379 VSS.n341 76.985
R612 VSS.n365 VSS.n338 76.985
R613 VSS.n381 VSS.n380 76.985
R614 VSS.n363 VSS.n334 76.985
R615 VSS.n383 VSS.n382 76.985
R616 VSS.n384 VSS.n329 76.985
R617 VSS.n362 VSS.n326 76.985
R618 VSS.n385 VSS.n325 76.985
R619 VSS.n146 VSS.n144 76.985
R620 VSS.n603 VSS.n143 76.985
R621 VSS.n605 VSS.n142 76.985
R622 VSS.n608 VSS.n141 76.985
R623 VSS.n610 VSS.n140 76.985
R624 VSS.n613 VSS.n139 76.985
R625 VSS.n615 VSS.n138 76.985
R626 VSS.n618 VSS.n137 76.985
R627 VSS.n620 VSS.n136 76.985
R628 VSS.n623 VSS.n135 76.985
R629 VSS.n625 VSS.n134 76.985
R630 VSS.n628 VSS.n133 76.985
R631 VSS.n630 VSS.n132 76.985
R632 VSS.n633 VSS.n131 76.985
R633 VSS.n635 VSS.n130 76.985
R634 VSS.n638 VSS.n129 76.985
R635 VSS.n640 VSS.n128 76.985
R636 VSS.n642 VSS.n127 76.985
R637 VSS.n674 VSS.n125 76.985
R638 VSS.n388 VSS.n387 76.985
R639 VSS.n373 VSS.n359 76.985
R640 VSS.n371 VSS.n357 76.985
R641 VSS.n375 VSS.n356 76.985
R642 VSS.n370 VSS.n353 76.985
R643 VSS.n368 VSS.n349 76.985
R644 VSS.n367 VSS.n366 76.985
R645 VSS.n376 VSS.n346 76.985
R646 VSS.n378 VSS.n344 76.985
R647 VSS.n379 VSS.n342 76.985
R648 VSS.n365 VSS.n364 76.985
R649 VSS.n381 VSS.n336 76.985
R650 VSS.n363 VSS.n333 76.985
R651 VSS.n383 VSS.n332 76.985
R652 VSS.n384 VSS.n330 76.985
R653 VSS.n362 VSS.n361 76.985
R654 VSS.n385 VSS.n324 76.985
R655 VSS.n675 VSS.n674 76.985
R656 VSS.n643 VSS.n127 76.985
R657 VSS.n641 VSS.n128 76.985
R658 VSS.n639 VSS.n129 76.985
R659 VSS.n637 VSS.n130 76.985
R660 VSS.n634 VSS.n131 76.985
R661 VSS.n632 VSS.n132 76.985
R662 VSS.n629 VSS.n133 76.985
R663 VSS.n627 VSS.n134 76.985
R664 VSS.n624 VSS.n135 76.985
R665 VSS.n622 VSS.n136 76.985
R666 VSS.n619 VSS.n137 76.985
R667 VSS.n617 VSS.n138 76.985
R668 VSS.n614 VSS.n139 76.985
R669 VSS.n612 VSS.n140 76.985
R670 VSS.n609 VSS.n141 76.985
R671 VSS.n607 VSS.n142 76.985
R672 VSS.n604 VSS.n143 76.985
R673 VSS.n602 VSS.n144 76.985
R674 VSS.n599 VSS.n126 74.6822
R675 VSS.n583 VSS.n161 74.6822
R676 VSS.n578 VSS.n166 74.6822
R677 VSS.n573 VSS.n173 74.6822
R678 VSS.n568 VSS.n173 74.6822
R679 VSS.n563 VSS.n183 74.6822
R680 VSS.n563 VSS.n182 74.6822
R681 VSS.n558 VSS.n182 74.6822
R682 VSS.n558 VSS.n188 74.6822
R683 VSS.n553 VSS.n188 74.6822
R684 VSS.n553 VSS.n193 74.6822
R685 VSS.n548 VSS.n193 74.6822
R686 VSS.n548 VSS.n198 74.6822
R687 VSS.n543 VSS.n198 74.6822
R688 VSS.n543 VSS.n203 74.6822
R689 VSS.n538 VSS.n203 74.6822
R690 VSS.n538 VSS.n208 74.6822
R691 VSS.n533 VSS.n208 74.6822
R692 VSS.n533 VSS.n213 74.6822
R693 VSS.n528 VSS.n213 74.6822
R694 VSS.n528 VSS.n218 74.6822
R695 VSS.n523 VSS.n218 74.6822
R696 VSS.n523 VSS.n223 74.6822
R697 VSS.n518 VSS.n223 74.6822
R698 VSS.n518 VSS.n228 74.6822
R699 VSS.n513 VSS.n233 74.6822
R700 VSS.n508 VSS.n233 74.6822
R701 VSS.n503 VSS.n243 74.6822
R702 VSS.n503 VSS.n242 74.6822
R703 VSS.n498 VSS.n242 74.6822
R704 VSS.n498 VSS.n248 74.6822
R705 VSS.n493 VSS.n248 74.6822
R706 VSS.n493 VSS.n253 74.6822
R707 VSS.n488 VSS.n253 74.6822
R708 VSS.n488 VSS.n258 74.6822
R709 VSS.n483 VSS.n258 74.6822
R710 VSS.n483 VSS.n263 74.6822
R711 VSS.n478 VSS.n263 74.6822
R712 VSS.n478 VSS.n268 74.6822
R713 VSS.n473 VSS.n268 74.6822
R714 VSS.n473 VSS.n273 74.6822
R715 VSS.n468 VSS.n273 74.6822
R716 VSS.n468 VSS.n278 74.6822
R717 VSS.n463 VSS.n278 74.6822
R718 VSS.n463 VSS.n283 74.6822
R719 VSS.n458 VSS.n283 74.6822
R720 VSS.n458 VSS.n288 74.6822
R721 VSS.n453 VSS.n293 74.6822
R722 VSS.n448 VSS.n293 74.6822
R723 VSS.n443 VSS.n302 74.6822
R724 VSS.n438 VSS.n437 74.6822
R725 VSS.n421 VSS.n320 74.6822
R726 VSS.n183 VSS.t8 72.6078
R727 VSS.t10 VSS.n288 72.6078
R728 VSS.n595 VSS.t26 69.496
R729 VSS.n427 VSS.t20 69.496
R730 VSS.n590 VSS.t3 64.3098
R731 VSS.n432 VSS.t16 64.3098
R732 VSS.n584 VSS.t27 61.198
R733 VSS.t19 VSS.n311 61.198
R734 VSS.t7 VSS.n166 60.1608
R735 VSS.n302 VSS.t12 60.1608
R736 VSS.n508 VSS.t0 57.0491
R737 VSS.n513 VSS.t23 54.9746
R738 VSS.n596 VSS.t25 50.8256
R739 VSS.n321 VSS.t21 50.8256
R740 VSS.t5 VSS.n583 47.7138
R741 VSS.n438 VSS.t15 47.7138
R742 VSS.t6 VSS.n161 43.5649
R743 VSS.n437 VSS.t14 43.5649
R744 VSS.t1 VSS.t24 36.3041
R745 VSS.t22 VSS.t17 36.3041
R746 VSS.n389 VSS.n318 32.8005
R747 VSS.n677 VSS.n676 32.8005
R748 VSS.n671 VSS.n10 32.8005
R749 VSS.n418 VSS.n323 32.8005
R750 VSS.n599 VSS.t24 32.1551
R751 VSS.n421 VSS.t22 32.1551
R752 VSS.n578 VSS.t6 31.1179
R753 VSS.n443 VSS.t14 31.1179
R754 VSS.t18 VSS.t13 95.9611
R755 VSS.t11 VSS.t13 96.4373
R756 VSS.t9 VSS.t4 96.4373
R757 VSS.t2 VSS.t4 95.9611
R758 VSS.n584 VSS.t5 26.9689
R759 VSS.n311 VSS.t15 26.9689
R760 VSS.t25 VSS.n595 23.8572
R761 VSS.n427 VSS.t21 23.8572
R762 VSS.t23 VSS.n228 19.7082
R763 VSS.n243 VSS.t0 17.6337
R764 VSS.n573 VSS.t7 14.522
R765 VSS.n448 VSS.t12 14.522
R766 VSS.n590 VSS.t27 13.4847
R767 VSS.n432 VSS.t19 13.4847
R768 VSS.n390 VSS.n64 3.55797
R769 VSS.n391 VSS.n390 11.5205
R770 VSS.n66 VSS.n65 3.55797
R771 VSS.n392 VSS.n65 11.5205
R772 VSS.n393 VSS.n83 3.55797
R773 VSS.n394 VSS.n393 11.5205
R774 VSS.n394 VSS.n355 11.5205
R775 VSS.n395 VSS.n67 3.55797
R776 VSS.n396 VSS.n395 11.5205
R777 VSS.n397 VSS.n68 3.55797
R778 VSS.n397 VSS.n351 11.5205
R779 VSS.n398 VSS.n69 3.55797
R780 VSS.n399 VSS.n398 11.5205
R781 VSS.n400 VSS.n70 3.55797
R782 VSS.n400 VSS.n347 11.5205
R783 VSS.n401 VSS.n71 3.55797
R784 VSS.n402 VSS.n401 11.5205
R785 VSS.n403 VSS.n72 3.55797
R786 VSS.n403 VSS.n343 11.5205
R787 VSS.n404 VSS.n73 3.55797
R788 VSS.n405 VSS.n404 11.5205
R789 VSS.n406 VSS.n74 3.55797
R790 VSS.n406 VSS.n339 11.5205
R791 VSS.n407 VSS.n75 3.55797
R792 VSS.n408 VSS.n407 11.5205
R793 VSS.n409 VSS.n76 3.55797
R794 VSS.n409 VSS.n335 11.5205
R795 VSS.n410 VSS.n77 3.55797
R796 VSS.n411 VSS.n410 11.5205
R797 VSS.n412 VSS.n78 3.55797
R798 VSS.n412 VSS.n331 11.5205
R799 VSS.n413 VSS.n79 3.55797
R800 VSS.n414 VSS.n413 11.5205
R801 VSS.n415 VSS.n80 3.55797
R802 VSS.n415 VSS.n327 11.5205
R803 VSS.n416 VSS.n81 3.55797
R804 VSS.n417 VSS.n416 11.5205
R805 VSS.n418 VSS.n82 3.55797
R806 VSS.n677 VSS.n122 11.5205
R807 VSS.n151 VSS.n85 3.55797
R808 VSS.n158 VSS.n151 11.5205
R809 VSS.n587 VSS.n86 3.55797
R810 VSS.n587 VSS.n157 11.5205
R811 VSS.n586 VSS.n87 3.55797
R812 VSS.n586 VSS.n159 11.5205
R813 VSS.n170 VSS.n88 3.55797
R814 VSS.n576 VSS.n170 11.5205
R815 VSS.n89 VSS.n169 3.55797
R816 VSS.n575 VSS.n169 11.5205
R817 VSS.n90 VSS.n171 3.55797
R818 VSS.n566 VSS.n171 11.5205
R819 VSS.n91 VSS.n179 3.55797
R820 VSS.n565 VSS.n179 11.5205
R821 VSS.n92 VSS.n180 3.55797
R822 VSS.n556 VSS.n180 11.5205
R823 VSS.n93 VSS.n190 3.55797
R824 VSS.n555 VSS.n190 11.5205
R825 VSS.n94 VSS.n191 3.55797
R826 VSS.n546 VSS.n191 11.5205
R827 VSS.n95 VSS.n200 3.55797
R828 VSS.n545 VSS.n200 11.5205
R829 VSS.n96 VSS.n201 3.55797
R830 VSS.n536 VSS.n201 11.5205
R831 VSS.n97 VSS.n210 3.55797
R832 VSS.n535 VSS.n210 11.5205
R833 VSS.n98 VSS.n211 3.55797
R834 VSS.n526 VSS.n211 11.5205
R835 VSS.n99 VSS.n220 3.55797
R836 VSS.n525 VSS.n220 11.5205
R837 VSS.n100 VSS.n221 3.55797
R838 VSS.n516 VSS.n221 11.5205
R839 VSS.n101 VSS.n230 3.55797
R840 VSS.n515 VSS.n230 11.5205
R841 VSS.n102 VSS.n231 3.55797
R842 VSS.n506 VSS.n231 11.5205
R843 VSS.n103 VSS.n239 3.55797
R844 VSS.n505 VSS.n239 11.5205
R845 VSS.n104 VSS.n240 3.55797
R846 VSS.n496 VSS.n240 11.5205
R847 VSS.n105 VSS.n250 3.55797
R848 VSS.n495 VSS.n250 11.5205
R849 VSS.n106 VSS.n251 3.55797
R850 VSS.n486 VSS.n251 11.5205
R851 VSS.n107 VSS.n260 3.55797
R852 VSS.n485 VSS.n260 11.5205
R853 VSS.n108 VSS.n261 3.55797
R854 VSS.n476 VSS.n261 11.5205
R855 VSS.n109 VSS.n270 3.55797
R856 VSS.n475 VSS.n270 11.5205
R857 VSS.n110 VSS.n271 3.55797
R858 VSS.n466 VSS.n271 11.5205
R859 VSS.n111 VSS.n280 3.55797
R860 VSS.n465 VSS.n280 11.5205
R861 VSS.n112 VSS.n281 3.55797
R862 VSS.n456 VSS.n281 11.5205
R863 VSS.n113 VSS.n290 3.55797
R864 VSS.n455 VSS.n290 11.5205
R865 VSS.n114 VSS.n291 3.55797
R866 VSS.n446 VSS.n291 11.5205
R867 VSS.n115 VSS.n299 3.55797
R868 VSS.n445 VSS.n299 11.5205
R869 VSS.n116 VSS.n300 3.55797
R870 VSS.n435 VSS.n300 11.5205
R871 VSS.n117 VSS.n308 3.55797
R872 VSS.n434 VSS.n308 11.5205
R873 VSS.n118 VSS.n309 3.55797
R874 VSS.n424 VSS.n309 11.5205
R875 VSS.n119 VSS.n317 3.55797
R876 VSS.n423 VSS.n317 11.5205
R877 VSS.n120 VSS.n318 3.55797
R878 VSS.n676 VSS.n124 11.5205
R879 VSS.n644 VSS.n11 3.55797
R880 VSS.n645 VSS.n644 11.5205
R881 VSS.n646 VSS.n645 11.5205
R882 VSS.n646 VSS.n84 3.55797
R883 VSS.n647 VSS.n121 11.5205
R884 VSS.n648 VSS.n647 11.5205
R885 VSS.n649 VSS.n12 3.55797
R886 VSS.n649 VSS.n636 11.5205
R887 VSS.n650 VSS.n13 3.55797
R888 VSS.n651 VSS.n650 11.5205
R889 VSS.n652 VSS.n14 3.55797
R890 VSS.n652 VSS.n631 11.5205
R891 VSS.n653 VSS.n15 3.55797
R892 VSS.n654 VSS.n653 11.5205
R893 VSS.n655 VSS.n16 3.55797
R894 VSS.n655 VSS.n626 11.5205
R895 VSS.n656 VSS.n17 3.55797
R896 VSS.n657 VSS.n656 11.5205
R897 VSS.n658 VSS.n18 3.55797
R898 VSS.n658 VSS.n621 11.5205
R899 VSS.n659 VSS.n19 3.55797
R900 VSS.n660 VSS.n659 11.5205
R901 VSS.n661 VSS.n20 3.55797
R902 VSS.n661 VSS.n616 11.5205
R903 VSS.n662 VSS.n21 3.55797
R904 VSS.n663 VSS.n662 11.5205
R905 VSS.n664 VSS.n22 3.55797
R906 VSS.n664 VSS.n611 11.5205
R907 VSS.n665 VSS.n23 3.55797
R908 VSS.n666 VSS.n665 11.5205
R909 VSS.n667 VSS.n24 3.55797
R910 VSS.n667 VSS.n606 11.5205
R911 VSS.n668 VSS.n25 3.55797
R912 VSS.n669 VSS.n668 11.5205
R913 VSS.n670 VSS.n26 3.55797
R914 VSS.n670 VSS.n147 11.5205
R915 VSS.n671 VSS.n27 3.55797
R916 VSS.n601 VSS.n10 11.5205
R917 VSS.n28 VSS.n148 3.55797
R918 VSS.n593 VSS.n148 11.5205
R919 VSS.n29 VSS.n153 3.55797
R920 VSS.n592 VSS.n153 11.5205
R921 VSS.n30 VSS.n154 3.55797
R922 VSS.n581 VSS.n154 11.5205
R923 VSS.n31 VSS.n163 3.55797
R924 VSS.n580 VSS.n163 11.5205
R925 VSS.n32 VSS.n164 3.55797
R926 VSS.n571 VSS.n164 11.5205
R927 VSS.n33 VSS.n175 3.55797
R928 VSS.n570 VSS.n175 11.5205
R929 VSS.n34 VSS.n176 3.55797
R930 VSS.n561 VSS.n176 11.5205
R931 VSS.n35 VSS.n185 3.55797
R932 VSS.n560 VSS.n185 11.5205
R933 VSS.n36 VSS.n186 3.55797
R934 VSS.n551 VSS.n186 11.5205
R935 VSS.n37 VSS.n195 3.55797
R936 VSS.n550 VSS.n195 11.5205
R937 VSS.n38 VSS.n196 3.55797
R938 VSS.n541 VSS.n196 11.5205
R939 VSS.n39 VSS.n205 3.55797
R940 VSS.n540 VSS.n205 11.5205
R941 VSS.n40 VSS.n206 3.55797
R942 VSS.n531 VSS.n206 11.5205
R943 VSS.n41 VSS.n215 3.55797
R944 VSS.n530 VSS.n215 11.5205
R945 VSS.n42 VSS.n216 3.55797
R946 VSS.n521 VSS.n216 11.5205
R947 VSS.n43 VSS.n225 3.55797
R948 VSS.n520 VSS.n225 11.5205
R949 VSS.n44 VSS.n226 3.55797
R950 VSS.n511 VSS.n226 11.5205
R951 VSS.n45 VSS.n235 3.55797
R952 VSS.n510 VSS.n235 11.5205
R953 VSS.n46 VSS.n236 3.55797
R954 VSS.n501 VSS.n236 11.5205
R955 VSS.n47 VSS.n245 3.55797
R956 VSS.n500 VSS.n245 11.5205
R957 VSS.n48 VSS.n246 3.55797
R958 VSS.n491 VSS.n246 11.5205
R959 VSS.n49 VSS.n255 3.55797
R960 VSS.n490 VSS.n255 11.5205
R961 VSS.n50 VSS.n256 3.55797
R962 VSS.n481 VSS.n256 11.5205
R963 VSS.n51 VSS.n265 3.55797
R964 VSS.n480 VSS.n265 11.5205
R965 VSS.n52 VSS.n266 3.55797
R966 VSS.n471 VSS.n266 11.5205
R967 VSS.n53 VSS.n275 3.55797
R968 VSS.n470 VSS.n275 11.5205
R969 VSS.n54 VSS.n276 3.55797
R970 VSS.n461 VSS.n276 11.5205
R971 VSS.n55 VSS.n285 3.55797
R972 VSS.n460 VSS.n285 11.5205
R973 VSS.n56 VSS.n286 3.55797
R974 VSS.n451 VSS.n286 11.5205
R975 VSS.n57 VSS.n295 3.55797
R976 VSS.n450 VSS.n295 11.5205
R977 VSS.n58 VSS.n296 3.55797
R978 VSS.n441 VSS.n296 11.5205
R979 VSS.n59 VSS.n304 3.55797
R980 VSS.n440 VSS.n304 11.5205
R981 VSS.n60 VSS.n305 3.55797
R982 VSS.n430 VSS.n305 11.5205
R983 VSS.n61 VSS.n313 3.55797
R984 VSS.n429 VSS.n313 11.5205
R985 VSS.n62 VSS.n314 3.55797
R986 VSS.n419 VSS.n314 11.5205
R987 VSS.n63 VSS.n323 3.55797
R988 VSS.t3 VSS.n589 10.373
R989 VSS.n426 VSS.t16 10.373
R990 VSS.n120 VSS.n0 2.87251
R991 VSS.n120 VSS.n423 3.55797
R992 VSS.n0 VSS.n119 2.87251
R993 VSS.n424 VSS.n119 3.55797
R994 VSS.n118 VSS.n0 2.87251
R995 VSS.n118 VSS.n434 3.55797
R996 VSS.n0 VSS.n117 2.87251
R997 VSS.n435 VSS.n117 3.55797
R998 VSS.n116 VSS.n0 2.87251
R999 VSS.n116 VSS.n445 3.55797
R1000 VSS.n0 VSS.n115 2.87251
R1001 VSS.n446 VSS.n115 3.55797
R1002 VSS.n114 VSS.n9 2.87251
R1003 VSS.n114 VSS.n455 3.55797
R1004 VSS.n9 VSS.n113 2.87251
R1005 VSS.n456 VSS.n113 3.55797
R1006 VSS.n112 VSS.n9 2.87251
R1007 VSS.n112 VSS.n465 3.55797
R1008 VSS.n9 VSS.n111 2.87251
R1009 VSS.n466 VSS.n111 3.55797
R1010 VSS.n110 VSS.n9 2.87251
R1011 VSS.n110 VSS.n475 3.55797
R1012 VSS.n9 VSS.n109 2.87251
R1013 VSS.n476 VSS.n109 3.55797
R1014 VSS.n108 VSS.n9 2.87251
R1015 VSS.n108 VSS.n485 3.55797
R1016 VSS.n9 VSS.n107 2.87251
R1017 VSS.n486 VSS.n107 3.55797
R1018 VSS.n106 VSS.n9 2.87251
R1019 VSS.n106 VSS.n495 3.55797
R1020 VSS.n9 VSS.n105 2.87251
R1021 VSS.n496 VSS.n105 3.55797
R1022 VSS.n104 VSS.n9 2.87251
R1023 VSS.n104 VSS.n505 3.55797
R1024 VSS.n9 VSS.n103 2.87251
R1025 VSS.n506 VSS.n103 3.55797
R1026 VSS.n102 VSS 2.87251
R1027 VSS.n102 VSS.n515 3.55797
R1028 VSS VSS.n101 2.87251
R1029 VSS.n516 VSS.n101 3.55797
R1030 VSS.n100 VSS 2.87251
R1031 VSS.n100 VSS.n525 3.55797
R1032 VSS VSS.n99 2.87251
R1033 VSS.n526 VSS.n99 3.55797
R1034 VSS.n98 VSS 2.87251
R1035 VSS.n98 VSS.n535 3.55797
R1036 VSS VSS.n97 2.87251
R1037 VSS.n536 VSS.n97 3.55797
R1038 VSS.n96 VSS 2.87251
R1039 VSS.n96 VSS.n545 3.55797
R1040 VSS VSS.n95 2.87251
R1041 VSS.n546 VSS.n95 3.55797
R1042 VSS.n94 VSS 2.87251
R1043 VSS.n94 VSS.n555 3.55797
R1044 VSS VSS.n93 2.87251
R1045 VSS.n556 VSS.n93 3.55797
R1046 VSS.n92 VSS 2.87251
R1047 VSS.n92 VSS.n565 3.55797
R1048 VSS VSS.n91 2.87251
R1049 VSS.n566 VSS.n91 3.55797
R1050 VSS.n90 VSS 2.87251
R1051 VSS.n90 VSS.n575 3.55797
R1052 VSS VSS.n89 2.87251
R1053 VSS.n576 VSS.n89 3.55797
R1054 VSS VSS.n88 2.87251
R1055 VSS.n159 VSS.n88 3.55797
R1056 VSS VSS.n87 2.87251
R1057 VSS.n87 VSS.n157 3.55797
R1058 VSS.n86 VSS 2.87251
R1059 VSS.n86 VSS.n158 3.55797
R1060 VSS VSS.n85 2.87251
R1061 VSS.n122 VSS.n85 3.55797
R1062 VSS VSS.n677 9.3005
R1063 VSS.n27 VSS.n6 2.87251
R1064 VSS.n27 VSS.n147 3.55797
R1065 VSS.n6 VSS.n26 2.87251
R1066 VSS.n669 VSS.n26 3.55797
R1067 VSS.n25 VSS.n6 2.87251
R1068 VSS.n25 VSS.n606 3.55797
R1069 VSS.n6 VSS.n24 2.87251
R1070 VSS.n666 VSS.n24 3.55797
R1071 VSS.n23 VSS.n6 2.87251
R1072 VSS.n23 VSS.n611 3.55797
R1073 VSS.n6 VSS.n22 2.87251
R1074 VSS.n663 VSS.n22 3.55797
R1075 VSS.n21 VSS.n6 2.87251
R1076 VSS.n21 VSS.n616 3.55797
R1077 VSS.n6 VSS.n20 2.87251
R1078 VSS.n660 VSS.n20 3.55797
R1079 VSS.n19 VSS.n6 2.87251
R1080 VSS.n19 VSS.n621 3.55797
R1081 VSS.n7 VSS.n18 2.87251
R1082 VSS.n657 VSS.n18 3.55797
R1083 VSS.n17 VSS.n7 2.87251
R1084 VSS.n17 VSS.n626 3.55797
R1085 VSS.n7 VSS.n16 2.87251
R1086 VSS.n654 VSS.n16 3.55797
R1087 VSS.n15 VSS.n7 2.87251
R1088 VSS.n15 VSS.n631 3.55797
R1089 VSS.n7 VSS.n14 2.87251
R1090 VSS.n651 VSS.n14 3.55797
R1091 VSS.n13 VSS.n7 2.87251
R1092 VSS.n13 VSS.n636 3.55797
R1093 VSS.n7 VSS.n12 2.87251
R1094 VSS.n648 VSS.n12 3.55797
R1095 VSS.n647 VSS.n7 9.3005
R1096 VSS.n84 VSS.n121 3.55797
R1097 VSS VSS.n84 2.87251
R1098 VSS.n645 VSS 9.3005
R1099 VSS.n11 VSS 2.87251
R1100 VSS.n11 VSS.n124 3.55797
R1101 VSS.n676 VSS 9.3005
R1102 VSS.n6 VSS.n10 9.3005
R1103 VSS.n28 VSS.n601 3.55797
R1104 VSS.n28 VSS.n6 2.87251
R1105 VSS.n593 VSS.n29 3.55797
R1106 VSS.n5 VSS.n29 2.87251
R1107 VSS.n30 VSS.n592 3.55797
R1108 VSS.n30 VSS.n5 2.87251
R1109 VSS.n581 VSS.n31 3.55797
R1110 VSS.n5 VSS.n31 2.87251
R1111 VSS.n32 VSS.n580 3.55797
R1112 VSS.n32 VSS.n5 2.87251
R1113 VSS.n571 VSS.n33 3.55797
R1114 VSS.n5 VSS.n33 2.87251
R1115 VSS.n34 VSS.n570 3.55797
R1116 VSS.n34 VSS.n5 2.87251
R1117 VSS.n561 VSS.n35 3.55797
R1118 VSS.n5 VSS.n35 2.87251
R1119 VSS.n36 VSS.n560 3.55797
R1120 VSS.n36 VSS.n5 2.87251
R1121 VSS.n551 VSS.n37 3.55797
R1122 VSS.n4 VSS.n37 2.87251
R1123 VSS.n38 VSS.n550 3.55797
R1124 VSS.n38 VSS.n4 2.87251
R1125 VSS.n541 VSS.n39 3.55797
R1126 VSS.n4 VSS.n39 2.87251
R1127 VSS.n40 VSS.n540 3.55797
R1128 VSS.n40 VSS.n4 2.87251
R1129 VSS.n531 VSS.n41 3.55797
R1130 VSS.n4 VSS.n41 2.87251
R1131 VSS.n42 VSS.n530 3.55797
R1132 VSS.n42 VSS.n4 2.87251
R1133 VSS.n521 VSS.n43 3.55797
R1134 VSS.n4 VSS.n43 2.87251
R1135 VSS.n44 VSS.n520 3.55797
R1136 VSS.n44 VSS.n4 2.87251
R1137 VSS.n511 VSS.n45 3.55797
R1138 VSS.n2 VSS.n45 2.87251
R1139 VSS.n46 VSS.n510 3.55797
R1140 VSS.n46 VSS.n2 2.87251
R1141 VSS.n501 VSS.n47 3.55797
R1142 VSS.n2 VSS.n47 2.87251
R1143 VSS.n48 VSS.n500 3.55797
R1144 VSS.n48 VSS.n2 2.87251
R1145 VSS.n491 VSS.n49 3.55797
R1146 VSS.n2 VSS.n49 2.87251
R1147 VSS.n50 VSS.n490 3.55797
R1148 VSS.n50 VSS.n2 2.87251
R1149 VSS.n481 VSS.n51 3.55797
R1150 VSS.n2 VSS.n51 2.87251
R1151 VSS.n52 VSS.n480 3.55797
R1152 VSS.n52 VSS.n2 2.87251
R1153 VSS.n471 VSS.n53 3.55797
R1154 VSS.n3 VSS.n53 2.87251
R1155 VSS.n54 VSS.n470 3.55797
R1156 VSS.n54 VSS.n3 2.87251
R1157 VSS.n461 VSS.n55 3.55797
R1158 VSS.n3 VSS.n55 2.87251
R1159 VSS.n56 VSS.n460 3.55797
R1160 VSS.n56 VSS.n3 2.87251
R1161 VSS.n451 VSS.n57 3.55797
R1162 VSS.n3 VSS.n57 2.87251
R1163 VSS.n58 VSS.n450 3.55797
R1164 VSS.n58 VSS.n3 2.87251
R1165 VSS.n441 VSS.n59 3.55797
R1166 VSS.n3 VSS.n59 2.87251
R1167 VSS.n60 VSS.n440 3.55797
R1168 VSS.n60 VSS.n3 2.87251
R1169 VSS.n430 VSS.n61 3.55797
R1170 VSS.n8 VSS.n61 2.87251
R1171 VSS.n62 VSS.n429 3.55797
R1172 VSS.n62 VSS.n8 2.87251
R1173 VSS.n419 VSS.n63 3.55797
R1174 VSS.n8 VSS.n63 2.87251
R1175 VSS.n389 VSS.n64 3.55797
R1176 VSS.n64 VSS.n0 2.87251
R1177 VSS.n66 VSS.n391 3.55797
R1178 VSS.n0 VSS.n66 2.87251
R1179 VSS.n392 VSS.n83 3.55797
R1180 VSS.n83 VSS.n0 2.87251
R1181 VSS.n0 VSS.n394 9.3005
R1182 VSS.n67 VSS.n355 3.55797
R1183 VSS.n67 VSS.n0 2.87251
R1184 VSS.n396 VSS.n68 3.55797
R1185 VSS.n0 VSS.n68 2.87251
R1186 VSS.n69 VSS.n351 3.55797
R1187 VSS.n69 VSS.n0 2.87251
R1188 VSS.n399 VSS.n70 3.55797
R1189 VSS.n0 VSS.n70 2.87251
R1190 VSS.n71 VSS.n347 3.55797
R1191 VSS.n71 VSS.n1 2.87251
R1192 VSS.n402 VSS.n72 3.55797
R1193 VSS.n1 VSS.n72 2.87251
R1194 VSS.n73 VSS.n343 3.55797
R1195 VSS.n73 VSS.n1 2.87251
R1196 VSS.n405 VSS.n74 3.55797
R1197 VSS.n1 VSS.n74 2.87251
R1198 VSS.n75 VSS.n339 3.55797
R1199 VSS.n75 VSS.n1 2.87251
R1200 VSS.n408 VSS.n76 3.55797
R1201 VSS.n1 VSS.n76 2.87251
R1202 VSS.n77 VSS.n335 3.55797
R1203 VSS.n77 VSS.n1 2.87251
R1204 VSS.n411 VSS.n78 3.55797
R1205 VSS.n1 VSS.n78 2.87251
R1206 VSS.n79 VSS.n331 3.55797
R1207 VSS.n79 VSS.n8 2.87251
R1208 VSS.n414 VSS.n80 3.55797
R1209 VSS.n8 VSS.n80 2.87251
R1210 VSS.n81 VSS.n327 3.55797
R1211 VSS.n81 VSS.n8 2.87251
R1212 VSS.n417 VSS.n82 3.55797
R1213 VSS.n8 VSS.n82 2.87251
R1214 VSS.n596 VSS.t1 6.22398
R1215 VSS.t17 VSS.n321 6.22398
R1216 VSS.n0 VSS.t13 5.69098
R1217 VSS VSS.t4 5.69098
R1218 VSS.n589 VSS.t26 5.18673
R1219 VSS.t20 VSS.n426 5.18673
R1220 VSS.n5 VSS.n6 2.57081
R1221 VSS.n8 VSS.n3 2.34581
R1222 VSS.n568 VSS.t8 2.07499
R1223 VSS.n453 VSS.t10 2.07499
R1224 VSS.n6 VSS.n7 1.8005
R1225 VSS.n4 VSS.n5 1.8005
R1226 VSS.n2 VSS.n4 1.8005
R1227 VSS.n3 VSS.n2 1.8005
R1228 VSS.n8 VSS.n1 1.8005
R1229 VSS.n1 VSS.n0 1.688
R1230 VSS.n9 VSS 1.40774
R1231 VSS.n7 VSS 1.28644
R1232 VSS.n0 VSS.n9 1.08907
C0 outp inn 0.68731f
C1 outp nb 0.25349f
C2 VDD sp 0.2065f
C3 inp sn 0.00847f
C4 inn nb 0.00605f
C5 outn outp 0.20582f
C6 outn inn 0.88901f
C7 outn nb 0.25379f
C8 inp sp 0.68926f
C9 outp sn 4.62433f
C10 inn sn 0.76393f
C11 sn nb 2.52102f
C12 inp VDD 0.01749f
C13 sp outp 0.02589f
C14 outn sn 0.06666f
C15 sp inn 0.02062f
C16 sp nb 2.71032f
C17 VDD outp 0.07138f
C18 outn sp 4.59948f
C19 VDD inn 0.51599f
C20 VDD outn 1.28585f
C21 sp sn 4.94687f
C22 inp inn 0.14801f
C23 inp nb 0.00609f
C24 VDD sn 0.31783f
C25 inp outn 0.37141f
C26 outp VSS 3.75842f
C27 outn VSS 3.32259f
C28 VDD VSS 8.15342f
C29 sn VSS 1.18637f
C30 sp VSS 21.5907f
C31 VSS.t4 VSS 4.26519f
.ends
