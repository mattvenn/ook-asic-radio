* amp_dpc: magic R+C extraction of layout/amp_dpc.gds (layout/pex.sh)
.subckt amp_dpc inp inn nb outp outn VDD VSS
X0 outn.t0 inp.t1 sp VSS.t32 sky130_fd_pr__nfet_01v8 ad=0.75 pd=5.3 as=0.75 ps=5.3 w=5 l=0.15
X1 sp nb.t7 VSS.t10 VSS.t9 sky130_fd_pr__nfet_01v8 ad=0.45 pd=3.3 as=0.45 ps=3.3 w=3 l=0.5
X2 VSS.t20 nb.t2 sn VSS.t19 sky130_fd_pr__nfet_01v8 ad=0.45 pd=3.3 as=0.45 ps=3.3 w=3 l=0.5
X3 sp inp.t0 outn.t3 VSS.t33 sky130_fd_pr__nfet_01v8 ad=1.5 pd=10.6 as=0.75 ps=5.3 w=5 l=0.15
X4 VSS.t4 nb.t10 sp VSS.t3 sky130_fd_pr__nfet_01v8 ad=0.45 pd=3.3 as=0.45 ps=3.3 w=3 l=0.5
X5 sn nb.t1 VSS.t22 VSS.t21 sky130_fd_pr__nfet_01v8 ad=0.45 pd=3.3 as=0.45 ps=3.3 w=3 l=0.5
X6 sp sn sky130_fd_pr__cap_mim_m3_1 l=12.07 w=12.07
X7 sn nb.t5 VSS.t14 VSS.t13 sky130_fd_pr__nfet_01v8 ad=0.45 pd=3.3 as=0.9 ps=6.6 w=3 l=0.5
X8 sp nb.t9 VSS.t6 VSS.t5 sky130_fd_pr__nfet_01v8 ad=0.45 pd=3.3 as=0.45 ps=3.3 w=3 l=0.5
X9 VDD.t0 outp.t3 VSS.t0 sky130_fd_pr__res_high_po_0p69 l=7.38
X10 VSS.t12 nb.t6 sp VSS.t11 sky130_fd_pr__nfet_01v8 ad=0.9 pd=6.6 as=0.45 ps=3.3 w=3 l=0.5
X11 VSS.t24 nb.t0 sn VSS.t23 sky130_fd_pr__nfet_01v8 ad=0.9 pd=6.6 as=0.45 ps=3.3 w=3 l=0.5
X12 VSS.t16 nb.t4 sn VSS.t15 sky130_fd_pr__nfet_01v8 ad=0.45 pd=3.3 as=0.45 ps=3.3 w=3 l=0.5
X13 sn sp sky130_fd_pr__cap_mim_m3_1 l=12.07 w=12.07
X14 sp nb.t11 VSS.t2 VSS.t1 sky130_fd_pr__nfet_01v8 ad=0.45 pd=3.3 as=0.9 ps=6.6 w=3 l=0.5
X15 VDD.t1 outn.t4 VSS.t29 sky130_fd_pr__res_high_po_0p69 l=7.38
X16 outp.t0 inn.t3 sn VSS.t25 sky130_fd_pr__nfet_01v8 ad=0.75 pd=5.3 as=1.5 ps=10.6 w=5 l=0.15
X17 sn inn.t2 outp.t4 VSS.t26 sky130_fd_pr__nfet_01v8 ad=0.75 pd=5.3 as=0.75 ps=5.3 w=5 l=0.15
X18 sn nb.t3 VSS.t18 VSS.t17 sky130_fd_pr__nfet_01v8 ad=0.45 pd=3.3 as=0.45 ps=3.3 w=3 l=0.5
X19 VSS.t8 nb.t8 sp VSS.t7 sky130_fd_pr__nfet_01v8 ad=0.45 pd=3.3 as=0.45 ps=3.3 w=3 l=0.5
X20 outp.t2 inn.t1 sn VSS.t27 sky130_fd_pr__nfet_01v8 ad=0.75 pd=5.3 as=0.75 ps=5.3 w=5 l=0.15
X21 outn.t2 inp.t3 sp VSS.t30 sky130_fd_pr__nfet_01v8 ad=0.75 pd=5.3 as=1.5 ps=10.6 w=5 l=0.15
X22 sp inp.t2 outn.t1 VSS.t31 sky130_fd_pr__nfet_01v8 ad=0.75 pd=5.3 as=0.75 ps=5.3 w=5 l=0.15
X23 sn inn.t0 outp.t1 VSS.t28 sky130_fd_pr__nfet_01v8 ad=1.5 pd=10.6 as=0.75 ps=5.3 w=5 l=0.15
R0 outp.n2 outp.n0 20.4066
R1 outp.n2 outp.n1 20.1386
R2 outp.n3 outp.t3 11.3995
R3 outp outp.n3 7.78383
R4 outp.n1 outp.t4 3.6005
R5 outp.n1 outp.t0 3.6005
R6 outp.n0 outp.t1 3.6005
R7 outp.n0 outp.t2 3.6005
R8 outp.n3 outp.n2 1.2505
R9 inn.n0 inn.t2 1283.29
R10 inn.n2 inn.t0 1283.29
R11 inn.n0 inn.t3 1058.42
R12 inn.n1 inn.t1 1058.36
R13 inn inn.n2 12.977
R14 inn.n2 inn.n1 0.0609839
R15 inn.n1 inn.n0 0.0609839
R16 nb.n1 nb.t0 408.575
R17 nb.n11 nb.t10 408.567
R18 nb.n9 nb.t8 408.567
R19 nb.n7 nb.t6 408.567
R20 nb.n5 nb.t4 408.567
R21 nb.n3 nb.t2 408.567
R22 nb.n12 nb.t11 341.096
R23 nb.n10 nb.t9 341.087
R24 nb.n8 nb.t7 341.087
R25 nb.n6 nb.t5 341.087
R26 nb.n4 nb.t3 341.087
R27 nb.n2 nb.t1 341.087
R28 nb.n13 nb.n0 3.28141
R29 nb.n7 nb.n6 2.22362
R30 nb.n1 nb.n0 1.5005
R31 nb.n13 nb.n12 1.5005
R32 nb nb.n13 0.412462
R33 nb.n0 nb 0.345258
R34 nb.n3 nb.n2 0.108027
R35 nb.n4 nb.n3 0.108027
R36 nb.n5 nb.n4 0.108027
R37 nb.n6 nb.n5 0.108027
R38 nb.n8 nb.n7 0.108027
R39 nb.n9 nb.n8 0.108027
R40 nb.n10 nb.n9 0.108027
R41 nb.n11 nb.n10 0.108027
R42 nb.n2 nb.n1 0.0992903
R43 nb.n12 nb.n11 0.0992903
R44 outn.n2 outn.n0 20.4065
R45 outn.n2 outn.n1 20.1388
R46 outn.n3 outn.t4 11.4026
R47 outn outn.n3 10.5922
R48 outn.n0 outn.t1 3.6005
R49 outn.n0 outn.t2 3.6005
R50 outn.n1 outn.t3 3.6005
R51 outn.n1 outn.t0 3.6005
R52 outn.n3 outn.n2 1.2505
R53 VDD.n0 VDD.t0 8.00396
R54 VDD.n0 VDD.t1 8.00313
R55 VDD VDD.n0 1.28484
R56 inp.n0 inp.t0 1283.35
R57 inp.n1 inp.t2 1283.29
R58 inp.n2 inp.t3 1058.36
R59 inp.n0 inp.t1 1058.36
R60 inp inp.n2 8.78697
R61 inp.n1 inp.n0 0.0609839
R62 inp.n2 inp.n1 0.0609839
R63 VSS.n239 VSS.n238 585
R64 VSS.n238 VSS.n236 585
R65 VSS.n406 VSS.n405 585
R66 VSS.n407 VSS.n406 585
R67 VSS.n230 VSS.n229 585
R68 VSS.n237 VSS.n230 585
R69 VSS.n418 VSS.n417 585
R70 VSS.n417 VSS.n416 585
R71 VSS.n227 VSS.n226 585
R72 VSS.n415 VSS.n226 585
R73 VSS.n423 VSS.n422 585
R74 VSS.n424 VSS.n423 585
R75 VSS.n219 VSS.n218 585
R76 VSS.n225 VSS.n219 585
R77 VSS.n435 VSS.n434 585
R78 VSS.n434 VSS.n433 585
R79 VSS.n216 VSS.n215 585
R80 VSS.n432 VSS.n215 585
R81 VSS.n440 VSS.n439 585
R82 VSS.n441 VSS.n440 585
R83 VSS.n208 VSS.n207 585
R84 VSS.n214 VSS.n208 585
R85 VSS.n451 VSS.n450 585
R86 VSS.n450 VSS.n449 585
R87 VSS.n205 VSS.n204 585
R88 VSS.n204 VSS.n203 585
R89 VSS.n456 VSS.n455 585
R90 VSS.n457 VSS.n456 585
R91 VSS.n196 VSS.n195 585
R92 VSS.n197 VSS.n196 585
R93 VSS.n467 VSS.n466 585
R94 VSS.n466 VSS.n465 585
R95 VSS.n193 VSS.n192 585
R96 VSS.n192 VSS.n191 585
R97 VSS.n472 VSS.n471 585
R98 VSS.n473 VSS.n472 585
R99 VSS.n184 VSS.n183 585
R100 VSS.n185 VSS.n184 585
R101 VSS.n483 VSS.n482 585
R102 VSS.n482 VSS.n481 585
R103 VSS.n181 VSS.n180 585
R104 VSS.n180 VSS.n179 585
R105 VSS.n488 VSS.n487 585
R106 VSS.n489 VSS.n488 585
R107 VSS.n172 VSS.n171 585
R108 VSS.n173 VSS.n172 585
R109 VSS.n499 VSS.n498 585
R110 VSS.n498 VSS.n497 585
R111 VSS.n169 VSS.n168 585
R112 VSS.n168 VSS.n167 585
R113 VSS.n504 VSS.n503 585
R114 VSS.n505 VSS.n504 585
R115 VSS.n160 VSS.n159 585
R116 VSS.n161 VSS.n160 585
R117 VSS.n515 VSS.n514 585
R118 VSS.n514 VSS.n513 585
R119 VSS.n157 VSS.n156 585
R120 VSS.n156 VSS.n155 585
R121 VSS.n520 VSS.n519 585
R122 VSS.n521 VSS.n520 585
R123 VSS.n148 VSS.n147 585
R124 VSS.n149 VSS.n148 585
R125 VSS.n531 VSS.n530 585
R126 VSS.n530 VSS.n529 585
R127 VSS.n145 VSS.n144 585
R128 VSS.n144 VSS.n142 585
R129 VSS.n536 VSS.n535 585
R130 VSS.n537 VSS.n536 585
R131 VSS.n136 VSS.n135 585
R132 VSS.n143 VSS.n136 585
R133 VSS.n547 VSS.n546 585
R134 VSS.n546 VSS.n545 585
R135 VSS.n133 VSS.n132 585
R136 VSS.n132 VSS.n131 585
R137 VSS.n552 VSS.n551 585
R138 VSS.n553 VSS.n552 585
R139 VSS.n124 VSS.n123 585
R140 VSS.n125 VSS.n124 585
R141 VSS.n563 VSS.n562 585
R142 VSS.n562 VSS.n561 585
R143 VSS.n121 VSS.n120 585
R144 VSS.n120 VSS.n119 585
R145 VSS.n568 VSS.n567 585
R146 VSS.n569 VSS.n568 585
R147 VSS.n112 VSS.n111 585
R148 VSS.n113 VSS.n112 585
R149 VSS.n579 VSS.n578 585
R150 VSS.n578 VSS.n577 585
R151 VSS.n109 VSS.n108 585
R152 VSS.n108 VSS.n107 585
R153 VSS.n584 VSS.n583 585
R154 VSS.n585 VSS.n584 585
R155 VSS.n100 VSS.n99 585
R156 VSS.n101 VSS.n100 585
R157 VSS.n595 VSS.n594 585
R158 VSS.n594 VSS.n593 585
R159 VSS.n97 VSS.n96 585
R160 VSS.n96 VSS.n95 585
R161 VSS.n600 VSS.n599 585
R162 VSS.n601 VSS.n600 585
R163 VSS.n88 VSS.n87 585
R164 VSS.n89 VSS.n88 585
R165 VSS.n611 VSS.n610 585
R166 VSS.n610 VSS.n609 585
R167 VSS.n85 VSS.n84 585
R168 VSS.n84 VSS.n83 585
R169 VSS.n616 VSS.n615 585
R170 VSS.n617 VSS.n616 585
R171 VSS.n76 VSS.n75 585
R172 VSS.n77 VSS.n76 585
R173 VSS.n627 VSS.n626 585
R174 VSS.n626 VSS.n625 585
R175 VSS.n73 VSS.n72 585
R176 VSS.n72 VSS.n70 585
R177 VSS.n632 VSS.n631 585
R178 VSS.n633 VSS.n632 585
R179 VSS.n64 VSS.n63 585
R180 VSS.n71 VSS.n64 585
R181 VSS.n643 VSS.n642 585
R182 VSS.n642 VSS.n641 585
R183 VSS.n61 VSS.n60 585
R184 VSS.n60 VSS.n59 585
R185 VSS.n648 VSS.n647 585
R186 VSS.n649 VSS.n648 585
R187 VSS.n50 VSS.n49 585
R188 VSS.n51 VSS.n50 585
R189 VSS.n660 VSS.n659 585
R190 VSS.n659 VSS.n658 585
R191 VSS.n47 VSS.n46 585
R192 VSS.n46 VSS.n45 585
R193 VSS.n665 VSS.n664 585
R194 VSS.n666 VSS.n665 585
R195 VSS.n38 VSS.n37 585
R196 VSS.n667 VSS.n38 585
R197 VSS.n680 VSS.n679 585
R198 VSS.n679 VSS.n678 585
R199 VSS.n35 VSS.n34 585
R200 VSS.n677 VSS.n34 585
R201 VSS.n685 VSS.n684 585
R202 VSS.n686 VSS.n685 585
R203 VSS.n31 VSS.n30 585
R204 VSS.n687 VSS.n31 585
R205 VSS.n692 VSS.n691 585
R206 VSS.n691 VSS.n690 585
R207 VSS.n27 VSS.n25 585
R208 VSS.n25 VSS.n6 585
R209 VSS.n834 VSS.n833 585
R210 VSS.n5 VSS.n4 585
R211 VSS.n749 VSS.n746 585
R212 VSS.n750 VSS.n745 585
R213 VSS.n751 VSS.n744 585
R214 VSS.n742 VSS.n741 585
R215 VSS.n781 VSS.n740 585
R216 VSS.n782 VSS.n739 585
R217 VSS.n783 VSS.n738 585
R218 VSS.n736 VSS.n735 585
R219 VSS.n787 VSS.n734 585
R220 VSS.n788 VSS.n733 585
R221 VSS.n789 VSS.n732 585
R222 VSS.n730 VSS.n729 585
R223 VSS.n793 VSS.n728 585
R224 VSS.n794 VSS.n727 585
R225 VSS.n795 VSS.n726 585
R226 VSS.n724 VSS.n723 585
R227 VSS.n799 VSS.n722 585
R228 VSS.n800 VSS.n721 585
R229 VSS.n801 VSS.n720 585
R230 VSS.n718 VSS.n717 585
R231 VSS.n805 VSS.n716 585
R232 VSS.n806 VSS.n715 585
R233 VSS.n807 VSS.n714 585
R234 VSS.n712 VSS.n711 585
R235 VSS.n811 VSS.n710 585
R236 VSS.n812 VSS.n709 585
R237 VSS.n813 VSS.n708 585
R238 VSS.n706 VSS.n705 585
R239 VSS.n817 VSS.n704 585
R240 VSS.n818 VSS.n703 585
R241 VSS.n819 VSS.n702 585
R242 VSS.n700 VSS.n699 585
R243 VSS.n823 VSS.n698 585
R244 VSS.n824 VSS.n697 585
R245 VSS.n825 VSS.n696 585
R246 VSS.n28 VSS.n26 585
R247 VSS.n830 VSS.n829 585
R248 VSS.n831 VSS.n830 585
R249 VSS.n835 VSS.n3 585
R250 VSS.n6 VSS.n3 585
R251 VSS.n689 VSS.n2 585
R252 VSS.n690 VSS.n689 585
R253 VSS.n688 VSS.n33 585
R254 VSS.n688 VSS.n687 585
R255 VSS.n41 VSS.n32 585
R256 VSS.n686 VSS.n32 585
R257 VSS.n676 VSS.n675 585
R258 VSS.n677 VSS.n676 585
R259 VSS.n40 VSS.n39 585
R260 VSS.n678 VSS.n39 585
R261 VSS.n669 VSS.n668 585
R262 VSS.n668 VSS.n667 585
R263 VSS.n44 VSS.n43 585
R264 VSS.n666 VSS.n44 585
R265 VSS.n55 VSS.n53 585
R266 VSS.n53 VSS.n45 585
R267 VSS.n657 VSS.n656 585
R268 VSS.n658 VSS.n657 585
R269 VSS.n54 VSS.n52 585
R270 VSS.n52 VSS.n51 585
R271 VSS.n651 VSS.n650 585
R272 VSS.n650 VSS.n649 585
R273 VSS.n58 VSS.n57 585
R274 VSS.n59 VSS.n58 585
R275 VSS.n640 VSS.n639 585
R276 VSS.n641 VSS.n640 585
R277 VSS.n66 VSS.n65 585
R278 VSS.n71 VSS.n65 585
R279 VSS.n635 VSS.n634 585
R280 VSS.n634 VSS.n633 585
R281 VSS.n69 VSS.n68 585
R282 VSS.n70 VSS.n69 585
R283 VSS.n624 VSS.n623 585
R284 VSS.n625 VSS.n624 585
R285 VSS.n79 VSS.n78 585
R286 VSS.n78 VSS.n77 585
R287 VSS.n619 VSS.n618 585
R288 VSS.n618 VSS.n617 585
R289 VSS.n82 VSS.n81 585
R290 VSS.n83 VSS.n82 585
R291 VSS.n608 VSS.n607 585
R292 VSS.n609 VSS.n608 585
R293 VSS.n91 VSS.n90 585
R294 VSS.n90 VSS.n89 585
R295 VSS.n603 VSS.n602 585
R296 VSS.n602 VSS.n601 585
R297 VSS.n94 VSS.n93 585
R298 VSS.n95 VSS.n94 585
R299 VSS.n592 VSS.n591 585
R300 VSS.n593 VSS.n592 585
R301 VSS.n103 VSS.n102 585
R302 VSS.n102 VSS.n101 585
R303 VSS.n587 VSS.n586 585
R304 VSS.n586 VSS.n585 585
R305 VSS.n106 VSS.n105 585
R306 VSS.n107 VSS.n106 585
R307 VSS.n576 VSS.n575 585
R308 VSS.n577 VSS.n576 585
R309 VSS.n115 VSS.n114 585
R310 VSS.n114 VSS.n113 585
R311 VSS.n571 VSS.n570 585
R312 VSS.n570 VSS.n569 585
R313 VSS.n118 VSS.n117 585
R314 VSS.n119 VSS.n118 585
R315 VSS.n560 VSS.n559 585
R316 VSS.n561 VSS.n560 585
R317 VSS.n127 VSS.n126 585
R318 VSS.n126 VSS.n125 585
R319 VSS.n555 VSS.n554 585
R320 VSS.n554 VSS.n553 585
R321 VSS.n130 VSS.n129 585
R322 VSS.n131 VSS.n130 585
R323 VSS.n544 VSS.n543 585
R324 VSS.n545 VSS.n544 585
R325 VSS.n138 VSS.n137 585
R326 VSS.n143 VSS.n137 585
R327 VSS.n539 VSS.n538 585
R328 VSS.n538 VSS.n537 585
R329 VSS.n141 VSS.n140 585
R330 VSS.n142 VSS.n141 585
R331 VSS.n528 VSS.n527 585
R332 VSS.n529 VSS.n528 585
R333 VSS.n151 VSS.n150 585
R334 VSS.n150 VSS.n149 585
R335 VSS.n523 VSS.n522 585
R336 VSS.n522 VSS.n521 585
R337 VSS.n154 VSS.n153 585
R338 VSS.n155 VSS.n154 585
R339 VSS.n512 VSS.n511 585
R340 VSS.n513 VSS.n512 585
R341 VSS.n163 VSS.n162 585
R342 VSS.n162 VSS.n161 585
R343 VSS.n507 VSS.n506 585
R344 VSS.n506 VSS.n505 585
R345 VSS.n166 VSS.n165 585
R346 VSS.n167 VSS.n166 585
R347 VSS.n496 VSS.n495 585
R348 VSS.n497 VSS.n496 585
R349 VSS.n175 VSS.n174 585
R350 VSS.n174 VSS.n173 585
R351 VSS.n491 VSS.n490 585
R352 VSS.n490 VSS.n489 585
R353 VSS.n178 VSS.n177 585
R354 VSS.n179 VSS.n178 585
R355 VSS.n480 VSS.n479 585
R356 VSS.n481 VSS.n480 585
R357 VSS.n187 VSS.n186 585
R358 VSS.n186 VSS.n185 585
R359 VSS.n475 VSS.n474 585
R360 VSS.n474 VSS.n473 585
R361 VSS.n190 VSS.n189 585
R362 VSS.n191 VSS.n190 585
R363 VSS.n464 VSS.n463 585
R364 VSS.n465 VSS.n464 585
R365 VSS.n199 VSS.n198 585
R366 VSS.n198 VSS.n197 585
R367 VSS.n459 VSS.n458 585
R368 VSS.n458 VSS.n457 585
R369 VSS.n202 VSS.n201 585
R370 VSS.n203 VSS.n202 585
R371 VSS.n448 VSS.n447 585
R372 VSS.n449 VSS.n448 585
R373 VSS.n210 VSS.n209 585
R374 VSS.n214 VSS.n209 585
R375 VSS.n443 VSS.n442 585
R376 VSS.n442 VSS.n441 585
R377 VSS.n213 VSS.n212 585
R378 VSS.n432 VSS.n213 585
R379 VSS.n431 VSS.n430 585
R380 VSS.n433 VSS.n431 585
R381 VSS.n221 VSS.n220 585
R382 VSS.n225 VSS.n220 585
R383 VSS.n426 VSS.n425 585
R384 VSS.n425 VSS.n424 585
R385 VSS.n224 VSS.n223 585
R386 VSS.n415 VSS.n224 585
R387 VSS.n414 VSS.n413 585
R388 VSS.n416 VSS.n414 585
R389 VSS.n232 VSS.n231 585
R390 VSS.n237 VSS.n231 585
R391 VSS.n409 VSS.n408 585
R392 VSS.n408 VSS.n407 585
R393 VSS.n235 VSS.n234 585
R394 VSS.n236 VSS.n235 585
R395 VSS.n401 VSS.n241 585
R396 VSS.n400 VSS.n242 585
R397 VSS.n399 VSS.n243 585
R398 VSS.n341 VSS.n243 585
R399 VSS.n314 VSS.n244 585
R400 VSS.n395 VSS.n246 585
R401 VSS.n394 VSS.n247 585
R402 VSS.n393 VSS.n248 585
R403 VSS.n317 VSS.n249 585
R404 VSS.n389 VSS.n251 585
R405 VSS.n388 VSS.n252 585
R406 VSS.n387 VSS.n253 585
R407 VSS.n320 VSS.n254 585
R408 VSS.n383 VSS.n256 585
R409 VSS.n382 VSS.n257 585
R410 VSS.n381 VSS.n258 585
R411 VSS.n323 VSS.n259 585
R412 VSS.n377 VSS.n261 585
R413 VSS.n376 VSS.n262 585
R414 VSS.n375 VSS.n263 585
R415 VSS.n326 VSS.n264 585
R416 VSS.n371 VSS.n266 585
R417 VSS.n370 VSS.n267 585
R418 VSS.n369 VSS.n268 585
R419 VSS.n329 VSS.n269 585
R420 VSS.n365 VSS.n271 585
R421 VSS.n364 VSS.n272 585
R422 VSS.n363 VSS.n273 585
R423 VSS.n332 VSS.n274 585
R424 VSS.n359 VSS.n276 585
R425 VSS.n358 VSS.n277 585
R426 VSS.n357 VSS.n278 585
R427 VSS.n335 VSS.n279 585
R428 VSS.n353 VSS.n281 585
R429 VSS.n352 VSS.n282 585
R430 VSS.n351 VSS.n283 585
R431 VSS.n338 VSS.n284 585
R432 VSS.n347 VSS.n312 585
R433 VSS.n346 VSS.n313 585
R434 VSS.n345 VSS.n343 585
R435 VSS.n830 VSS.n25 504.812
R436 VSS.n833 VSS.n3 504.812
R437 VSS.n343 VSS.n235 504.812
R438 VSS.n241 VSS.n238 504.812
R439 VSS.n775 VSS.n774 256.483
R440 VSS.n761 VSS.n760 256.483
R441 VSS.n293 VSS.n292 256.483
R442 VSS.n307 VSS.n306 256.483
R443 VSS.n832 VSS.n831 254.01
R444 VSS.n831 VSS.n7 254.01
R445 VSS.n831 VSS.n8 254.01
R446 VSS.n831 VSS.n9 254.01
R447 VSS.n831 VSS.n10 254.01
R448 VSS.n831 VSS.n11 254.01
R449 VSS.n831 VSS.n12 254.01
R450 VSS.n831 VSS.n13 254.01
R451 VSS.n831 VSS.n14 254.01
R452 VSS.n831 VSS.n15 254.01
R453 VSS.n831 VSS.n16 254.01
R454 VSS.n831 VSS.n17 254.01
R455 VSS.n831 VSS.n18 254.01
R456 VSS.n831 VSS.n19 254.01
R457 VSS.n831 VSS.n20 254.01
R458 VSS.n831 VSS.n21 254.01
R459 VSS.n831 VSS.n22 254.01
R460 VSS.n831 VSS.n23 254.01
R461 VSS.n831 VSS.n24 254.01
R462 VSS.n341 VSS.n340 254.01
R463 VSS.n341 VSS.n315 254.01
R464 VSS.n341 VSS.n316 254.01
R465 VSS.n341 VSS.n318 254.01
R466 VSS.n341 VSS.n319 254.01
R467 VSS.n341 VSS.n321 254.01
R468 VSS.n341 VSS.n322 254.01
R469 VSS.n341 VSS.n324 254.01
R470 VSS.n341 VSS.n325 254.01
R471 VSS.n341 VSS.n327 254.01
R472 VSS.n341 VSS.n328 254.01
R473 VSS.n341 VSS.n330 254.01
R474 VSS.n341 VSS.n331 254.01
R475 VSS.n341 VSS.n333 254.01
R476 VSS.n341 VSS.n334 254.01
R477 VSS.n341 VSS.n336 254.01
R478 VSS.n341 VSS.n337 254.01
R479 VSS.n341 VSS.n339 254.01
R480 VSS.n342 VSS.n341 254.01
R481 VSS.n770 VSS.n769 185
R482 VSS.n774 VSS.n773 185
R483 VSS.n756 VSS.n755 185
R484 VSS.n760 VSS.n759 185
R485 VSS.n288 VSS.n287 185
R486 VSS.n292 VSS.n291 185
R487 VSS.n302 VSS.n301 185
R488 VSS.n306 VSS.n305 185
R489 VSS.n771 VSS.t2 180.972
R490 VSS.n757 VSS.t12 180.972
R491 VSS.n289 VSS.t14 180.972
R492 VSS.n303 VSS.t24 180.972
R493 VSS.n830 VSS.n26 177.3
R494 VSS.n697 VSS.n696 177.3
R495 VSS.n699 VSS.n698 177.3
R496 VSS.n703 VSS.n702 177.3
R497 VSS.n705 VSS.n704 177.3
R498 VSS.n709 VSS.n708 177.3
R499 VSS.n711 VSS.n710 177.3
R500 VSS.n715 VSS.n714 177.3
R501 VSS.n717 VSS.n716 177.3
R502 VSS.n721 VSS.n720 177.3
R503 VSS.n723 VSS.n722 177.3
R504 VSS.n727 VSS.n726 177.3
R505 VSS.n729 VSS.n728 177.3
R506 VSS.n733 VSS.n732 177.3
R507 VSS.n735 VSS.n734 177.3
R508 VSS.n739 VSS.n738 177.3
R509 VSS.n741 VSS.n740 177.3
R510 VSS.n745 VSS.n744 177.3
R511 VSS.n746 VSS.n5 177.3
R512 VSS.n408 VSS.n235 177.3
R513 VSS.n408 VSS.n231 177.3
R514 VSS.n414 VSS.n231 177.3
R515 VSS.n414 VSS.n224 177.3
R516 VSS.n425 VSS.n224 177.3
R517 VSS.n425 VSS.n220 177.3
R518 VSS.n431 VSS.n220 177.3
R519 VSS.n431 VSS.n213 177.3
R520 VSS.n442 VSS.n213 177.3
R521 VSS.n442 VSS.n209 177.3
R522 VSS.n448 VSS.n209 177.3
R523 VSS.n448 VSS.n202 177.3
R524 VSS.n458 VSS.n202 177.3
R525 VSS.n458 VSS.n198 177.3
R526 VSS.n464 VSS.n198 177.3
R527 VSS.n464 VSS.n190 177.3
R528 VSS.n474 VSS.n190 177.3
R529 VSS.n474 VSS.n186 177.3
R530 VSS.n480 VSS.n186 177.3
R531 VSS.n480 VSS.n178 177.3
R532 VSS.n490 VSS.n178 177.3
R533 VSS.n490 VSS.n174 177.3
R534 VSS.n496 VSS.n174 177.3
R535 VSS.n496 VSS.n166 177.3
R536 VSS.n506 VSS.n166 177.3
R537 VSS.n506 VSS.n162 177.3
R538 VSS.n512 VSS.n162 177.3
R539 VSS.n512 VSS.n154 177.3
R540 VSS.n522 VSS.n154 177.3
R541 VSS.n522 VSS.n150 177.3
R542 VSS.n528 VSS.n150 177.3
R543 VSS.n528 VSS.n141 177.3
R544 VSS.n538 VSS.n141 177.3
R545 VSS.n538 VSS.n137 177.3
R546 VSS.n544 VSS.n137 177.3
R547 VSS.n544 VSS.n130 177.3
R548 VSS.n554 VSS.n130 177.3
R549 VSS.n554 VSS.n126 177.3
R550 VSS.n560 VSS.n126 177.3
R551 VSS.n560 VSS.n118 177.3
R552 VSS.n570 VSS.n118 177.3
R553 VSS.n570 VSS.n114 177.3
R554 VSS.n576 VSS.n114 177.3
R555 VSS.n576 VSS.n106 177.3
R556 VSS.n586 VSS.n106 177.3
R557 VSS.n586 VSS.n102 177.3
R558 VSS.n592 VSS.n102 177.3
R559 VSS.n592 VSS.n94 177.3
R560 VSS.n602 VSS.n94 177.3
R561 VSS.n602 VSS.n90 177.3
R562 VSS.n608 VSS.n90 177.3
R563 VSS.n608 VSS.n82 177.3
R564 VSS.n618 VSS.n82 177.3
R565 VSS.n618 VSS.n78 177.3
R566 VSS.n624 VSS.n78 177.3
R567 VSS.n624 VSS.n69 177.3
R568 VSS.n634 VSS.n69 177.3
R569 VSS.n634 VSS.n65 177.3
R570 VSS.n640 VSS.n65 177.3
R571 VSS.n640 VSS.n58 177.3
R572 VSS.n650 VSS.n58 177.3
R573 VSS.n650 VSS.n52 177.3
R574 VSS.n657 VSS.n52 177.3
R575 VSS.n657 VSS.n53 177.3
R576 VSS.n53 VSS.n44 177.3
R577 VSS.n668 VSS.n44 177.3
R578 VSS.n668 VSS.n39 177.3
R579 VSS.n676 VSS.n39 177.3
R580 VSS.n676 VSS.n32 177.3
R581 VSS.n688 VSS.n32 177.3
R582 VSS.n689 VSS.n688 177.3
R583 VSS.n689 VSS.n3 177.3
R584 VSS.n243 VSS.n242 177.3
R585 VSS.n314 VSS.n243 177.3
R586 VSS.n247 VSS.n246 177.3
R587 VSS.n317 VSS.n248 177.3
R588 VSS.n252 VSS.n251 177.3
R589 VSS.n320 VSS.n253 177.3
R590 VSS.n257 VSS.n256 177.3
R591 VSS.n323 VSS.n258 177.3
R592 VSS.n262 VSS.n261 177.3
R593 VSS.n326 VSS.n263 177.3
R594 VSS.n267 VSS.n266 177.3
R595 VSS.n329 VSS.n268 177.3
R596 VSS.n272 VSS.n271 177.3
R597 VSS.n332 VSS.n273 177.3
R598 VSS.n277 VSS.n276 177.3
R599 VSS.n335 VSS.n278 177.3
R600 VSS.n282 VSS.n281 177.3
R601 VSS.n338 VSS.n283 177.3
R602 VSS.n313 VSS.n312 177.3
R603 VSS.n406 VSS.n238 177.3
R604 VSS.n406 VSS.n230 177.3
R605 VSS.n417 VSS.n230 177.3
R606 VSS.n417 VSS.n226 177.3
R607 VSS.n423 VSS.n226 177.3
R608 VSS.n423 VSS.n219 177.3
R609 VSS.n434 VSS.n219 177.3
R610 VSS.n434 VSS.n215 177.3
R611 VSS.n440 VSS.n215 177.3
R612 VSS.n440 VSS.n208 177.3
R613 VSS.n450 VSS.n208 177.3
R614 VSS.n450 VSS.n204 177.3
R615 VSS.n456 VSS.n204 177.3
R616 VSS.n456 VSS.n196 177.3
R617 VSS.n466 VSS.n196 177.3
R618 VSS.n466 VSS.n192 177.3
R619 VSS.n472 VSS.n192 177.3
R620 VSS.n472 VSS.n184 177.3
R621 VSS.n482 VSS.n184 177.3
R622 VSS.n482 VSS.n180 177.3
R623 VSS.n488 VSS.n180 177.3
R624 VSS.n488 VSS.n172 177.3
R625 VSS.n498 VSS.n172 177.3
R626 VSS.n498 VSS.n168 177.3
R627 VSS.n504 VSS.n168 177.3
R628 VSS.n504 VSS.n160 177.3
R629 VSS.n514 VSS.n160 177.3
R630 VSS.n514 VSS.n156 177.3
R631 VSS.n520 VSS.n156 177.3
R632 VSS.n520 VSS.n148 177.3
R633 VSS.n530 VSS.n148 177.3
R634 VSS.n530 VSS.n144 177.3
R635 VSS.n536 VSS.n144 177.3
R636 VSS.n536 VSS.n136 177.3
R637 VSS.n546 VSS.n136 177.3
R638 VSS.n546 VSS.n132 177.3
R639 VSS.n552 VSS.n132 177.3
R640 VSS.n552 VSS.n124 177.3
R641 VSS.n562 VSS.n124 177.3
R642 VSS.n562 VSS.n120 177.3
R643 VSS.n568 VSS.n120 177.3
R644 VSS.n568 VSS.n112 177.3
R645 VSS.n578 VSS.n112 177.3
R646 VSS.n578 VSS.n108 177.3
R647 VSS.n584 VSS.n108 177.3
R648 VSS.n584 VSS.n100 177.3
R649 VSS.n594 VSS.n100 177.3
R650 VSS.n594 VSS.n96 177.3
R651 VSS.n600 VSS.n96 177.3
R652 VSS.n600 VSS.n88 177.3
R653 VSS.n610 VSS.n88 177.3
R654 VSS.n610 VSS.n84 177.3
R655 VSS.n616 VSS.n84 177.3
R656 VSS.n616 VSS.n76 177.3
R657 VSS.n626 VSS.n76 177.3
R658 VSS.n626 VSS.n72 177.3
R659 VSS.n632 VSS.n72 177.3
R660 VSS.n632 VSS.n64 177.3
R661 VSS.n642 VSS.n64 177.3
R662 VSS.n642 VSS.n60 177.3
R663 VSS.n648 VSS.n60 177.3
R664 VSS.n648 VSS.n50 177.3
R665 VSS.n659 VSS.n50 177.3
R666 VSS.n659 VSS.n46 177.3
R667 VSS.n665 VSS.n46 177.3
R668 VSS.n665 VSS.n38 177.3
R669 VSS.n679 VSS.n38 177.3
R670 VSS.n679 VSS.n34 177.3
R671 VSS.n685 VSS.n34 177.3
R672 VSS.n685 VSS.n31 177.3
R673 VSS.n691 VSS.n31 177.3
R674 VSS.n691 VSS.n25 177.3
R675 VSS.n774 VSS.n769 144
R676 VSS.n760 VSS.n755 144
R677 VSS.n292 VSS.n287 144
R678 VSS.n306 VSS.n301 144
R679 VSS.n341 VSS.n236 105.799
R680 VSS.n831 VSS.n6 105.799
R681 VSS.n696 VSS.n24 76.985
R682 VSS.n698 VSS.n23 76.985
R683 VSS.n702 VSS.n22 76.985
R684 VSS.n704 VSS.n21 76.985
R685 VSS.n708 VSS.n20 76.985
R686 VSS.n710 VSS.n19 76.985
R687 VSS.n714 VSS.n18 76.985
R688 VSS.n716 VSS.n17 76.985
R689 VSS.n720 VSS.n16 76.985
R690 VSS.n722 VSS.n15 76.985
R691 VSS.n726 VSS.n14 76.985
R692 VSS.n728 VSS.n13 76.985
R693 VSS.n732 VSS.n12 76.985
R694 VSS.n734 VSS.n11 76.985
R695 VSS.n738 VSS.n10 76.985
R696 VSS.n740 VSS.n9 76.985
R697 VSS.n744 VSS.n8 76.985
R698 VSS.n746 VSS.n7 76.985
R699 VSS.n833 VSS.n832 76.985
R700 VSS.n340 VSS.n241 76.985
R701 VSS.n315 VSS.n314 76.985
R702 VSS.n316 VSS.n247 76.985
R703 VSS.n318 VSS.n317 76.985
R704 VSS.n319 VSS.n252 76.985
R705 VSS.n321 VSS.n320 76.985
R706 VSS.n322 VSS.n257 76.985
R707 VSS.n324 VSS.n323 76.985
R708 VSS.n325 VSS.n262 76.985
R709 VSS.n327 VSS.n326 76.985
R710 VSS.n328 VSS.n267 76.985
R711 VSS.n330 VSS.n329 76.985
R712 VSS.n331 VSS.n272 76.985
R713 VSS.n333 VSS.n332 76.985
R714 VSS.n334 VSS.n277 76.985
R715 VSS.n336 VSS.n335 76.985
R716 VSS.n337 VSS.n282 76.985
R717 VSS.n339 VSS.n338 76.985
R718 VSS.n342 VSS.n313 76.985
R719 VSS.n832 VSS.n5 76.985
R720 VSS.n745 VSS.n7 76.985
R721 VSS.n741 VSS.n8 76.985
R722 VSS.n739 VSS.n9 76.985
R723 VSS.n735 VSS.n10 76.985
R724 VSS.n733 VSS.n11 76.985
R725 VSS.n729 VSS.n12 76.985
R726 VSS.n727 VSS.n13 76.985
R727 VSS.n723 VSS.n14 76.985
R728 VSS.n721 VSS.n15 76.985
R729 VSS.n717 VSS.n16 76.985
R730 VSS.n715 VSS.n17 76.985
R731 VSS.n711 VSS.n18 76.985
R732 VSS.n709 VSS.n19 76.985
R733 VSS.n705 VSS.n20 76.985
R734 VSS.n703 VSS.n21 76.985
R735 VSS.n699 VSS.n22 76.985
R736 VSS.n697 VSS.n23 76.985
R737 VSS.n26 VSS.n24 76.985
R738 VSS.n340 VSS.n242 76.985
R739 VSS.n315 VSS.n246 76.985
R740 VSS.n316 VSS.n248 76.985
R741 VSS.n318 VSS.n251 76.985
R742 VSS.n319 VSS.n253 76.985
R743 VSS.n321 VSS.n256 76.985
R744 VSS.n322 VSS.n258 76.985
R745 VSS.n324 VSS.n261 76.985
R746 VSS.n325 VSS.n263 76.985
R747 VSS.n327 VSS.n266 76.985
R748 VSS.n328 VSS.n268 76.985
R749 VSS.n330 VSS.n271 76.985
R750 VSS.n331 VSS.n273 76.985
R751 VSS.n333 VSS.n276 76.985
R752 VSS.n334 VSS.n278 76.985
R753 VSS.n336 VSS.n281 76.985
R754 VSS.n337 VSS.n283 76.985
R755 VSS.n339 VSS.n312 76.985
R756 VSS.n343 VSS.n342 76.985
R757 VSS.n407 VSS.n236 74.6822
R758 VSS.n433 VSS.n432 74.6822
R759 VSS.n441 VSS.n214 74.6822
R760 VSS.n449 VSS.n203 74.6822
R761 VSS.n457 VSS.n203 74.6822
R762 VSS.n465 VSS.n197 74.6822
R763 VSS.n465 VSS.n191 74.6822
R764 VSS.n473 VSS.n191 74.6822
R765 VSS.n473 VSS.n185 74.6822
R766 VSS.n481 VSS.n185 74.6822
R767 VSS.n481 VSS.n179 74.6822
R768 VSS.n489 VSS.n179 74.6822
R769 VSS.n489 VSS.n173 74.6822
R770 VSS.n497 VSS.n173 74.6822
R771 VSS.n497 VSS.n167 74.6822
R772 VSS.n505 VSS.n167 74.6822
R773 VSS.n505 VSS.n161 74.6822
R774 VSS.n513 VSS.n161 74.6822
R775 VSS.n513 VSS.n155 74.6822
R776 VSS.n521 VSS.n155 74.6822
R777 VSS.n521 VSS.n149 74.6822
R778 VSS.n529 VSS.n149 74.6822
R779 VSS.n529 VSS.n142 74.6822
R780 VSS.n537 VSS.n142 74.6822
R781 VSS.n537 VSS.n143 74.6822
R782 VSS.n545 VSS.n131 74.6822
R783 VSS.n553 VSS.n131 74.6822
R784 VSS.n561 VSS.n125 74.6822
R785 VSS.n561 VSS.n119 74.6822
R786 VSS.n569 VSS.n119 74.6822
R787 VSS.n569 VSS.n113 74.6822
R788 VSS.n577 VSS.n113 74.6822
R789 VSS.n577 VSS.n107 74.6822
R790 VSS.n585 VSS.n107 74.6822
R791 VSS.n585 VSS.n101 74.6822
R792 VSS.n593 VSS.n101 74.6822
R793 VSS.n593 VSS.n95 74.6822
R794 VSS.n601 VSS.n95 74.6822
R795 VSS.n601 VSS.n89 74.6822
R796 VSS.n609 VSS.n89 74.6822
R797 VSS.n609 VSS.n83 74.6822
R798 VSS.n617 VSS.n83 74.6822
R799 VSS.n617 VSS.n77 74.6822
R800 VSS.n625 VSS.n77 74.6822
R801 VSS.n625 VSS.n70 74.6822
R802 VSS.n633 VSS.n70 74.6822
R803 VSS.n633 VSS.n71 74.6822
R804 VSS.n641 VSS.n59 74.6822
R805 VSS.n649 VSS.n59 74.6822
R806 VSS.n658 VSS.n51 74.6822
R807 VSS.n666 VSS.n45 74.6822
R808 VSS.n690 VSS.n6 74.6822
R809 VSS.t13 VSS.n197 72.6078
R810 VSS.n71 VSS.t11 72.6078
R811 VSS.t2 VSS.n769 72.0005
R812 VSS.t12 VSS.n755 72.0005
R813 VSS.t14 VSS.n287 72.0005
R814 VSS.t24 VSS.n301 72.0005
R815 VSS.n416 VSS.t26 69.496
R816 VSS.n686 VSS.t32 69.496
R817 VSS.n424 VSS.t21 64.3098
R818 VSS.n678 VSS.t3 64.3098
R819 VSS.t25 VSS.n225 61.198
R820 VSS.n667 VSS.t33 61.198
R821 VSS.n214 VSS.t15 60.1608
R822 VSS.t9 VSS.n51 60.1608
R823 VSS.n545 VSS.t0 57.0491
R824 VSS.n553 VSS.t29 54.9746
R825 VSS.n237 VSS.t27 50.8256
R826 VSS.n687 VSS.t31 50.8256
R827 VSS.n433 VSS.t19 47.7138
R828 VSS.t5 VSS.n666 47.7138
R829 VSS.n432 VSS.t17 43.5649
R830 VSS.t7 VSS.n45 43.5649
R831 VSS.t28 VSS.t23 36.3041
R832 VSS.t1 VSS.t30 36.3041
R833 VSS.n401 VSS.n239 32.8005
R834 VSS.n829 VSS.n27 32.8005
R835 VSS.n835 VSS.n834 32.8005
R836 VSS.n345 VSS.n234 32.8005
R837 VSS.n407 VSS.t28 32.1551
R838 VSS.n690 VSS.t30 32.1551
R839 VSS.n441 VSS.t17 31.1179
R840 VSS.n658 VSS.t7 31.1179
R841 VSS.n766 VSS.n765 29.1277
R842 VSS.n764 VSS.n763 29.1277
R843 VSS.n296 VSS.n295 29.1277
R844 VSS.n298 VSS.n297 29.1277
R845 VSS.n773 VSS.n770 27.1064
R846 VSS.n773 VSS.n768 27.1064
R847 VSS.n759 VSS.n756 27.1064
R848 VSS.n759 VSS.n754 27.1064
R849 VSS.n291 VSS.n288 27.1064
R850 VSS.n291 VSS.n286 27.1064
R851 VSS.n305 VSS.n302 27.1064
R852 VSS.n305 VSS.n300 27.1064
R853 VSS.n225 VSS.t19 26.9689
R854 VSS.n667 VSS.t5 26.9689
R855 VSS.n776 VSS.n775 25.8526
R856 VSS.n762 VSS.n761 25.8526
R857 VSS.n294 VSS.n293 25.8526
R858 VSS.n308 VSS.n307 25.8526
R859 VSS.n416 VSS.t27 23.8572
R860 VSS.t31 VSS.n686 23.8572
R861 VSS.t29 VSS.n125 19.7082
R862 VSS.n143 VSS.t0 17.6337
R863 VSS.n449 VSS.t15 14.522
R864 VSS.n649 VSS.t9 14.522
R865 VSS.n424 VSS.t25 13.4847
R866 VSS.n678 VSS.t33 13.4847
R867 VSS.n405 VSS.n239 11.5205
R868 VSS.n405 VSS.n229 11.5205
R869 VSS.n418 VSS.n229 11.5205
R870 VSS.n418 VSS.n227 11.5205
R871 VSS.n422 VSS.n227 11.5205
R872 VSS.n422 VSS.n218 11.5205
R873 VSS.n435 VSS.n218 11.5205
R874 VSS.n435 VSS.n216 11.5205
R875 VSS.n439 VSS.n216 11.5205
R876 VSS.n439 VSS.n207 11.5205
R877 VSS.n451 VSS.n207 11.5205
R878 VSS.n451 VSS.n205 11.5205
R879 VSS.n455 VSS.n205 11.5205
R880 VSS.n455 VSS.n195 11.5205
R881 VSS.n467 VSS.n195 11.5205
R882 VSS.n467 VSS.n193 11.5205
R883 VSS.n471 VSS.n193 11.5205
R884 VSS.n471 VSS.n183 11.5205
R885 VSS.n483 VSS.n183 11.5205
R886 VSS.n483 VSS.n181 11.5205
R887 VSS.n487 VSS.n181 11.5205
R888 VSS.n487 VSS.n171 11.5205
R889 VSS.n499 VSS.n171 11.5205
R890 VSS.n499 VSS.n169 11.5205
R891 VSS.n503 VSS.n169 11.5205
R892 VSS.n503 VSS.n159 11.5205
R893 VSS.n515 VSS.n159 11.5205
R894 VSS.n515 VSS.n157 11.5205
R895 VSS.n519 VSS.n157 11.5205
R896 VSS.n519 VSS.n147 11.5205
R897 VSS.n531 VSS.n147 11.5205
R898 VSS.n531 VSS.n145 11.5205
R899 VSS.n535 VSS.n145 11.5205
R900 VSS.n535 VSS.n135 11.5205
R901 VSS.n547 VSS.n135 11.5205
R902 VSS.n547 VSS.n133 11.5205
R903 VSS.n551 VSS.n133 11.5205
R904 VSS.n551 VSS.n123 11.5205
R905 VSS.n563 VSS.n123 11.5205
R906 VSS.n563 VSS.n121 11.5205
R907 VSS.n567 VSS.n121 11.5205
R908 VSS.n567 VSS.n111 11.5205
R909 VSS.n579 VSS.n111 11.5205
R910 VSS.n579 VSS.n109 11.5205
R911 VSS.n583 VSS.n109 11.5205
R912 VSS.n583 VSS.n99 11.5205
R913 VSS.n595 VSS.n99 11.5205
R914 VSS.n595 VSS.n97 11.5205
R915 VSS.n599 VSS.n97 11.5205
R916 VSS.n599 VSS.n87 11.5205
R917 VSS.n611 VSS.n87 11.5205
R918 VSS.n611 VSS.n85 11.5205
R919 VSS.n615 VSS.n85 11.5205
R920 VSS.n615 VSS.n75 11.5205
R921 VSS.n627 VSS.n75 11.5205
R922 VSS.n627 VSS.n73 11.5205
R923 VSS.n631 VSS.n73 11.5205
R924 VSS.n631 VSS.n63 11.5205
R925 VSS.n643 VSS.n63 11.5205
R926 VSS.n643 VSS.n61 11.5205
R927 VSS.n647 VSS.n61 11.5205
R928 VSS.n647 VSS.n49 11.5205
R929 VSS.n660 VSS.n49 11.5205
R930 VSS.n660 VSS.n47 11.5205
R931 VSS.n664 VSS.n47 11.5205
R932 VSS.n664 VSS.n37 11.5205
R933 VSS.n680 VSS.n37 11.5205
R934 VSS.n680 VSS.n35 11.5205
R935 VSS.n684 VSS.n35 11.5205
R936 VSS.n684 VSS.n30 11.5205
R937 VSS.n692 VSS.n30 11.5205
R938 VSS.n692 VSS.n27 11.5205
R939 VSS.n829 VSS.n28 11.5205
R940 VSS.n825 VSS.n28 11.5205
R941 VSS.n825 VSS.n824 11.5205
R942 VSS.n824 VSS.n823 11.5205
R943 VSS.n823 VSS.n700 11.5205
R944 VSS.n819 VSS.n700 11.5205
R945 VSS.n819 VSS.n818 11.5205
R946 VSS.n818 VSS.n817 11.5205
R947 VSS.n817 VSS.n706 11.5205
R948 VSS.n813 VSS.n706 11.5205
R949 VSS.n813 VSS.n812 11.5205
R950 VSS.n812 VSS.n811 11.5205
R951 VSS.n811 VSS.n712 11.5205
R952 VSS.n807 VSS.n712 11.5205
R953 VSS.n807 VSS.n806 11.5205
R954 VSS.n806 VSS.n805 11.5205
R955 VSS.n805 VSS.n718 11.5205
R956 VSS.n801 VSS.n718 11.5205
R957 VSS.n801 VSS.n800 11.5205
R958 VSS.n800 VSS.n799 11.5205
R959 VSS.n799 VSS.n724 11.5205
R960 VSS.n795 VSS.n724 11.5205
R961 VSS.n795 VSS.n794 11.5205
R962 VSS.n794 VSS.n793 11.5205
R963 VSS.n793 VSS.n730 11.5205
R964 VSS.n789 VSS.n730 11.5205
R965 VSS.n789 VSS.n788 11.5205
R966 VSS.n788 VSS.n787 11.5205
R967 VSS.n787 VSS.n736 11.5205
R968 VSS.n783 VSS.n736 11.5205
R969 VSS.n783 VSS.n782 11.5205
R970 VSS.n782 VSS.n781 11.5205
R971 VSS.n781 VSS.n742 11.5205
R972 VSS.n751 VSS.n742 11.5205
R973 VSS.n751 VSS.n750 11.5205
R974 VSS.n750 VSS.n749 11.5205
R975 VSS.n749 VSS.n4 11.5205
R976 VSS.n834 VSS.n4 11.5205
R977 VSS.n409 VSS.n234 11.5205
R978 VSS.n409 VSS.n232 11.5205
R979 VSS.n413 VSS.n232 11.5205
R980 VSS.n413 VSS.n223 11.5205
R981 VSS.n426 VSS.n223 11.5205
R982 VSS.n426 VSS.n221 11.5205
R983 VSS.n430 VSS.n221 11.5205
R984 VSS.n430 VSS.n212 11.5205
R985 VSS.n443 VSS.n212 11.5205
R986 VSS.n443 VSS.n210 11.5205
R987 VSS.n447 VSS.n210 11.5205
R988 VSS.n447 VSS.n201 11.5205
R989 VSS.n459 VSS.n201 11.5205
R990 VSS.n459 VSS.n199 11.5205
R991 VSS.n463 VSS.n199 11.5205
R992 VSS.n463 VSS.n189 11.5205
R993 VSS.n475 VSS.n189 11.5205
R994 VSS.n475 VSS.n187 11.5205
R995 VSS.n479 VSS.n187 11.5205
R996 VSS.n479 VSS.n177 11.5205
R997 VSS.n491 VSS.n177 11.5205
R998 VSS.n491 VSS.n175 11.5205
R999 VSS.n495 VSS.n175 11.5205
R1000 VSS.n495 VSS.n165 11.5205
R1001 VSS.n507 VSS.n165 11.5205
R1002 VSS.n507 VSS.n163 11.5205
R1003 VSS.n511 VSS.n163 11.5205
R1004 VSS.n511 VSS.n153 11.5205
R1005 VSS.n523 VSS.n153 11.5205
R1006 VSS.n523 VSS.n151 11.5205
R1007 VSS.n527 VSS.n151 11.5205
R1008 VSS.n527 VSS.n140 11.5205
R1009 VSS.n539 VSS.n140 11.5205
R1010 VSS.n539 VSS.n138 11.5205
R1011 VSS.n543 VSS.n138 11.5205
R1012 VSS.n543 VSS.n129 11.5205
R1013 VSS.n555 VSS.n129 11.5205
R1014 VSS.n555 VSS.n127 11.5205
R1015 VSS.n559 VSS.n127 11.5205
R1016 VSS.n559 VSS.n117 11.5205
R1017 VSS.n571 VSS.n117 11.5205
R1018 VSS.n571 VSS.n115 11.5205
R1019 VSS.n575 VSS.n115 11.5205
R1020 VSS.n575 VSS.n105 11.5205
R1021 VSS.n587 VSS.n105 11.5205
R1022 VSS.n587 VSS.n103 11.5205
R1023 VSS.n591 VSS.n103 11.5205
R1024 VSS.n591 VSS.n93 11.5205
R1025 VSS.n603 VSS.n93 11.5205
R1026 VSS.n603 VSS.n91 11.5205
R1027 VSS.n607 VSS.n91 11.5205
R1028 VSS.n607 VSS.n81 11.5205
R1029 VSS.n619 VSS.n81 11.5205
R1030 VSS.n619 VSS.n79 11.5205
R1031 VSS.n623 VSS.n79 11.5205
R1032 VSS.n623 VSS.n68 11.5205
R1033 VSS.n635 VSS.n68 11.5205
R1034 VSS.n635 VSS.n66 11.5205
R1035 VSS.n639 VSS.n66 11.5205
R1036 VSS.n639 VSS.n57 11.5205
R1037 VSS.n651 VSS.n57 11.5205
R1038 VSS.n651 VSS.n54 11.5205
R1039 VSS.n656 VSS.n54 11.5205
R1040 VSS.n656 VSS.n55 11.5205
R1041 VSS.n55 VSS.n43 11.5205
R1042 VSS.n669 VSS.n43 11.5205
R1043 VSS.n669 VSS.n40 11.5205
R1044 VSS.n675 VSS.n40 11.5205
R1045 VSS.n675 VSS.n41 11.5205
R1046 VSS.n41 VSS.n33 11.5205
R1047 VSS.n33 VSS.n2 11.5205
R1048 VSS.n835 VSS.n2 11.5205
R1049 VSS.n401 VSS.n400 11.5205
R1050 VSS.n400 VSS.n399 11.5205
R1051 VSS.n399 VSS.n244 11.5205
R1052 VSS.n395 VSS.n244 11.5205
R1053 VSS.n395 VSS.n394 11.5205
R1054 VSS.n394 VSS.n393 11.5205
R1055 VSS.n393 VSS.n249 11.5205
R1056 VSS.n389 VSS.n249 11.5205
R1057 VSS.n389 VSS.n388 11.5205
R1058 VSS.n388 VSS.n387 11.5205
R1059 VSS.n387 VSS.n254 11.5205
R1060 VSS.n383 VSS.n254 11.5205
R1061 VSS.n383 VSS.n382 11.5205
R1062 VSS.n382 VSS.n381 11.5205
R1063 VSS.n381 VSS.n259 11.5205
R1064 VSS.n377 VSS.n259 11.5205
R1065 VSS.n377 VSS.n376 11.5205
R1066 VSS.n376 VSS.n375 11.5205
R1067 VSS.n375 VSS.n264 11.5205
R1068 VSS.n371 VSS.n264 11.5205
R1069 VSS.n371 VSS.n370 11.5205
R1070 VSS.n370 VSS.n369 11.5205
R1071 VSS.n369 VSS.n269 11.5205
R1072 VSS.n365 VSS.n269 11.5205
R1073 VSS.n365 VSS.n364 11.5205
R1074 VSS.n364 VSS.n363 11.5205
R1075 VSS.n363 VSS.n274 11.5205
R1076 VSS.n359 VSS.n274 11.5205
R1077 VSS.n359 VSS.n358 11.5205
R1078 VSS.n358 VSS.n357 11.5205
R1079 VSS.n357 VSS.n279 11.5205
R1080 VSS.n353 VSS.n279 11.5205
R1081 VSS.n353 VSS.n352 11.5205
R1082 VSS.n352 VSS.n351 11.5205
R1083 VSS.n351 VSS.n284 11.5205
R1084 VSS.n347 VSS.n284 11.5205
R1085 VSS.n347 VSS.n346 11.5205
R1086 VSS.n346 VSS.n345 11.5205
R1087 VSS.n415 VSS.t21 10.373
R1088 VSS.t3 VSS.n677 10.373
R1089 VSS.n773 VSS.n772 9.3005
R1090 VSS.n768 VSS.n767 9.3005
R1091 VSS.n759 VSS.n758 9.3005
R1092 VSS.n754 VSS.n753 9.3005
R1093 VSS.n291 VSS.n290 9.3005
R1094 VSS.n286 VSS.n285 9.3005
R1095 VSS.n305 VSS.n304 9.3005
R1096 VSS.n300 VSS.n299 9.3005
R1097 VSS.n402 VSS.n401 9.3005
R1098 VSS.n400 VSS.n240 9.3005
R1099 VSS.n399 VSS.n398 9.3005
R1100 VSS.n397 VSS.n244 9.3005
R1101 VSS.n396 VSS.n395 9.3005
R1102 VSS.n394 VSS.n245 9.3005
R1103 VSS.n393 VSS.n392 9.3005
R1104 VSS.n391 VSS.n249 9.3005
R1105 VSS.n390 VSS.n389 9.3005
R1106 VSS.n388 VSS.n250 9.3005
R1107 VSS.n387 VSS.n386 9.3005
R1108 VSS.n385 VSS.n254 9.3005
R1109 VSS.n384 VSS.n383 9.3005
R1110 VSS.n382 VSS.n255 9.3005
R1111 VSS.n381 VSS.n380 9.3005
R1112 VSS.n379 VSS.n259 9.3005
R1113 VSS.n378 VSS.n377 9.3005
R1114 VSS.n376 VSS.n260 9.3005
R1115 VSS.n375 VSS.n374 9.3005
R1116 VSS.n373 VSS.n264 9.3005
R1117 VSS.n372 VSS.n371 9.3005
R1118 VSS.n370 VSS.n265 9.3005
R1119 VSS.n369 VSS.n368 9.3005
R1120 VSS.n367 VSS.n269 9.3005
R1121 VSS.n366 VSS.n365 9.3005
R1122 VSS.n364 VSS.n270 9.3005
R1123 VSS.n363 VSS.n362 9.3005
R1124 VSS.n361 VSS.n274 9.3005
R1125 VSS.n360 VSS.n359 9.3005
R1126 VSS.n358 VSS.n275 9.3005
R1127 VSS.n357 VSS.n356 9.3005
R1128 VSS.n355 VSS.n279 9.3005
R1129 VSS.n354 VSS.n353 9.3005
R1130 VSS.n352 VSS.n280 9.3005
R1131 VSS.n351 VSS.n350 9.3005
R1132 VSS.n349 VSS.n284 9.3005
R1133 VSS.n348 VSS.n347 9.3005
R1134 VSS.n346 VSS.n311 9.3005
R1135 VSS.n345 VSS.n344 9.3005
R1136 VSS.n403 VSS.n239 9.3005
R1137 VSS.n405 VSS.n404 9.3005
R1138 VSS.n229 VSS.n228 9.3005
R1139 VSS.n419 VSS.n418 9.3005
R1140 VSS.n420 VSS.n227 9.3005
R1141 VSS.n422 VSS.n421 9.3005
R1142 VSS.n218 VSS.n217 9.3005
R1143 VSS.n436 VSS.n435 9.3005
R1144 VSS.n437 VSS.n216 9.3005
R1145 VSS.n439 VSS.n438 9.3005
R1146 VSS.n207 VSS.n206 9.3005
R1147 VSS.n452 VSS.n451 9.3005
R1148 VSS.n453 VSS.n205 9.3005
R1149 VSS.n455 VSS.n454 9.3005
R1150 VSS.n195 VSS.n194 9.3005
R1151 VSS.n468 VSS.n467 9.3005
R1152 VSS.n469 VSS.n193 9.3005
R1153 VSS.n471 VSS.n470 9.3005
R1154 VSS.n183 VSS.n182 9.3005
R1155 VSS.n484 VSS.n483 9.3005
R1156 VSS.n485 VSS.n181 9.3005
R1157 VSS.n487 VSS.n486 9.3005
R1158 VSS.n171 VSS.n170 9.3005
R1159 VSS.n500 VSS.n499 9.3005
R1160 VSS.n501 VSS.n169 9.3005
R1161 VSS.n503 VSS.n502 9.3005
R1162 VSS.n159 VSS.n158 9.3005
R1163 VSS.n516 VSS.n515 9.3005
R1164 VSS.n517 VSS.n157 9.3005
R1165 VSS.n519 VSS.n518 9.3005
R1166 VSS.n147 VSS.n146 9.3005
R1167 VSS.n532 VSS.n531 9.3005
R1168 VSS.n533 VSS.n145 9.3005
R1169 VSS.n535 VSS.n534 9.3005
R1170 VSS.n135 VSS.n134 9.3005
R1171 VSS.n548 VSS.n547 9.3005
R1172 VSS.n549 VSS.n133 9.3005
R1173 VSS.n551 VSS.n550 9.3005
R1174 VSS.n123 VSS.n122 9.3005
R1175 VSS.n564 VSS.n563 9.3005
R1176 VSS.n565 VSS.n121 9.3005
R1177 VSS.n567 VSS.n566 9.3005
R1178 VSS.n111 VSS.n110 9.3005
R1179 VSS.n580 VSS.n579 9.3005
R1180 VSS.n581 VSS.n109 9.3005
R1181 VSS.n583 VSS.n582 9.3005
R1182 VSS.n99 VSS.n98 9.3005
R1183 VSS.n596 VSS.n595 9.3005
R1184 VSS.n597 VSS.n97 9.3005
R1185 VSS.n599 VSS.n598 9.3005
R1186 VSS.n87 VSS.n86 9.3005
R1187 VSS.n612 VSS.n611 9.3005
R1188 VSS.n613 VSS.n85 9.3005
R1189 VSS.n615 VSS.n614 9.3005
R1190 VSS.n75 VSS.n74 9.3005
R1191 VSS.n628 VSS.n627 9.3005
R1192 VSS.n629 VSS.n73 9.3005
R1193 VSS.n631 VSS.n630 9.3005
R1194 VSS.n63 VSS.n62 9.3005
R1195 VSS.n644 VSS.n643 9.3005
R1196 VSS.n645 VSS.n61 9.3005
R1197 VSS.n647 VSS.n646 9.3005
R1198 VSS.n49 VSS.n48 9.3005
R1199 VSS.n661 VSS.n660 9.3005
R1200 VSS.n662 VSS.n47 9.3005
R1201 VSS.n664 VSS.n663 9.3005
R1202 VSS.n37 VSS.n36 9.3005
R1203 VSS.n681 VSS.n680 9.3005
R1204 VSS.n682 VSS.n35 9.3005
R1205 VSS.n684 VSS.n683 9.3005
R1206 VSS.n30 VSS.n29 9.3005
R1207 VSS.n693 VSS.n692 9.3005
R1208 VSS.n694 VSS.n27 9.3005
R1209 VSS.n834 VSS.n0 9.3005
R1210 VSS.n747 VSS.n4 9.3005
R1211 VSS.n749 VSS.n748 9.3005
R1212 VSS.n750 VSS.n743 9.3005
R1213 VSS.n752 VSS.n751 9.3005
R1214 VSS.n779 VSS.n742 9.3005
R1215 VSS.n781 VSS.n780 9.3005
R1216 VSS.n782 VSS.n737 9.3005
R1217 VSS.n784 VSS.n783 9.3005
R1218 VSS.n785 VSS.n736 9.3005
R1219 VSS.n787 VSS.n786 9.3005
R1220 VSS.n788 VSS.n731 9.3005
R1221 VSS.n790 VSS.n789 9.3005
R1222 VSS.n791 VSS.n730 9.3005
R1223 VSS.n793 VSS.n792 9.3005
R1224 VSS.n794 VSS.n725 9.3005
R1225 VSS.n796 VSS.n795 9.3005
R1226 VSS.n797 VSS.n724 9.3005
R1227 VSS.n799 VSS.n798 9.3005
R1228 VSS.n800 VSS.n719 9.3005
R1229 VSS.n802 VSS.n801 9.3005
R1230 VSS.n803 VSS.n718 9.3005
R1231 VSS.n805 VSS.n804 9.3005
R1232 VSS.n806 VSS.n713 9.3005
R1233 VSS.n808 VSS.n807 9.3005
R1234 VSS.n809 VSS.n712 9.3005
R1235 VSS.n811 VSS.n810 9.3005
R1236 VSS.n812 VSS.n707 9.3005
R1237 VSS.n814 VSS.n813 9.3005
R1238 VSS.n815 VSS.n706 9.3005
R1239 VSS.n817 VSS.n816 9.3005
R1240 VSS.n818 VSS.n701 9.3005
R1241 VSS.n820 VSS.n819 9.3005
R1242 VSS.n821 VSS.n700 9.3005
R1243 VSS.n823 VSS.n822 9.3005
R1244 VSS.n824 VSS.n695 9.3005
R1245 VSS.n826 VSS.n825 9.3005
R1246 VSS.n827 VSS.n28 9.3005
R1247 VSS.n829 VSS.n828 9.3005
R1248 VSS.n836 VSS.n835 9.3005
R1249 VSS.n2 VSS.n1 9.3005
R1250 VSS.n672 VSS.n33 9.3005
R1251 VSS.n673 VSS.n41 9.3005
R1252 VSS.n675 VSS.n674 9.3005
R1253 VSS.n671 VSS.n40 9.3005
R1254 VSS.n670 VSS.n669 9.3005
R1255 VSS.n43 VSS.n42 9.3005
R1256 VSS.n654 VSS.n55 9.3005
R1257 VSS.n656 VSS.n655 9.3005
R1258 VSS.n653 VSS.n54 9.3005
R1259 VSS.n652 VSS.n651 9.3005
R1260 VSS.n57 VSS.n56 9.3005
R1261 VSS.n639 VSS.n638 9.3005
R1262 VSS.n637 VSS.n66 9.3005
R1263 VSS.n636 VSS.n635 9.3005
R1264 VSS.n68 VSS.n67 9.3005
R1265 VSS.n623 VSS.n622 9.3005
R1266 VSS.n621 VSS.n79 9.3005
R1267 VSS.n620 VSS.n619 9.3005
R1268 VSS.n81 VSS.n80 9.3005
R1269 VSS.n607 VSS.n606 9.3005
R1270 VSS.n605 VSS.n91 9.3005
R1271 VSS.n604 VSS.n603 9.3005
R1272 VSS.n93 VSS.n92 9.3005
R1273 VSS.n591 VSS.n590 9.3005
R1274 VSS.n589 VSS.n103 9.3005
R1275 VSS.n588 VSS.n587 9.3005
R1276 VSS.n105 VSS.n104 9.3005
R1277 VSS.n575 VSS.n574 9.3005
R1278 VSS.n573 VSS.n115 9.3005
R1279 VSS.n572 VSS.n571 9.3005
R1280 VSS.n117 VSS.n116 9.3005
R1281 VSS.n559 VSS.n558 9.3005
R1282 VSS.n557 VSS.n127 9.3005
R1283 VSS.n556 VSS.n555 9.3005
R1284 VSS.n129 VSS.n128 9.3005
R1285 VSS.n543 VSS.n542 9.3005
R1286 VSS.n541 VSS.n138 9.3005
R1287 VSS.n540 VSS.n539 9.3005
R1288 VSS.n140 VSS.n139 9.3005
R1289 VSS.n527 VSS.n526 9.3005
R1290 VSS.n525 VSS.n151 9.3005
R1291 VSS.n524 VSS.n523 9.3005
R1292 VSS.n153 VSS.n152 9.3005
R1293 VSS.n511 VSS.n510 9.3005
R1294 VSS.n509 VSS.n163 9.3005
R1295 VSS.n508 VSS.n507 9.3005
R1296 VSS.n165 VSS.n164 9.3005
R1297 VSS.n495 VSS.n494 9.3005
R1298 VSS.n493 VSS.n175 9.3005
R1299 VSS.n492 VSS.n491 9.3005
R1300 VSS.n177 VSS.n176 9.3005
R1301 VSS.n479 VSS.n478 9.3005
R1302 VSS.n477 VSS.n187 9.3005
R1303 VSS.n476 VSS.n475 9.3005
R1304 VSS.n189 VSS.n188 9.3005
R1305 VSS.n463 VSS.n462 9.3005
R1306 VSS.n461 VSS.n199 9.3005
R1307 VSS.n460 VSS.n459 9.3005
R1308 VSS.n201 VSS.n200 9.3005
R1309 VSS.n447 VSS.n446 9.3005
R1310 VSS.n445 VSS.n210 9.3005
R1311 VSS.n444 VSS.n443 9.3005
R1312 VSS.n212 VSS.n211 9.3005
R1313 VSS.n430 VSS.n429 9.3005
R1314 VSS.n428 VSS.n221 9.3005
R1315 VSS.n427 VSS.n426 9.3005
R1316 VSS.n223 VSS.n222 9.3005
R1317 VSS.n413 VSS.n412 9.3005
R1318 VSS.n411 VSS.n232 9.3005
R1319 VSS.n410 VSS.n409 9.3005
R1320 VSS.n234 VSS.n233 9.3005
R1321 VSS.n775 VSS.n768 9.2683
R1322 VSS.n761 VSS.n754 9.2683
R1323 VSS.n293 VSS.n286 9.2683
R1324 VSS.n307 VSS.n300 9.2683
R1325 VSS.n771 VSS.n770 6.30294
R1326 VSS.n757 VSS.n756 6.30294
R1327 VSS.n289 VSS.n288 6.30294
R1328 VSS.n303 VSS.n302 6.30294
R1329 VSS.t23 VSS.n237 6.22398
R1330 VSS.n687 VSS.t1 6.22398
R1331 VSS.n765 VSS.t6 6.0005
R1332 VSS.n765 VSS.t4 6.0005
R1333 VSS.n763 VSS.t10 6.0005
R1334 VSS.n763 VSS.t8 6.0005
R1335 VSS.n295 VSS.t18 6.0005
R1336 VSS.n295 VSS.t16 6.0005
R1337 VSS.n297 VSS.t22 6.0005
R1338 VSS.n297 VSS.t20 6.0005
R1339 VSS.t26 VSS.n415 5.18673
R1340 VSS.n677 VSS.t32 5.18673
R1341 VSS.n764 VSS.n762 4.97669
R1342 VSS.n296 VSS.n294 4.97669
R1343 VSS.n778 VSS.n777 4.7386
R1344 VSS.n310 VSS.n309 4.7386
R1345 VSS.n777 VSS.n776 4.5005
R1346 VSS.n309 VSS.n308 4.5005
R1347 VSS.n457 VSS.t13 2.07499
R1348 VSS.n641 VSS.t11 2.07499
R1349 VSS.n772 VSS.n771 1.22195
R1350 VSS.n758 VSS.n757 1.22195
R1351 VSS.n290 VSS.n289 1.22195
R1352 VSS.n304 VSS.n303 1.22195
R1353 VSS.n766 VSS.n764 0.47669
R1354 VSS.n777 VSS.n766 0.47669
R1355 VSS.n309 VSS.n298 0.47669
R1356 VSS.n298 VSS.n296 0.47669
R1357 VSS.n403 VSS.n402 0.320812
R1358 VSS.n828 VSS.n694 0.320812
R1359 VSS.n344 VSS.n233 0.19499
R1360 VSS.n772 VSS.n767 0.193616
R1361 VSS.n758 VSS.n753 0.193616
R1362 VSS.n290 VSS.n285 0.193616
R1363 VSS.n304 VSS.n299 0.193616
R1364 VSS.n837 VSS.n0 0.161438
R1365 VSS VSS.n837 0.146991
R1366 VSS.n402 VSS.n240 0.113
R1367 VSS.n398 VSS.n240 0.113
R1368 VSS.n398 VSS.n397 0.113
R1369 VSS.n397 VSS.n396 0.113
R1370 VSS.n396 VSS.n245 0.113
R1371 VSS.n392 VSS.n245 0.113
R1372 VSS.n392 VSS.n391 0.113
R1373 VSS.n391 VSS.n390 0.113
R1374 VSS.n390 VSS.n250 0.113
R1375 VSS.n386 VSS.n250 0.113
R1376 VSS.n386 VSS.n385 0.113
R1377 VSS.n385 VSS.n384 0.113
R1378 VSS.n384 VSS.n255 0.113
R1379 VSS.n380 VSS.n255 0.113
R1380 VSS.n380 VSS.n379 0.113
R1381 VSS.n379 VSS.n378 0.113
R1382 VSS.n378 VSS.n260 0.113
R1383 VSS.n374 VSS.n260 0.113
R1384 VSS.n374 VSS.n373 0.113
R1385 VSS.n373 VSS.n372 0.113
R1386 VSS.n372 VSS.n265 0.113
R1387 VSS.n368 VSS.n265 0.113
R1388 VSS.n368 VSS.n367 0.113
R1389 VSS.n367 VSS.n366 0.113
R1390 VSS.n366 VSS.n270 0.113
R1391 VSS.n362 VSS.n270 0.113
R1392 VSS.n362 VSS.n361 0.113
R1393 VSS.n361 VSS.n360 0.113
R1394 VSS.n360 VSS.n275 0.113
R1395 VSS.n356 VSS.n275 0.113
R1396 VSS.n356 VSS.n355 0.113
R1397 VSS.n355 VSS.n354 0.113
R1398 VSS.n354 VSS.n280 0.113
R1399 VSS.n350 VSS.n349 0.113
R1400 VSS.n349 VSS.n348 0.113
R1401 VSS.n348 VSS.n311 0.113
R1402 VSS.n344 VSS.n311 0.113
R1403 VSS.n404 VSS.n403 0.113
R1404 VSS.n404 VSS.n228 0.113
R1405 VSS.n419 VSS.n228 0.113
R1406 VSS.n420 VSS.n419 0.113
R1407 VSS.n421 VSS.n420 0.113
R1408 VSS.n421 VSS.n217 0.113
R1409 VSS.n436 VSS.n217 0.113
R1410 VSS.n437 VSS.n436 0.113
R1411 VSS.n438 VSS.n437 0.113
R1412 VSS.n438 VSS.n206 0.113
R1413 VSS.n452 VSS.n206 0.113
R1414 VSS.n453 VSS.n452 0.113
R1415 VSS.n454 VSS.n453 0.113
R1416 VSS.n454 VSS.n194 0.113
R1417 VSS.n468 VSS.n194 0.113
R1418 VSS.n469 VSS.n468 0.113
R1419 VSS.n470 VSS.n469 0.113
R1420 VSS.n470 VSS.n182 0.113
R1421 VSS.n484 VSS.n182 0.113
R1422 VSS.n485 VSS.n484 0.113
R1423 VSS.n486 VSS.n485 0.113
R1424 VSS.n486 VSS.n170 0.113
R1425 VSS.n500 VSS.n170 0.113
R1426 VSS.n501 VSS.n500 0.113
R1427 VSS.n502 VSS.n501 0.113
R1428 VSS.n502 VSS.n158 0.113
R1429 VSS.n516 VSS.n158 0.113
R1430 VSS.n517 VSS.n516 0.113
R1431 VSS.n518 VSS.n517 0.113
R1432 VSS.n518 VSS.n146 0.113
R1433 VSS.n532 VSS.n146 0.113
R1434 VSS.n533 VSS.n532 0.113
R1435 VSS.n534 VSS.n533 0.113
R1436 VSS.n534 VSS.n134 0.113
R1437 VSS.n548 VSS.n134 0.113
R1438 VSS.n549 VSS.n548 0.113
R1439 VSS.n550 VSS.n549 0.113
R1440 VSS.n550 VSS.n122 0.113
R1441 VSS.n564 VSS.n122 0.113
R1442 VSS.n565 VSS.n564 0.113
R1443 VSS.n566 VSS.n565 0.113
R1444 VSS.n566 VSS.n110 0.113
R1445 VSS.n580 VSS.n110 0.113
R1446 VSS.n581 VSS.n580 0.113
R1447 VSS.n582 VSS.n581 0.113
R1448 VSS.n582 VSS.n98 0.113
R1449 VSS.n596 VSS.n98 0.113
R1450 VSS.n597 VSS.n596 0.113
R1451 VSS.n598 VSS.n597 0.113
R1452 VSS.n598 VSS.n86 0.113
R1453 VSS.n612 VSS.n86 0.113
R1454 VSS.n613 VSS.n612 0.113
R1455 VSS.n614 VSS.n613 0.113
R1456 VSS.n614 VSS.n74 0.113
R1457 VSS.n628 VSS.n74 0.113
R1458 VSS.n629 VSS.n628 0.113
R1459 VSS.n630 VSS.n629 0.113
R1460 VSS.n630 VSS.n62 0.113
R1461 VSS.n644 VSS.n62 0.113
R1462 VSS.n645 VSS.n644 0.113
R1463 VSS.n646 VSS.n645 0.113
R1464 VSS.n646 VSS.n48 0.113
R1465 VSS.n661 VSS.n48 0.113
R1466 VSS.n662 VSS.n661 0.113
R1467 VSS.n663 VSS.n662 0.113
R1468 VSS.n663 VSS.n36 0.113
R1469 VSS.n681 VSS.n36 0.113
R1470 VSS.n682 VSS.n681 0.113
R1471 VSS.n683 VSS.n682 0.113
R1472 VSS.n683 VSS.n29 0.113
R1473 VSS.n693 VSS.n29 0.113
R1474 VSS.n694 VSS.n693 0.113
R1475 VSS.n828 VSS.n827 0.113
R1476 VSS.n827 VSS.n826 0.113
R1477 VSS.n826 VSS.n695 0.113
R1478 VSS.n822 VSS.n695 0.113
R1479 VSS.n822 VSS.n821 0.113
R1480 VSS.n821 VSS.n820 0.113
R1481 VSS.n820 VSS.n701 0.113
R1482 VSS.n816 VSS.n701 0.113
R1483 VSS.n816 VSS.n815 0.113
R1484 VSS.n815 VSS.n814 0.113
R1485 VSS.n814 VSS.n707 0.113
R1486 VSS.n810 VSS.n707 0.113
R1487 VSS.n810 VSS.n809 0.113
R1488 VSS.n809 VSS.n808 0.113
R1489 VSS.n808 VSS.n713 0.113
R1490 VSS.n804 VSS.n713 0.113
R1491 VSS.n804 VSS.n803 0.113
R1492 VSS.n803 VSS.n802 0.113
R1493 VSS.n802 VSS.n719 0.113
R1494 VSS.n798 VSS.n719 0.113
R1495 VSS.n798 VSS.n797 0.113
R1496 VSS.n797 VSS.n796 0.113
R1497 VSS.n796 VSS.n725 0.113
R1498 VSS.n792 VSS.n725 0.113
R1499 VSS.n792 VSS.n791 0.113
R1500 VSS.n791 VSS.n790 0.113
R1501 VSS.n790 VSS.n731 0.113
R1502 VSS.n786 VSS.n731 0.113
R1503 VSS.n786 VSS.n785 0.113
R1504 VSS.n785 VSS.n784 0.113
R1505 VSS.n784 VSS.n737 0.113
R1506 VSS.n780 VSS.n737 0.113
R1507 VSS.n780 VSS.n779 0.113
R1508 VSS.n752 VSS.n743 0.113
R1509 VSS.n748 VSS.n743 0.113
R1510 VSS.n748 VSS.n747 0.113
R1511 VSS.n747 VSS.n0 0.113
R1512 VSS.n350 VSS.n310 0.0895625
R1513 VSS.n778 VSS.n752 0.0895625
R1514 VSS.n776 VSS.n767 0.0796667
R1515 VSS.n762 VSS.n753 0.0796667
R1516 VSS.n294 VSS.n285 0.0796667
R1517 VSS.n308 VSS.n299 0.0796667
R1518 VSS.n837 VSS.n836 0.0340526
R1519 VSS.n410 VSS.n233 0.0241842
R1520 VSS.n411 VSS.n410 0.0241842
R1521 VSS.n412 VSS.n411 0.0241842
R1522 VSS.n412 VSS.n222 0.0241842
R1523 VSS.n427 VSS.n222 0.0241842
R1524 VSS.n428 VSS.n427 0.0241842
R1525 VSS.n429 VSS.n428 0.0241842
R1526 VSS.n429 VSS.n211 0.0241842
R1527 VSS.n444 VSS.n211 0.0241842
R1528 VSS.n445 VSS.n444 0.0241842
R1529 VSS.n446 VSS.n445 0.0241842
R1530 VSS.n446 VSS.n200 0.0241842
R1531 VSS.n460 VSS.n200 0.0241842
R1532 VSS.n461 VSS.n460 0.0241842
R1533 VSS.n462 VSS.n461 0.0241842
R1534 VSS.n462 VSS.n188 0.0241842
R1535 VSS.n476 VSS.n188 0.0241842
R1536 VSS.n477 VSS.n476 0.0241842
R1537 VSS.n478 VSS.n477 0.0241842
R1538 VSS.n478 VSS.n176 0.0241842
R1539 VSS.n492 VSS.n176 0.0241842
R1540 VSS.n493 VSS.n492 0.0241842
R1541 VSS.n494 VSS.n493 0.0241842
R1542 VSS.n494 VSS.n164 0.0241842
R1543 VSS.n508 VSS.n164 0.0241842
R1544 VSS.n509 VSS.n508 0.0241842
R1545 VSS.n510 VSS.n509 0.0241842
R1546 VSS.n510 VSS.n152 0.0241842
R1547 VSS.n524 VSS.n152 0.0241842
R1548 VSS.n525 VSS.n524 0.0241842
R1549 VSS.n526 VSS.n525 0.0241842
R1550 VSS.n526 VSS.n139 0.0241842
R1551 VSS.n540 VSS.n139 0.0241842
R1552 VSS.n541 VSS.n540 0.0241842
R1553 VSS.n542 VSS.n541 0.0241842
R1554 VSS.n542 VSS.n128 0.0241842
R1555 VSS.n556 VSS.n128 0.0241842
R1556 VSS.n557 VSS.n556 0.0241842
R1557 VSS.n558 VSS.n557 0.0241842
R1558 VSS.n558 VSS.n116 0.0241842
R1559 VSS.n572 VSS.n116 0.0241842
R1560 VSS.n573 VSS.n572 0.0241842
R1561 VSS.n574 VSS.n573 0.0241842
R1562 VSS.n574 VSS.n104 0.0241842
R1563 VSS.n588 VSS.n104 0.0241842
R1564 VSS.n589 VSS.n588 0.0241842
R1565 VSS.n590 VSS.n589 0.0241842
R1566 VSS.n590 VSS.n92 0.0241842
R1567 VSS.n604 VSS.n92 0.0241842
R1568 VSS.n605 VSS.n604 0.0241842
R1569 VSS.n606 VSS.n605 0.0241842
R1570 VSS.n606 VSS.n80 0.0241842
R1571 VSS.n620 VSS.n80 0.0241842
R1572 VSS.n621 VSS.n620 0.0241842
R1573 VSS.n622 VSS.n621 0.0241842
R1574 VSS.n622 VSS.n67 0.0241842
R1575 VSS.n636 VSS.n67 0.0241842
R1576 VSS.n637 VSS.n636 0.0241842
R1577 VSS.n638 VSS.n637 0.0241842
R1578 VSS.n638 VSS.n56 0.0241842
R1579 VSS.n652 VSS.n56 0.0241842
R1580 VSS.n653 VSS.n652 0.0241842
R1581 VSS.n655 VSS.n653 0.0241842
R1582 VSS.n655 VSS.n654 0.0241842
R1583 VSS.n654 VSS.n42 0.0241842
R1584 VSS.n670 VSS.n42 0.0241842
R1585 VSS.n671 VSS.n670 0.0241842
R1586 VSS.n674 VSS.n671 0.0241842
R1587 VSS.n674 VSS.n673 0.0241842
R1588 VSS.n673 VSS.n672 0.0241842
R1589 VSS.n672 VSS.n1 0.0241842
R1590 VSS.n836 VSS.n1 0.0241842
R1591 VSS.n310 VSS.n280 0.0239375
R1592 VSS.n779 VSS.n778 0.0239375
C0 sp outn 6.08199f
C1 outp outn 0.40036f
C2 inn outn 1.68611f
C3 outn nb 0.41868f
C4 inp sp 0.70382f
C5 outn VDD 2.01105f
C6 inp inn 0.29061f
C7 inp nb 0.00991f
C8 inp VDD 0.0209f
C9 inp outn 0.42353f
C10 sn sp 5.17757f
C11 sn outp 6.10684f
C12 sn inn 0.77851f
C13 sn nb 2.56069f
C14 sn VDD 0.41473f
C15 sp outp 0.02589f
C16 sp inn 0.02062f
C17 sp nb 2.75f
C18 sp VDD 0.29989f
C19 sn outn 0.06666f
C20 outp inn 0.96992f
C21 outp nb 0.41814f
C22 outp VDD 0.10531f
C23 inn nb 0.00985f
C24 inn VDD 0.65237f
C25 sn inp 0.00847f
C26 outp VSS 4.05266f
C27 inn VSS 5.33607f
C28 nb VSS 10.51432f
C29 outn VSS 5.92068f
C30 VDD VSS 8.92044f
C31 inp VSS 1.80932f
C32 sn VSS 9.61546f
C33 sp VSS 9.74498f
C34 inp.t0 VSS 0.11565f
C35 inp.t1 VSS 0.10652f
C36 inp.n0 VSS 0.25651f
C37 inp.t2 VSS 0.11565f
C38 inp.n1 VSS 0.13676f
C39 inp.t3 VSS 0.10652f
C40 inp.n2 VSS 0.28598f
C41 VDD.t0 VSS 0.25633f
C42 VDD.t1 VSS 0.25619f
C43 VDD.n0 VSS 2.26737f
C44 outn.t4 VSS 1.97654f
C45 outn.t1 VSS 0.14021f
C46 outn.t2 VSS 0.14021f
C47 outn.n0 VSS 0.48029f
C48 outn.t3 VSS 0.14021f
C49 outn.t0 VSS 0.14021f
C50 outn.n1 VSS 0.47141f
C51 outn.n2 VSS 1.57872f
C52 outn.n3 VSS 2.74747f
C53 nb.n0 VSS 1.04086f
C54 nb.t0 VSS 0.13097f
C55 nb.n1 VSS 0.08855f
C56 nb.t1 VSS 0.11429f
C57 nb.n2 VSS 0.08776f
C58 nb.t2 VSS 0.13096f
C59 nb.n3 VSS 0.10263f
C60 nb.t3 VSS 0.11429f
C61 nb.n4 VSS 0.09027f
C62 nb.t4 VSS 0.13096f
C63 nb.n5 VSS 0.10263f
C64 nb.t5 VSS 0.11429f
C65 nb.n6 VSS 0.69761f
C66 nb.t6 VSS 0.13096f
C67 nb.n7 VSS 0.70998f
C68 nb.t7 VSS 0.11429f
C69 nb.n8 VSS 0.09027f
C70 nb.t8 VSS 0.13096f
C71 nb.n9 VSS 0.10263f
C72 nb.t9 VSS 0.11429f
C73 nb.n10 VSS 0.09027f
C74 nb.t10 VSS 0.13096f
C75 nb.n11 VSS 0.10013f
C76 nb.t11 VSS 0.11429f
C77 nb.n12 VSS 0.07618f
C78 nb.n13 VSS 1.06015f
C79 inn.t3 VSS 0.14357f
C80 inn.t2 VSS 0.15587f
C81 inn.n0 VSS 0.34684f
C82 inn.t1 VSS 0.14356f
C83 inn.n1 VSS 0.17145f
C84 inn.t0 VSS 0.15587f
C85 inn.n2 VSS 0.6895f
C86 outp.t3 VSS 1.80223f
C87 outp.t1 VSS 0.12788f
C88 outp.t2 VSS 0.12788f
C89 outp.n0 VSS 0.43806f
C90 outp.t4 VSS 0.12788f
C91 outp.t0 VSS 0.12788f
C92 outp.n1 VSS 0.42997f
C93 outp.n2 VSS 1.43992f
C94 outp.n3 VSS 2.16727f
.ends
