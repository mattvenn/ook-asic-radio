* tx_ring: magic R+C extraction of layout/tx_ring.gds (layout/pex.sh)
.subckt tx_ring en out VDD VSS
X0 VSS r19 r20 VSS sky130_fd_pr__nfet_01v8 ad=0.169 pd=1.82 as=0.08775 ps=0.92 w=0.65 l=0.15
X1 r19 r18 VSS VSS sky130_fd_pr__nfet_01v8 ad=0.08775 pd=0.92 as=0.169 ps=1.82 w=0.65 l=0.15
X2 VSS r21 r22 VSS sky130_fd_pr__nfet_01v8 ad=0.169 pd=1.82 as=0.08775 ps=0.92 w=0.65 l=0.15
X3 VDD.t23 r12 r13 VDD.t22 sky130_fd_pr__pfet_01v8_hvt ad=0.26 pd=2.52 as=0.135 ps=1.27 w=1 l=0.15
X4 VDD.t73 r1 r2 VDD.t72 sky130_fd_pr__pfet_01v8_hvt ad=0.26 pd=2.52 as=0.135 ps=1.27 w=1 l=0.15
X5 r3 r2 VDD.t55 VDD.t54 sky130_fd_pr__pfet_01v8_hvt ad=0.135 pd=1.27 as=0.26 ps=2.52 w=1 l=0.15
X6 r4 r3 VDD.t37 VDD.t36 sky130_fd_pr__pfet_01v8_hvt ad=0.135 pd=1.27 as=0.26 ps=2.52 w=1 l=0.15
X7 r21 r20 VSS VSS sky130_fd_pr__nfet_01v8 ad=0.08775 pd=0.92 as=0.169 ps=1.82 w=0.65 l=0.15
X8 VSS r14 r15 VSS sky130_fd_pr__nfet_01v8 ad=0.169 pd=1.82 as=0.08775 ps=0.92 w=0.65 l=0.15
X9 r14 r13 VSS VSS sky130_fd_pr__nfet_01v8 ad=0.08775 pd=0.92 as=0.169 ps=1.82 w=0.65 l=0.15
X10 VDD.t47 r8 r9 VDD.t46 sky130_fd_pr__pfet_01v8_hvt ad=0.26 pd=2.52 as=0.135 ps=1.27 w=1 l=0.15
X11 r4 r3 VSS VSS sky130_fd_pr__nfet_01v8 ad=0.08775 pd=0.92 as=0.169 ps=1.82 w=0.65 l=0.15
X12 r7 r6 VSS VSS sky130_fd_pr__nfet_01v8 ad=0.08775 pd=0.92 as=0.169 ps=1.82 w=0.65 l=0.15
X13 r20 r19 VSS VSS sky130_fd_pr__nfet_01v8 ad=0.08775 pd=0.92 as=0.169 ps=1.82 w=0.65 l=0.15
X14 VDD.t15 r22 out.t4 VDD.t14 sky130_fd_pr__pfet_01v8_hvt ad=0.26 pd=2.52 as=0.135 ps=1.27 w=1 l=0.15
X15 r10 r9 VDD.t75 VDD.t74 sky130_fd_pr__pfet_01v8_hvt ad=0.135 pd=1.27 as=0.26 ps=2.52 w=1 l=0.15
X16 r22 r21 VSS VSS sky130_fd_pr__nfet_01v8 ad=0.08775 pd=0.92 as=0.169 ps=1.82 w=0.65 l=0.15
X17 VDD.t81 out.t8 r1 VDD.t80 sky130_fd_pr__pfet_01v8_hvt ad=0.26 pd=2.52 as=0.135 ps=1.27 w=1 l=0.15
X18 r2 r1 VDD.t71 VDD.t70 sky130_fd_pr__pfet_01v8_hvt ad=0.135 pd=1.27 as=0.26 ps=2.52 w=1 l=0.15
X19 r2 r1 VSS VSS sky130_fd_pr__nfet_01v8 ad=0.08775 pd=0.92 as=0.169 ps=1.82 w=0.65 l=0.15
X20 r3 r2 VSS VSS sky130_fd_pr__nfet_01v8 ad=0.08775 pd=0.92 as=0.169 ps=1.82 w=0.65 l=0.15
X21 VSS r15 r16 VSS sky130_fd_pr__nfet_01v8 ad=0.169 pd=1.82 as=0.08775 ps=0.92 w=0.65 l=0.15
X22 r15 r14 VSS VSS sky130_fd_pr__nfet_01v8 ad=0.08775 pd=0.92 as=0.169 ps=1.82 w=0.65 l=0.15
X23 r9 r8 VDD.t45 VDD.t44 sky130_fd_pr__pfet_01v8_hvt ad=0.135 pd=1.27 as=0.26 ps=2.52 w=1 l=0.15
X24 VSS r8 r9 VSS sky130_fd_pr__nfet_01v8 ad=0.169 pd=1.82 as=0.08775 ps=0.92 w=0.65 l=0.15
X25 VSS r9 r10 VSS sky130_fd_pr__nfet_01v8 ad=0.169 pd=1.82 as=0.08775 ps=0.92 w=0.65 l=0.15
X26 r1 out.t9 VDD.t79 VDD.t78 sky130_fd_pr__pfet_01v8_hvt ad=0.135 pd=1.27 as=0.26 ps=2.52 w=1 l=0.15
X27 r8 r7 VDD.t82 VDD.t66 sky130_fd_pr__pfet_01v8_hvt ad=0.135 pd=1.27 as=0.26 ps=2.52 w=1 l=0.15
X28 r16 r15 VSS VSS sky130_fd_pr__nfet_01v8 ad=0.08775 pd=0.92 as=0.169 ps=1.82 w=0.65 l=0.15
X29 out.t5 r22 VDD.t13 VDD.t12 sky130_fd_pr__pfet_01v8_hvt ad=0.135 pd=1.27 as=0.135 ps=1.27 w=1 l=0.15
X30 r17 r16 VDD.t67 VDD.t66 sky130_fd_pr__pfet_01v8_hvt ad=0.135 pd=1.27 as=0.26 ps=2.52 w=1 l=0.15
X31 VSS r16 r17 VSS sky130_fd_pr__nfet_01v8 ad=0.169 pd=1.82 as=0.08775 ps=0.92 w=0.65 l=0.15
X32 VDD.t51 en.t0 out.t2 VDD.t50 sky130_fd_pr__pfet_01v8_hvt ad=0.135 pd=1.27 as=0.135 ps=1.27 w=1 l=0.15
X33 VDD.t3 r20 r21 VDD.t2 sky130_fd_pr__pfet_01v8_hvt ad=0.26 pd=2.52 as=0.135 ps=1.27 w=1 l=0.15
X34 VDD.t87 r11 r12 VDD.t86 sky130_fd_pr__pfet_01v8_hvt ad=0.26 pd=2.52 as=0.135 ps=1.27 w=1 l=0.15
X35 VSS r3 r4 VSS sky130_fd_pr__nfet_01v8 ad=0.169 pd=1.82 as=0.08775 ps=0.92 w=0.65 l=0.15
X36 VSS r4 r5 VSS sky130_fd_pr__nfet_01v8 ad=0.169 pd=1.82 as=0.08775 ps=0.92 w=0.65 l=0.15
X37 r8 r7 VSS VSS sky130_fd_pr__nfet_01v8 ad=0.08775 pd=0.92 as=0.169 ps=1.82 w=0.65 l=0.15
X38 VSS r12 r13 VSS sky130_fd_pr__nfet_01v8 ad=0.169 pd=1.82 as=0.08775 ps=0.92 w=0.65 l=0.15
X39 out.t1 en.t1 VDD.t49 VDD.t48 sky130_fd_pr__pfet_01v8_hvt ad=0.135 pd=1.27 as=0.26 ps=2.52 w=1 l=0.15
X40 VDD.t27 r13 r14 VDD.t26 sky130_fd_pr__pfet_01v8_hvt ad=0.26 pd=2.52 as=0.135 ps=1.27 w=1 l=0.15
X41 VSS r2 r3 VSS sky130_fd_pr__nfet_01v8 ad=0.169 pd=1.82 as=0.08775 ps=0.92 w=0.65 l=0.15
X42 r10 r9 VSS VSS sky130_fd_pr__nfet_01v8 ad=0.08775 pd=0.92 as=0.169 ps=1.82 w=0.65 l=0.15
X43 r13 r12 VDD.t21 VDD.t20 sky130_fd_pr__pfet_01v8_hvt ad=0.135 pd=1.27 as=0.26 ps=2.52 w=1 l=0.15
X44 VDD.t61 r6 r7 VDD.t42 sky130_fd_pr__pfet_01v8_hvt ad=0.26 pd=2.52 as=0.135 ps=1.27 w=1 l=0.15
X45 a_139_911# r22 VSS VSS sky130_fd_pr__nfet_01v8 ad=0.169 pd=1.82 as=0.08775 ps=0.92 w=0.65 l=0.15
X46 VDD.t43 r17 r18 VDD.t42 sky130_fd_pr__pfet_01v8_hvt ad=0.26 pd=2.52 as=0.135 ps=1.27 w=1 l=0.15
X47 VDD.t59 r5 r6 VDD.t18 sky130_fd_pr__pfet_01v8_hvt ad=0.26 pd=2.52 as=0.135 ps=1.27 w=1 l=0.15
X48 r7 r6 VDD.t60 VDD.t40 sky130_fd_pr__pfet_01v8_hvt ad=0.135 pd=1.27 as=0.26 ps=2.52 w=1 l=0.15
X49 VSS r22 a_139_911# VSS sky130_fd_pr__nfet_01v8 ad=0.08775 pd=0.92 as=0.08775 ps=0.92 w=0.65 l=0.15
X50 VDD.t19 r18 r19 VDD.t18 sky130_fd_pr__pfet_01v8_hvt ad=0.26 pd=2.52 as=0.135 ps=1.27 w=1 l=0.15
X51 r5 r4 VSS VSS sky130_fd_pr__nfet_01v8 ad=0.08775 pd=0.92 as=0.169 ps=1.82 w=0.65 l=0.15
X52 r17 r16 VSS VSS sky130_fd_pr__nfet_01v8 ad=0.08775 pd=0.92 as=0.169 ps=1.82 w=0.65 l=0.15
X53 r18 r17 VDD.t41 VDD.t40 sky130_fd_pr__pfet_01v8_hvt ad=0.135 pd=1.27 as=0.26 ps=2.52 w=1 l=0.15
X54 VDD.t53 r4 r5 VDD.t6 sky130_fd_pr__pfet_01v8_hvt ad=0.26 pd=2.52 as=0.135 ps=1.27 w=1 l=0.15
X55 r6 r5 VDD.t58 VDD.t16 sky130_fd_pr__pfet_01v8_hvt ad=0.135 pd=1.27 as=0.26 ps=2.52 w=1 l=0.15
X56 r6 r5 VSS VSS sky130_fd_pr__nfet_01v8 ad=0.08775 pd=0.92 as=0.169 ps=1.82 w=0.65 l=0.15
X57 VDD.t7 r19 r20 VDD.t6 sky130_fd_pr__pfet_01v8_hvt ad=0.26 pd=2.52 as=0.135 ps=1.27 w=1 l=0.15
X58 r19 r18 VDD.t17 VDD.t16 sky130_fd_pr__pfet_01v8_hvt ad=0.135 pd=1.27 as=0.26 ps=2.52 w=1 l=0.15
X59 r12 r11 VDD.t85 VDD.t84 sky130_fd_pr__pfet_01v8_hvt ad=0.135 pd=1.27 as=0.26 ps=2.52 w=1 l=0.15
X60 r1 out.t7 VSS VSS sky130_fd_pr__nfet_01v8 ad=0.08775 pd=0.92 as=0.169 ps=1.82 w=0.65 l=0.15
X61 VSS r7 r8 VSS sky130_fd_pr__nfet_01v8 ad=0.169 pd=1.82 as=0.08775 ps=0.92 w=0.65 l=0.15
X62 a_139_911# en.t2 out.t3 VSS sky130_fd_pr__nfet_01v8 ad=0.08775 pd=0.92 as=0.08775 ps=0.92 w=0.65 l=0.15
X63 VDD.t65 r10 r11 VDD.t64 sky130_fd_pr__pfet_01v8_hvt ad=0.26 pd=2.52 as=0.135 ps=1.27 w=1 l=0.15
X64 r11 r10 VSS VSS sky130_fd_pr__nfet_01v8 ad=0.08775 pd=0.92 as=0.169 ps=1.82 w=0.65 l=0.15
X65 VSS r20 r21 VSS sky130_fd_pr__nfet_01v8 ad=0.169 pd=1.82 as=0.08775 ps=0.92 w=0.65 l=0.15
X66 VDD.t11 r21 r22 VDD.t10 sky130_fd_pr__pfet_01v8_hvt ad=0.26 pd=2.52 as=0.135 ps=1.27 w=1 l=0.15
X67 r21 r20 VDD.t1 VDD.t0 sky130_fd_pr__pfet_01v8_hvt ad=0.135 pd=1.27 as=0.26 ps=2.52 w=1 l=0.15
X68 VDD.t35 r14 r15 VDD.t34 sky130_fd_pr__pfet_01v8_hvt ad=0.26 pd=2.52 as=0.135 ps=1.27 w=1 l=0.15
X69 VDD.t39 r3 r4 VDD.t38 sky130_fd_pr__pfet_01v8_hvt ad=0.26 pd=2.52 as=0.135 ps=1.27 w=1 l=0.15
X70 r5 r4 VDD.t52 VDD.t4 sky130_fd_pr__pfet_01v8_hvt ad=0.135 pd=1.27 as=0.26 ps=2.52 w=1 l=0.15
X71 r12 r11 VSS VSS sky130_fd_pr__nfet_01v8 ad=0.08775 pd=0.92 as=0.169 ps=1.82 w=0.65 l=0.15
X72 out.t0 en.t3 a_139_911# VSS sky130_fd_pr__nfet_01v8 ad=0.08775 pd=0.92 as=0.169 ps=1.82 w=0.65 l=0.15
X73 r14 r13 VDD.t25 VDD.t24 sky130_fd_pr__pfet_01v8_hvt ad=0.135 pd=1.27 as=0.26 ps=2.52 w=1 l=0.15
X74 VSS r13 r14 VSS sky130_fd_pr__nfet_01v8 ad=0.169 pd=1.82 as=0.08775 ps=0.92 w=0.65 l=0.15
X75 r13 r12 VSS VSS sky130_fd_pr__nfet_01v8 ad=0.08775 pd=0.92 as=0.169 ps=1.82 w=0.65 l=0.15
X76 r22 r21 VDD.t9 VDD.t8 sky130_fd_pr__pfet_01v8_hvt ad=0.135 pd=1.27 as=0.26 ps=2.52 w=1 l=0.15
X77 r20 r19 VDD.t5 VDD.t4 sky130_fd_pr__pfet_01v8_hvt ad=0.135 pd=1.27 as=0.26 ps=2.52 w=1 l=0.15
X78 r11 r10 VDD.t63 VDD.t62 sky130_fd_pr__pfet_01v8_hvt ad=0.135 pd=1.27 as=0.26 ps=2.52 w=1 l=0.15
X79 VSS r17 r18 VSS sky130_fd_pr__nfet_01v8 ad=0.169 pd=1.82 as=0.08775 ps=0.92 w=0.65 l=0.15
X80 VDD.t31 r15 r16 VDD.t30 sky130_fd_pr__pfet_01v8_hvt ad=0.26 pd=2.52 as=0.135 ps=1.27 w=1 l=0.15
X81 r15 r14 VDD.t33 VDD.t32 sky130_fd_pr__pfet_01v8_hvt ad=0.135 pd=1.27 as=0.26 ps=2.52 w=1 l=0.15
X82 VSS r5 r6 VSS sky130_fd_pr__nfet_01v8 ad=0.169 pd=1.82 as=0.08775 ps=0.92 w=0.65 l=0.15
X83 VSS r6 r7 VSS sky130_fd_pr__nfet_01v8 ad=0.169 pd=1.82 as=0.08775 ps=0.92 w=0.65 l=0.15
X84 r16 r15 VDD.t29 VDD.t28 sky130_fd_pr__pfet_01v8_hvt ad=0.135 pd=1.27 as=0.26 ps=2.52 w=1 l=0.15
X85 VDD.t83 r7 r8 VDD.t68 sky130_fd_pr__pfet_01v8_hvt ad=0.26 pd=2.52 as=0.135 ps=1.27 w=1 l=0.15
X86 VSS out.t6 r1 VSS sky130_fd_pr__nfet_01v8 ad=0.169 pd=1.82 as=0.08775 ps=0.92 w=0.65 l=0.15
X87 VDD.t69 r16 r17 VDD.t68 sky130_fd_pr__pfet_01v8_hvt ad=0.26 pd=2.52 as=0.135 ps=1.27 w=1 l=0.15
X88 VSS r1 r2 VSS sky130_fd_pr__nfet_01v8 ad=0.169 pd=1.82 as=0.08775 ps=0.92 w=0.65 l=0.15
X89 r9 r8 VSS VSS sky130_fd_pr__nfet_01v8 ad=0.08775 pd=0.92 as=0.169 ps=1.82 w=0.65 l=0.15
X90 VSS r10 r11 VSS sky130_fd_pr__nfet_01v8 ad=0.169 pd=1.82 as=0.08775 ps=0.92 w=0.65 l=0.15
X91 VSS r18 r19 VSS sky130_fd_pr__nfet_01v8 ad=0.169 pd=1.82 as=0.08775 ps=0.92 w=0.65 l=0.15
X92 r18 r17 VSS VSS sky130_fd_pr__nfet_01v8 ad=0.08775 pd=0.92 as=0.169 ps=1.82 w=0.65 l=0.15
X93 VDD.t57 r2 r3 VDD.t56 sky130_fd_pr__pfet_01v8_hvt ad=0.26 pd=2.52 as=0.135 ps=1.27 w=1 l=0.15
X94 VDD.t77 r9 r10 VDD.t76 sky130_fd_pr__pfet_01v8_hvt ad=0.26 pd=2.52 as=0.135 ps=1.27 w=1 l=0.15
X95 VSS r11 r12 VSS sky130_fd_pr__nfet_01v8 ad=0.169 pd=1.82 as=0.08775 ps=0.92 w=0.65 l=0.15
R0 out.n3 out.n1 243.68
R1 out out.n0 213.334
R2 out.n6 out.t8 212.081
R3 out.n7 out.t9 212.081
R4 out.n3 out.n2 205.28
R5 out.n8 out.n7 184.721
R6 out.n6 out.t6 139.78
R7 out.n7 out.t7 139.78
R8 out.n7 out.n6 61.346
R9 out.n1 out.t4 26.5955
R10 out.n1 out.t5 26.5955
R11 out.n2 out.t2 26.5955
R12 out.n2 out.t1 26.5955
R13 out.n0 out.t3 24.9236
R14 out.n0 out.t0 24.9236
R15 out.n4 out.n3 18.824
R16 out out.n4 13.9434
R17 out.n5 out 11.6576
R18 out out.n5 11.176
R19 out.n9 out.n8 10.4822
R20 out.n8 out 4.3525
R21 out.n5 out 3.88621
R22 out.n4 out 1.6005
R23 out.n11 out.n9 0.88211
R24 out.n9 out 0.609771
R25 out.n11 out.n10 0.0601773
R26 out.n10 out 0.0475
R27 out.n10 out 0.0226176
R28 out out.n11 0.0133631
R29 en.n0 en.t0 212.081
R30 en.n1 en.t1 212.081
R31 en.n3 en.n2 156.864
R32 en.n0 en.t2 139.78
R33 en.n1 en.t3 139.78
R34 en.n2 en.n0 30.6732
R35 en.n2 en.n1 30.6732
R36 en.n3 en 11.534
R37 en en.n3 4.3525
R38 VDD.n75 VDD.t49 338.108
R39 VDD.n71 VDD.n8 320.976
R40 VDD.n49 VDD.t53 255.453
R41 VDD.n15 VDD.t59 255.453
R42 VDD.n40 VDD.t61 255.453
R43 VDD.n19 VDD.t83 255.453
R44 VDD.n51 VDD.t5 255.453
R45 VDD.n48 VDD.t17 255.453
R46 VDD.n42 VDD.t41 255.453
R47 VDD.n39 VDD.t67 255.453
R48 VDD.n5 VDD.t39 254.475
R49 VDD.n85 VDD.t87 254.475
R50 VDD.n4 VDD.t29 254.475
R51 VDD.n51 VDD.t52 252.95
R52 VDD.n48 VDD.t58 252.95
R53 VDD.n42 VDD.t60 252.95
R54 VDD.n39 VDD.t82 252.95
R55 VDD.n33 VDD.t45 252.95
R56 VDD.n27 VDD.t75 252.95
R57 VDD.n93 VDD.t63 252.95
R58 VDD.n87 VDD.t85 252.95
R59 VDD.n56 VDD.t37 252.95
R60 VDD.n63 VDD.t55 252.95
R61 VDD.n70 VDD.t71 252.95
R62 VDD.n49 VDD.t7 252.948
R63 VDD.n15 VDD.t19 252.948
R64 VDD.n40 VDD.t43 252.948
R65 VDD.n19 VDD.t69 252.948
R66 VDD.n32 VDD.t31 252.948
R67 VDD.n26 VDD.t35 252.948
R68 VDD.n92 VDD.t27 252.948
R69 VDD.n86 VDD.t23 252.948
R70 VDD.n11 VDD.t3 252.948
R71 VDD.n10 VDD.t11 252.948
R72 VDD.n31 VDD.t47 250.724
R73 VDD.n25 VDD.t77 250.724
R74 VDD.n91 VDD.t65 250.724
R75 VDD.n58 VDD.t57 250.724
R76 VDD.n65 VDD.t73 250.724
R77 VDD.n73 VDD.t81 250.724
R78 VDD.n21 VDD.t33 250.722
R79 VDD.n1 VDD.t25 250.722
R80 VDD.n2 VDD.t21 250.722
R81 VDD.n57 VDD.t1 250.722
R82 VDD.n64 VDD.t9 250.722
R83 VDD.n9 VDD.t15 249.362
R84 VDD.n74 VDD.t79 248.219
R85 VDD VDD.n80 232.445
R86 VDD.n81 VDD.n5 213.119
R87 VDD.n82 VDD.n4 213.119
R88 VDD.n83 VDD.t86 198.155
R89 VDD.n82 VDD 182.952
R90 VDD.t20 VDD.t64 167.845
R91 VDD.t24 VDD.t76 167.845
R92 VDD.t32 VDD.t46 167.845
R93 VDD.t0 VDD.t56 167.845
R94 VDD.t8 VDD.t72 167.845
R95 VDD.t68 VDD.t66 140.989
R96 VDD.t42 VDD.t40 140.989
R97 VDD.t18 VDD.t16 140.989
R98 VDD.t6 VDD.t4 140.989
R99 VDD.t12 VDD.t50 140.989
R100 VDD VDD.n81 125.883
R101 VDD.t66 VDD 112.457
R102 VDD.t40 VDD 112.457
R103 VDD.t16 VDD 112.457
R104 VDD.t4 VDD 112.457
R105 VDD.t78 VDD 112.457
R106 VDD.t80 VDD.t48 110.778
R107 VDD.t14 VDD 102.385
R108 VDD.t72 VDD 100.707
R109 VDD.t86 VDD 99.0288
R110 VDD.t22 VDD 99.0288
R111 VDD.t64 VDD 99.0288
R112 VDD.t26 VDD 99.0288
R113 VDD.t76 VDD 99.0288
R114 VDD.t34 VDD 99.0288
R115 VDD.t46 VDD 99.0288
R116 VDD.t30 VDD 99.0288
R117 VDD.t38 VDD 99.0288
R118 VDD.t2 VDD 99.0288
R119 VDD.t56 VDD 99.0288
R120 VDD.t10 VDD 99.0288
R121 VDD.t28 VDD.n82 83.9228
R122 VDD.n81 VDD.t38 83.9228
R123 VDD VDD.t68 55.3892
R124 VDD VDD.t42 55.3892
R125 VDD VDD.t18 55.3892
R126 VDD VDD.t6 55.3892
R127 VDD VDD.t84 41.9616
R128 VDD VDD.t20 41.9616
R129 VDD VDD.t62 41.9616
R130 VDD VDD.t24 41.9616
R131 VDD VDD.t74 41.9616
R132 VDD VDD.t32 41.9616
R133 VDD VDD.t44 41.9616
R134 VDD VDD.t28 41.9616
R135 VDD VDD.t36 41.9616
R136 VDD VDD.t0 41.9616
R137 VDD VDD.t54 41.9616
R138 VDD VDD.t8 41.9616
R139 VDD VDD.t70 40.2832
R140 VDD VDD.t12 38.6047
R141 VDD.n76 VDD.n73 33.1299
R142 VDD.t50 VDD.t80 30.2125
R143 VDD.t48 VDD.t78 30.2125
R144 VDD.n76 VDD.n75 28.2358
R145 VDD.n8 VDD.t13 26.5955
R146 VDD.n8 VDD.t51 26.5955
R147 VDD.n50 VDD.n49 25.224
R148 VDD.n51 VDD.n50 25.224
R149 VDD.n47 VDD.n15 25.224
R150 VDD.n48 VDD.n47 25.224
R151 VDD.n41 VDD.n40 25.224
R152 VDD.n42 VDD.n41 25.224
R153 VDD.n38 VDD.n19 25.224
R154 VDD.n39 VDD.n38 25.224
R155 VDD.n32 VDD.n31 25.224
R156 VDD.n27 VDD.n21 25.224
R157 VDD.n26 VDD.n25 25.224
R158 VDD.n93 VDD.n1 25.224
R159 VDD.n92 VDD.n91 25.224
R160 VDD.n87 VDD.n2 25.224
R161 VDD.n57 VDD.n56 25.224
R162 VDD.n58 VDD.n10 25.224
R163 VDD.n64 VDD.n63 25.224
R164 VDD.n80 VDD.n6 23.7181
R165 VDD.n71 VDD.n70 22.9652
R166 VDD.n65 VDD.n9 22.2123
R167 VDD.n49 VDD.n48 18.824
R168 VDD.n42 VDD.n15 18.824
R169 VDD.n40 VDD.n39 18.824
R170 VDD.n70 VDD.n9 16.5652
R171 VDD VDD.n83 16.1832
R172 VDD.n51 VDD.n5 15.8123
R173 VDD.n19 VDD.n4 15.8123
R174 VDD.n33 VDD.n4 15.8123
R175 VDD.n33 VDD.n32 15.8123
R176 VDD.n27 VDD.n26 15.8123
R177 VDD.n93 VDD.n92 15.8123
R178 VDD.n87 VDD.n86 15.8123
R179 VDD.n86 VDD.n85 15.8123
R180 VDD.n11 VDD.n5 15.8123
R181 VDD.n56 VDD.n11 15.8123
R182 VDD.n63 VDD.n10 15.8123
R183 VDD.t84 VDD.t22 13.4281
R184 VDD.t62 VDD.t26 13.4281
R185 VDD.t74 VDD.t34 13.4281
R186 VDD.t44 VDD.t30 13.4281
R187 VDD.t36 VDD.t2 13.4281
R188 VDD.t54 VDD.t10 13.4281
R189 VDD.t70 VDD.t14 10.0712
R190 VDD.n80 VDD.n79 9.3005
R191 VDD.n85 VDD.n84 9.3005
R192 VDD.n86 VDD.n3 9.3005
R193 VDD.n88 VDD.n87 9.3005
R194 VDD.n90 VDD.n89 9.3005
R195 VDD.n92 VDD.n0 9.3005
R196 VDD.n94 VDD.n93 9.3005
R197 VDD.n24 VDD.n23 9.3005
R198 VDD.n26 VDD.n22 9.3005
R199 VDD.n28 VDD.n27 9.3005
R200 VDD.n30 VDD.n29 9.3005
R201 VDD.n32 VDD.n20 9.3005
R202 VDD.n34 VDD.n33 9.3005
R203 VDD.n35 VDD.n4 9.3005
R204 VDD.n36 VDD.n19 9.3005
R205 VDD.n38 VDD.n37 9.3005
R206 VDD.n39 VDD.n18 9.3005
R207 VDD.n40 VDD.n17 9.3005
R208 VDD.n41 VDD.n16 9.3005
R209 VDD.n43 VDD.n42 9.3005
R210 VDD.n45 VDD.n15 9.3005
R211 VDD.n47 VDD.n46 9.3005
R212 VDD.n48 VDD.n14 9.3005
R213 VDD.n49 VDD.n13 9.3005
R214 VDD.n50 VDD.n12 9.3005
R215 VDD.n52 VDD.n51 9.3005
R216 VDD.n53 VDD.n5 9.3005
R217 VDD.n54 VDD.n11 9.3005
R218 VDD.n56 VDD.n55 9.3005
R219 VDD.n60 VDD.n59 9.3005
R220 VDD.n61 VDD.n10 9.3005
R221 VDD.n63 VDD.n62 9.3005
R222 VDD.n67 VDD.n66 9.3005
R223 VDD.n68 VDD.n9 9.3005
R224 VDD.n70 VDD.n69 9.3005
R225 VDD.n72 VDD.n7 9.3005
R226 VDD.n77 VDD.n76 9.3005
R227 VDD.n78 VDD.n6 9.3005
R228 VDD.n75 VDD.n74 5.64756
R229 VDD.n85 VDD.n83 5.60368
R230 VDD.n72 VDD.n71 3.76521
R231 VDD.n30 VDD.n21 1.50638
R232 VDD.n31 VDD.n30 1.50638
R233 VDD.n24 VDD.n1 1.50638
R234 VDD.n25 VDD.n24 1.50638
R235 VDD.n90 VDD.n2 1.50638
R236 VDD.n91 VDD.n90 1.50638
R237 VDD.n59 VDD.n57 1.50638
R238 VDD.n59 VDD.n58 1.50638
R239 VDD.n66 VDD.n64 1.50638
R240 VDD.n66 VDD.n65 1.50638
R241 VDD.n73 VDD.n72 1.50638
R242 VDD.n74 VDD.n6 0.753441
R243 VDD.n44 VDD 0.718385
R244 VDD.n89 VDD.n0 0.0826429
R245 VDD.n23 VDD.n22 0.0826429
R246 VDD.n29 VDD.n20 0.0826429
R247 VDD.n37 VDD.n18 0.0826429
R248 VDD.n43 VDD.n16 0.0826429
R249 VDD.n46 VDD.n14 0.0826429
R250 VDD.n52 VDD.n12 0.0826429
R251 VDD.n61 VDD.n60 0.0826429
R252 VDD.n68 VDD.n67 0.0826429
R253 VDD.n77 VDD.n7 0.0826429
R254 VDD.n78 VDD.n77 0.0826429
R255 VDD.n88 VDD 0.0674643
R256 VDD.n89 VDD 0.0674643
R257 VDD VDD.n94 0.0674643
R258 VDD.n23 VDD 0.0674643
R259 VDD.n28 VDD 0.0674643
R260 VDD.n29 VDD 0.0674643
R261 VDD.n34 VDD 0.0674643
R262 VDD.n35 VDD 0.0674643
R263 VDD.n37 VDD 0.0674643
R264 VDD VDD.n17 0.0674643
R265 VDD VDD.n16 0.0674643
R266 VDD.n46 VDD 0.0674643
R267 VDD VDD.n13 0.0674643
R268 VDD VDD.n12 0.0674643
R269 VDD.n53 VDD 0.0674643
R270 VDD.n55 VDD 0.0674643
R271 VDD.n60 VDD 0.0674643
R272 VDD.n62 VDD 0.0674643
R273 VDD.n67 VDD 0.0674643
R274 VDD VDD.n7 0.0674643
R275 VDD.n79 VDD 0.0674643
R276 VDD.n69 VDD 0.0665714
R277 VDD.n36 VDD 0.0612143
R278 VDD.n84 VDD 0.05675
R279 VDD VDD.n3 0.05675
R280 VDD.n54 VDD 0.05675
R281 VDD.n45 VDD.n44 0.0415714
R282 VDD.n84 VDD 0.0263929
R283 VDD.n44 VDD 0.0263929
R284 VDD VDD.n53 0.0263929
R285 VDD VDD.n35 0.0219286
R286 VDD.n79 VDD 0.0219286
R287 VDD VDD.n68 0.0165714
R288 VDD.n3 VDD 0.0156786
R289 VDD VDD.n88 0.0156786
R290 VDD VDD.n0 0.0156786
R291 VDD.n94 VDD 0.0156786
R292 VDD.n22 VDD 0.0156786
R293 VDD VDD.n28 0.0156786
R294 VDD.n20 VDD 0.0156786
R295 VDD VDD.n34 0.0156786
R296 VDD VDD.n36 0.0156786
R297 VDD.n18 VDD 0.0156786
R298 VDD.n17 VDD 0.0156786
R299 VDD VDD.n43 0.0156786
R300 VDD VDD.n45 0.0156786
R301 VDD.n14 VDD 0.0156786
R302 VDD.n13 VDD 0.0156786
R303 VDD VDD.n52 0.0156786
R304 VDD VDD.n54 0.0156786
R305 VDD.n55 VDD 0.0156786
R306 VDD VDD.n61 0.0156786
R307 VDD.n62 VDD 0.0156786
R308 VDD.n69 VDD 0.0156786
R309 VDD VDD.n78 0.0156786
R310 VSS VSS.n33 5907.21
R311 VSS.n70 VSS 4319.8
R312 VSS VSS.n97 3121.55
R313 VSS.n34 VSS 2759.32
R314 VSS.n98 VSS 1997.28
R315 VSS VSS.n0 1931.37
R316 VSS.n97 VSS.n96 1198.25
R317 VSS.n35 VSS.n34 1198.25
R318 VSS.n34 VSS 1161.26
R319 VSS.n97 VSS 799.032
R320 VSS.n27 VSS.n13 34.6358
R321 VSS.n28 VSS.n27 34.6358
R322 VSS.n29 VSS.n28 34.6358
R323 VSS.n29 VSS.n11 34.6358
R324 VSS.n23 VSS.n13 28.2358
R325 VSS.n84 VSS.n83 25.224
R326 VSS.n84 VSS.n61 25.224
R327 VSS.n81 VSS.n65 25.224
R328 VSS.n82 VSS.n81 25.224
R329 VSS.n76 VSS.n75 25.224
R330 VSS.n77 VSS.n76 25.224
R331 VSS.n73 VSS.n69 25.224
R332 VSS.n74 VSS.n73 25.224
R333 VSS.n92 VSS.n62 25.224
R334 VSS.n92 VSS.n91 25.224
R335 VSS.n90 VSS.n89 25.224
R336 VSS.n89 VSS.n48 25.224
R337 VSS.n122 VSS.n121 25.224
R338 VSS.n121 VSS.n120 25.224
R339 VSS.n119 VSS.n118 25.224
R340 VSS.n118 VSS.n52 25.224
R341 VSS.n114 VSS.n113 25.224
R342 VSS.n113 VSS.n112 25.224
R343 VSS.n111 VSS.n110 25.224
R344 VSS.n110 VSS.n56 25.224
R345 VSS.n106 VSS.n105 25.224
R346 VSS.n105 VSS.n104 25.224
R347 VSS.n103 VSS.n102 25.224
R348 VSS.n102 VSS.n60 25.224
R349 VSS.n22 VSS.n21 25.224
R350 VSS.n23 VSS.n22 25.224
R351 VSS.n19 VSS.n10 25.224
R352 VSS.n20 VSS.n19 25.224
R353 VSS.n40 VSS.n39 25.224
R354 VSS.n39 VSS.n9 25.224
R355 VSS.n45 VSS.n44 25.224
R356 VSS.n44 VSS.n8 25.224
R357 VSS.n129 VSS.n128 25.224
R358 VSS.n128 VSS.n7 25.224
R359 VSS.n134 VSS.n133 25.224
R360 VSS.n133 VSS.n6 25.224
R361 VSS.n139 VSS.n138 25.224
R362 VSS.n138 VSS.n5 25.224
R363 VSS.n144 VSS.n143 25.224
R364 VSS.n143 VSS.n4 25.224
R365 VSS.n149 VSS.n148 25.224
R366 VSS.n148 VSS.n3 25.224
R367 VSS.n154 VSS.n1 25.224
R368 VSS.n150 VSS.n1 25.224
R369 VSS.n33 VSS.n11 23.7181
R370 VSS.n83 VSS.n82 20.3299
R371 VSS.n77 VSS.n65 20.3299
R372 VSS.n75 VSS.n74 20.3299
R373 VSS.n91 VSS.n90 20.3299
R374 VSS.n122 VSS.n48 20.3299
R375 VSS.n120 VSS.n119 20.3299
R376 VSS.n114 VSS.n52 20.3299
R377 VSS.n112 VSS.n111 20.3299
R378 VSS.n106 VSS.n56 20.3299
R379 VSS.n104 VSS.n103 20.3299
R380 VSS.n21 VSS.n20 20.3299
R381 VSS.n40 VSS.n8 20.3299
R382 VSS.n45 VSS.n7 20.3299
R383 VSS.n129 VSS.n6 20.3299
R384 VSS.n134 VSS.n5 20.3299
R385 VSS.n139 VSS.n4 20.3299
R386 VSS.n144 VSS.n3 20.3299
R387 VSS.n150 VSS.n149 20.3299
R388 VSS VSS.n0 17.5438
R389 VSS.n70 VSS.n69 17.3181
R390 VSS.n96 VSS.n62 17.3181
R391 VSS.n35 VSS.n9 17.3181
R392 VSS.n96 VSS.n61 15.8123
R393 VSS.n98 VSS.n60 15.8123
R394 VSS.n35 VSS.n10 15.8123
R395 VSS.n155 VSS.n154 15.8123
R396 VSS VSS.n70 9.31613
R397 VSS.n99 VSS.n98 9.3005
R398 VSS.n100 VSS.n60 9.3005
R399 VSS.n71 VSS.n69 9.3005
R400 VSS.n73 VSS.n72 9.3005
R401 VSS.n74 VSS.n68 9.3005
R402 VSS.n75 VSS.n67 9.3005
R403 VSS.n76 VSS.n66 9.3005
R404 VSS.n78 VSS.n77 9.3005
R405 VSS.n79 VSS.n65 9.3005
R406 VSS.n81 VSS.n80 9.3005
R407 VSS.n82 VSS.n64 9.3005
R408 VSS.n83 VSS.n63 9.3005
R409 VSS.n85 VSS.n84 9.3005
R410 VSS.n86 VSS.n61 9.3005
R411 VSS.n96 VSS.n95 9.3005
R412 VSS.n94 VSS.n62 9.3005
R413 VSS.n93 VSS.n92 9.3005
R414 VSS.n91 VSS.n87 9.3005
R415 VSS.n90 VSS.n88 9.3005
R416 VSS.n89 VSS.n47 9.3005
R417 VSS.n124 VSS.n48 9.3005
R418 VSS.n123 VSS.n122 9.3005
R419 VSS.n121 VSS.n49 9.3005
R420 VSS.n120 VSS.n50 9.3005
R421 VSS.n119 VSS.n51 9.3005
R422 VSS.n118 VSS.n117 9.3005
R423 VSS.n116 VSS.n52 9.3005
R424 VSS.n115 VSS.n114 9.3005
R425 VSS.n113 VSS.n53 9.3005
R426 VSS.n112 VSS.n54 9.3005
R427 VSS.n111 VSS.n55 9.3005
R428 VSS.n110 VSS.n109 9.3005
R429 VSS.n108 VSS.n56 9.3005
R430 VSS.n107 VSS.n106 9.3005
R431 VSS.n105 VSS.n57 9.3005
R432 VSS.n104 VSS.n58 9.3005
R433 VSS.n103 VSS.n59 9.3005
R434 VSS.n102 VSS.n101 9.3005
R435 VSS.n156 VSS.n155 9.3005
R436 VSS.n154 VSS.n153 9.3005
R437 VSS.n152 VSS.n1 9.3005
R438 VSS.n151 VSS.n150 9.3005
R439 VSS.n149 VSS.n2 9.3005
R440 VSS.n148 VSS.n147 9.3005
R441 VSS.n146 VSS.n3 9.3005
R442 VSS.n145 VSS.n144 9.3005
R443 VSS.n143 VSS.n142 9.3005
R444 VSS.n141 VSS.n4 9.3005
R445 VSS.n140 VSS.n139 9.3005
R446 VSS.n138 VSS.n137 9.3005
R447 VSS.n136 VSS.n5 9.3005
R448 VSS.n135 VSS.n134 9.3005
R449 VSS.n133 VSS.n132 9.3005
R450 VSS.n131 VSS.n6 9.3005
R451 VSS.n130 VSS.n129 9.3005
R452 VSS.n128 VSS.n127 9.3005
R453 VSS.n126 VSS.n7 9.3005
R454 VSS.n46 VSS.n45 9.3005
R455 VSS.n44 VSS.n43 9.3005
R456 VSS.n42 VSS.n8 9.3005
R457 VSS.n41 VSS.n40 9.3005
R458 VSS.n39 VSS.n38 9.3005
R459 VSS.n37 VSS.n9 9.3005
R460 VSS.n36 VSS.n35 9.3005
R461 VSS.n17 VSS.n10 9.3005
R462 VSS.n19 VSS.n18 9.3005
R463 VSS.n20 VSS.n16 9.3005
R464 VSS.n21 VSS.n15 9.3005
R465 VSS.n22 VSS.n14 9.3005
R466 VSS.n24 VSS.n23 9.3005
R467 VSS.n25 VSS.n13 9.3005
R468 VSS.n27 VSS.n26 9.3005
R469 VSS.n28 VSS.n12 9.3005
R470 VSS.n30 VSS.n29 9.3005
R471 VSS.n31 VSS.n11 9.3005
R472 VSS.n33 VSS.n32 9.3005
R473 VSS.n155 VSS.n0 4.5261
R474 VSS.n126 VSS.n125 3.44729
R475 VSS.n125 VSS 0.46084
R476 VSS.n72 VSS.n71 0.058
R477 VSS.n72 VSS.n68 0.058
R478 VSS.n67 VSS.n66 0.058
R479 VSS.n78 VSS.n66 0.058
R480 VSS.n80 VSS.n79 0.058
R481 VSS.n80 VSS.n64 0.058
R482 VSS.n85 VSS.n63 0.058
R483 VSS.n86 VSS.n85 0.058
R484 VSS.n94 VSS.n93 0.058
R485 VSS.n93 VSS.n87 0.058
R486 VSS.n88 VSS.n47 0.058
R487 VSS.n124 VSS.n47 0.058
R488 VSS.n123 VSS.n49 0.058
R489 VSS.n50 VSS.n49 0.058
R490 VSS.n117 VSS.n51 0.058
R491 VSS.n117 VSS.n116 0.058
R492 VSS.n115 VSS.n53 0.058
R493 VSS.n54 VSS.n53 0.058
R494 VSS.n109 VSS.n55 0.058
R495 VSS.n109 VSS.n108 0.058
R496 VSS.n107 VSS.n57 0.058
R497 VSS.n58 VSS.n57 0.058
R498 VSS.n101 VSS.n59 0.058
R499 VSS.n101 VSS.n100 0.058
R500 VSS.n152 VSS.n151 0.058
R501 VSS.n151 VSS.n2 0.058
R502 VSS.n147 VSS.n146 0.058
R503 VSS.n146 VSS.n145 0.058
R504 VSS.n142 VSS.n141 0.058
R505 VSS.n141 VSS.n140 0.058
R506 VSS.n137 VSS.n136 0.058
R507 VSS.n136 VSS.n135 0.058
R508 VSS.n132 VSS.n131 0.058
R509 VSS.n131 VSS.n130 0.058
R510 VSS.n127 VSS.n126 0.058
R511 VSS.n126 VSS.n46 0.058
R512 VSS.n43 VSS.n42 0.058
R513 VSS.n42 VSS.n41 0.058
R514 VSS.n38 VSS.n37 0.058
R515 VSS.n37 VSS.n36 0.058
R516 VSS.n18 VSS.n16 0.058
R517 VSS.n16 VSS.n15 0.058
R518 VSS.n24 VSS.n14 0.058
R519 VSS.n25 VSS.n24 0.058
R520 VSS.n26 VSS.n12 0.058
R521 VSS.n30 VSS.n12 0.058
R522 VSS.n31 VSS.n30 0.058
R523 VSS.n32 VSS.n31 0.058
R524 VSS VSS.n67 0.047375
R525 VSS.n79 VSS 0.047375
R526 VSS VSS.n63 0.047375
R527 VSS.n95 VSS 0.047375
R528 VSS.n88 VSS 0.047375
R529 VSS VSS.n123 0.047375
R530 VSS.n51 VSS 0.047375
R531 VSS VSS.n115 0.047375
R532 VSS.n55 VSS 0.047375
R533 VSS VSS.n107 0.047375
R534 VSS.n59 VSS 0.047375
R535 VSS VSS.n99 0.047375
R536 VSS VSS.n152 0.047375
R537 VSS.n147 VSS 0.047375
R538 VSS.n142 VSS 0.047375
R539 VSS.n137 VSS 0.047375
R540 VSS.n132 VSS 0.047375
R541 VSS.n127 VSS 0.047375
R542 VSS.n43 VSS 0.047375
R543 VSS.n38 VSS 0.047375
R544 VSS.n18 VSS 0.047375
R545 VSS VSS.n14 0.047375
R546 VSS.n26 VSS 0.04675
R547 VSS.n71 VSS 0.042375
R548 VSS VSS.n94 0.042375
R549 VSS VSS.n156 0.04175
R550 VSS.n153 VSS 0.04175
R551 VSS.n17 VSS 0.04175
R552 VSS.n125 VSS.n124 0.0272857
R553 VSS.n156 VSS 0.01675
R554 VSS.n36 VSS 0.01675
R555 VSS.n32 VSS 0.01675
R556 VSS.n95 VSS 0.016125
R557 VSS.n99 VSS 0.016125
R558 VSS VSS.n25 0.01175
R559 VSS.n68 VSS 0.011125
R560 VSS VSS.n78 0.011125
R561 VSS.n64 VSS 0.011125
R562 VSS VSS.n86 0.011125
R563 VSS VSS.n87 0.011125
R564 VSS.n124 VSS 0.011125
R565 VSS VSS.n50 0.011125
R566 VSS.n116 VSS 0.011125
R567 VSS VSS.n54 0.011125
R568 VSS.n108 VSS 0.011125
R569 VSS VSS.n58 0.011125
R570 VSS.n100 VSS 0.011125
R571 VSS.n153 VSS 0.011125
R572 VSS VSS.n2 0.011125
R573 VSS.n145 VSS 0.011125
R574 VSS.n140 VSS 0.011125
R575 VSS.n135 VSS 0.011125
R576 VSS.n130 VSS 0.011125
R577 VSS.n46 VSS 0.011125
R578 VSS.n41 VSS 0.011125
R579 VSS VSS.n17 0.011125
R580 VSS.n15 VSS 0.011125
C0 r16 r12 0.00196f
C1 a_139_911# en 0.04893f
C2 out r4 0.00362f
C3 r15 r16 0.15255f
C4 r3 VDD 0.46944f
C5 r1 r22 0.01131f
C6 en VDD 0.42962f
C7 r14 r9 0.01243f
C8 r17 en 0
C9 r1 out 0.19085f
C10 r6 r8 0
C11 r3 r4 0.15255f
C12 r18 r20 0
C13 a_139_911# VDD 0.00761f
C14 r6 VDD 0.46356f
C15 VDD r8 0.50609f
C16 r17 r6 0.02441f
C17 r3 r1 0
C18 en r1 0.00297f
C19 r20 r21 0.15036f
C20 r6 r4 0
C21 r2 r21 0.01243f
C22 VDD r11 0.4649f
C23 r17 VDD 0.46356f
C24 r14 r16 0
C25 a_139_911# r1 0
C26 r19 r5 0.00121f
C27 r12 r7 0.00125f
C28 VDD r4 0.46356f
C29 r18 r12 0
C30 r9 r8 0.15036f
C31 r1 VDD 0.46643f
C32 out r5 0.00234f
C33 r9 VDD 0.47082f
C34 r9 r11 0
C35 r12 r10 0.00995f
C36 r13 r10 0.01243f
C37 r13 r12 0.18032f
C38 r3 r5 0
C39 r15 r12 0.00355f
C40 r19 r18 0.15255f
C41 r19 r20 0.14408f
C42 r16 r8 0.00111f
C43 r13 r15 0
C44 r19 r21 0
C45 r6 r5 0.15255f
C46 r16 VDD 0.46356f
C47 r17 r16 0.15255f
C48 r20 r22 0
C49 r2 r22 0
C50 r18 out 0
C51 r20 out 0.00136f
C52 VDD r5 0.46356f
C53 r22 r21 0.14989f
C54 r2 out 0.01368f
C55 r14 r10 0.00101f
C56 out r21 0.00276f
C57 r5 r4 0.15255f
C58 r14 r12 0.00862f
C59 r20 r3 0.01243f
C60 r18 en 0.00183f
C61 r2 r3 0.15255f
C62 r20 en 0.00518f
C63 r14 r13 0.15255f
C64 r3 r21 0.00101f
C65 r14 r15 0.15255f
C66 en r21 0.00978f
C67 r6 r7 0.15255f
C68 r18 r6 0.00121f
C69 r7 r8 0.14408f
C70 VDD r7 0.46604f
C71 r18 VDD 0.46356f
C72 r20 VDD 0.50609f
C73 r17 r7 0.00121f
C74 r17 r18 0.15255f
C75 r2 VDD 0.46944f
C76 VDD r21 0.47094f
C77 r20 r4 0.00111f
C78 r10 r8 0
C79 r2 r4 0
C80 r12 r6 0
C81 r12 r8 0.00229f
C82 r19 out 0
C83 VDD r10 0.46944f
C84 r11 r10 0.15255f
C85 r2 r1 0.15255f
C86 r12 VDD 0.76619f
C87 r15 r8 0.01243f
C88 r12 r11 0.17114f
C89 r9 r7 0
C90 r17 r12 0.00123f
C91 r13 VDD 0.46712f
C92 r13 r11 0.00101f
C93 r15 VDD 0.46944f
C94 r22 out 0.08007f
C95 r19 en 0.00273f
C96 r17 r15 0
C97 r9 r10 0.15255f
C98 en r22 0.12276f
C99 r3 out 0.00629f
C100 r12 r9 0.00433f
C101 r16 r7 0.02441f
C102 en out 0.47361f
C103 r18 r16 0
C104 r19 VDD 0.46604f
C105 r15 r9 0.00101f
C106 a_139_911# r22 0.10263f
C107 r17 r19 0
C108 r5 r7 0
C109 r18 r5 0.02441f
C110 r14 VDD 0.46944f
C111 a_139_911# out 0.10708f
C112 r6 out 0
C113 r19 r4 0.02441f
C114 r22 VDD 0.46322f
C115 VDD out 1.06295f
C116 out VSS 1.56021f
C117 en VSS 0.96666f
C118 VDD VSS 11.7298f
C119 r11 VSS 0.48146f
C120 r10 VSS 0.46371f
C121 r9 VSS 0.4641f
C122 r8 VSS 0.50783f
C123 r7 VSS 0.46813f
C124 r6 VSS 0.46303f
C125 r5 VSS 0.46299f
C126 r4 VSS 0.46299f
C127 r3 VSS 0.4628f
C128 r2 VSS 0.4628f
C129 r1 VSS 0.47205f
C130 a_139_911# VSS 0.35757f
C131 r12 VSS 1.16096f
C132 r13 VSS 0.47291f
C133 r14 VSS 0.46362f
C134 r15 VSS 0.46322f
C135 r16 VSS 0.46325f
C136 r17 VSS 0.46313f
C137 r18 VSS 0.46303f
C138 r19 VSS 0.468f
C139 r20 VSS 0.50755f
C140 r21 VSS 0.46568f
C141 r22 VSS 0.41309f
C142 VDD.n0 VSS 0.01964f
C143 VDD.t25 VSS 0.02718f
C144 VDD.n1 VSS 0.02735f
C145 VDD.t63 VSS 0.02771f
C146 VDD.t27 VSS 0.02771f
C147 VDD.t65 VSS 0.02718f
C148 VDD.t21 VSS 0.02718f
C149 VDD.n2 VSS 0.02735f
C150 VDD.t85 VSS 0.02771f
C151 VDD.t23 VSS 0.02771f
C152 VDD.n3 VSS 0.01442f
C153 VDD.t29 VSS 0.02756f
C154 VDD.n4 VSS 0.07018f
C155 VDD.t39 VSS 0.02756f
C156 VDD.n5 VSS 0.07018f
C157 VDD.n6 VSS 0.00284f
C158 VDD.n7 VSS 0.0301f
C159 VDD.t81 VSS 0.02718f
C160 VDD.t13 VSS 0.00695f
C161 VDD.t51 VSS 0.00695f
C162 VDD.n8 VSS 0.01492f
C163 VDD.t15 VSS 0.02772f
C164 VDD.n9 VSS 0.03864f
C165 VDD.t9 VSS 0.02718f
C166 VDD.t11 VSS 0.02771f
C167 VDD.n10 VSS 0.03487f
C168 VDD.t1 VSS 0.02718f
C169 VDD.t3 VSS 0.02771f
C170 VDD.n11 VSS 0.03377f
C171 VDD.n12 VSS 0.0301f
C172 VDD.t5 VSS 0.02765f
C173 VDD.t52 VSS 0.02771f
C174 VDD.t7 VSS 0.02771f
C175 VDD.n13 VSS 0.01658f
C176 VDD.t53 VSS 0.02765f
C177 VDD.t17 VSS 0.02765f
C178 VDD.n14 VSS 0.01964f
C179 VDD.t58 VSS 0.02771f
C180 VDD.t19 VSS 0.02771f
C181 VDD.t59 VSS 0.02765f
C182 VDD.n15 VSS 0.059f
C183 VDD.n16 VSS 0.0301f
C184 VDD.t41 VSS 0.02765f
C185 VDD.t60 VSS 0.02771f
C186 VDD.t43 VSS 0.02771f
C187 VDD.n17 VSS 0.01658f
C188 VDD.t61 VSS 0.02765f
C189 VDD.t67 VSS 0.02765f
C190 VDD.n18 VSS 0.01964f
C191 VDD.t82 VSS 0.02771f
C192 VDD.t69 VSS 0.02771f
C193 VDD.t83 VSS 0.02765f
C194 VDD.n19 VSS 0.05865f
C195 VDD.t45 VSS 0.02771f
C196 VDD.t31 VSS 0.02771f
C197 VDD.n20 VSS 0.01964f
C198 VDD.t47 VSS 0.02718f
C199 VDD.t33 VSS 0.02718f
C200 VDD.n21 VSS 0.02735f
C201 VDD.t75 VSS 0.02771f
C202 VDD.t35 VSS 0.02771f
C203 VDD.n22 VSS 0.01964f
C204 VDD.t77 VSS 0.02718f
C205 VDD.n23 VSS 0.0301f
C206 VDD.n24 VSS 0
C207 VDD.n25 VSS 0.02735f
C208 VDD.n26 VSS 0.03487f
C209 VDD.n27 VSS 0.03487f
C210 VDD.n28 VSS 0.01658f
C211 VDD.n29 VSS 0.0301f
C212 VDD.n30 VSS 0
C213 VDD.n31 VSS 0.02735f
C214 VDD.n32 VSS 0.03487f
C215 VDD.n33 VSS 0.03377f
C216 VDD.n34 VSS 0.01658f
C217 VDD.n35 VSS 0.01784f
C218 VDD.n36 VSS 0.01532f
C219 VDD.n37 VSS 0.0301f
C220 VDD.n38 VSS 0.00586f
C221 VDD.n39 VSS 0.059f
C222 VDD.n40 VSS 0.059f
C223 VDD.n41 VSS 0.00586f
C224 VDD.n42 VSS 0.059f
C225 VDD.n43 VSS 0.01964f
C226 VDD.n44 VSS 1.41445f
C227 VDD.n45 VSS 0.01135f
C228 VDD.n46 VSS 0.0301f
C229 VDD.n47 VSS 0.00586f
C230 VDD.n48 VSS 0.059f
C231 VDD.n49 VSS 0.059f
C232 VDD.n50 VSS 0.00586f
C233 VDD.n51 VSS 0.05865f
C234 VDD.n52 VSS 0.01964f
C235 VDD.n53 VSS 0.01874f
C236 VDD.n54 VSS 0.01442f
C237 VDD.n55 VSS 0.01658f
C238 VDD.t37 VSS 0.02771f
C239 VDD.n56 VSS 0.03487f
C240 VDD.n57 VSS 0.02735f
C241 VDD.t57 VSS 0.02718f
C242 VDD.n58 VSS 0.02735f
C243 VDD.n59 VSS 0
C244 VDD.n60 VSS 0.0301f
C245 VDD.n61 VSS 0.01964f
C246 VDD.n62 VSS 0.01658f
C247 VDD.t55 VSS 0.02771f
C248 VDD.n63 VSS 0.03487f
C249 VDD.n64 VSS 0.02735f
C250 VDD.t73 VSS 0.02718f
C251 VDD.n65 VSS 0.027f
C252 VDD.n66 VSS 0
C253 VDD.n67 VSS 0.0301f
C254 VDD.n68 VSS 0.01982f
C255 VDD.n69 VSS 0.0164f
C256 VDD.t71 VSS 0.02771f
C257 VDD.n70 VSS 0.03469f
C258 VDD.n71 VSS 0.01609f
C259 VDD.n72 VSS 0
C260 VDD.n73 VSS 0.02827f
C261 VDD.t49 VSS 0.02619f
C262 VDD.t79 VSS 0.02719f
C263 VDD.n74 VSS 0.02733f
C264 VDD.n75 VSS 0.02554f
C265 VDD.n76 VSS 0.00713f
C266 VDD.n77 VSS 0.03316f
C267 VDD.n78 VSS 0.01964f
C268 VDD.n79 VSS 0.01784f
C269 VDD.n80 VSS 0.19094f
C270 VDD.t78 VSS 0.06193f
C271 VDD.t48 VSS 0.0612f
C272 VDD.t80 VSS 0.0612f
C273 VDD.t50 VSS 0.07432f
C274 VDD.t12 VSS 0.07796f
C275 VDD.t14 VSS 0.04882f
C276 VDD.t70 VSS 0.02186f
C277 VDD.t72 VSS 0.11658f
C278 VDD.t8 VSS 0.09108f
C279 VDD.t10 VSS 0.04882f
C280 VDD.t54 VSS 0.02404f
C281 VDD.t56 VSS 0.11585f
C282 VDD.t0 VSS 0.09108f
C283 VDD.t2 VSS 0.04882f
C284 VDD.t36 VSS 0.02404f
C285 VDD.t38 VSS 0.07942f
C286 VDD.n81 VSS 0.10364f
C287 VDD.t4 VSS 0.11002f
C288 VDD.t6 VSS 0.08525f
C289 VDD.t16 VSS 0.11002f
C290 VDD.t18 VSS 0.08525f
C291 VDD.t40 VSS 0.11002f
C292 VDD.t42 VSS 0.08525f
C293 VDD.t66 VSS 0.11002f
C294 VDD.t68 VSS 0.08525f
C295 VDD.n82 VSS 0.12841f
C296 VDD.t28 VSS 0.05465f
C297 VDD.t30 VSS 0.04882f
C298 VDD.t44 VSS 0.02404f
C299 VDD.t46 VSS 0.11585f
C300 VDD.t32 VSS 0.09108f
C301 VDD.t34 VSS 0.04882f
C302 VDD.t74 VSS 0.02404f
C303 VDD.t76 VSS 0.11585f
C304 VDD.t24 VSS 0.09108f
C305 VDD.t26 VSS 0.04882f
C306 VDD.t62 VSS 0.02404f
C307 VDD.t64 VSS 0.11585f
C308 VDD.t20 VSS 0.09108f
C309 VDD.t22 VSS 0.04882f
C310 VDD.t84 VSS 0.02404f
C311 VDD.t86 VSS 0.19681f
C312 VDD.n83 VSS 0.20558f
C313 VDD.t87 VSS 0.02756f
C314 VDD.n84 VSS 0.01658f
C315 VDD.n85 VSS 0.06983f
C316 VDD.n86 VSS 0.03377f
C317 VDD.n87 VSS 0.03487f
C318 VDD.n88 VSS 0.01658f
C319 VDD.n89 VSS 0.0301f
C320 VDD.n90 VSS 0
C321 VDD.n91 VSS 0.02735f
C322 VDD.n92 VSS 0.03487f
C323 VDD.n93 VSS 0.03487f
C324 VDD.n94 VSS 0.01658f
C325 en.t2 VSS 0.03007f
C326 en.t0 VSS 0.05103f
C327 en.n0 VSS 0.06879f
C328 en.t3 VSS 0.03007f
C329 en.t1 VSS 0.05103f
C330 en.n1 VSS 0.06879f
C331 en.n2 VSS 0.03576f
C332 en.n3 VSS 0.13819f
C333 out.t3 VSS 0.01443f
C334 out.t0 VSS 0.01443f
C335 out.n0 VSS 0.03412f
C336 out.t4 VSS 0.0222f
C337 out.t5 VSS 0.0222f
C338 out.n1 VSS 0.06741f
C339 out.t2 VSS 0.0222f
C340 out.t1 VSS 0.0222f
C341 out.n2 VSS 0.04935f
C342 out.n3 VSS 0.21811f
C343 out.n4 VSS 0.02265f
C344 out.n5 VSS 0.04686f
C345 out.t9 VSS 0.03453f
C346 out.t7 VSS 0.02035f
C347 out.t8 VSS 0.03453f
C348 out.t6 VSS 0.02035f
C349 out.n6 VSS 0.05794f
C350 out.n7 VSS 0.08581f
C351 out.n8 VSS 0.03799f
C352 out.n9 VSS 0.35829f
C353 out.n10 VSS 0.0081f
C354 out.n11 VSS 0.17726f
.ends
