* tx_ring: magic R+C extraction of layout/tx_ring.gds (layout/pex.sh)
.subckt tx_ring en out VDD VSS
X0 VSS r12 r13 VSS sky130_fd_pr__nfet_01v8 ad=0.169 pd=1.82 as=0.08775 ps=0.92 w=0.65 l=0.15
X1 r16 r15 VSS VSS sky130_fd_pr__nfet_01v8 ad=0.08775 pd=0.92 as=0.169 ps=1.82 w=0.65 l=0.15
X2 a_6375_47# en.t0 out.t3 VSS sky130_fd_pr__nfet_01v8 ad=0.169 pd=1.82 as=0.08775 ps=0.92 w=0.65 l=0.15
X3 VDD.t11 r1 r2 VDD.t10 sky130_fd_pr__pfet_01v8_hvt ad=0.26 pd=2.52 as=0.135 ps=1.27 w=1 l=0.15
X4 r3 r2 VDD.t1 VDD.t0 sky130_fd_pr__pfet_01v8_hvt ad=0.135 pd=1.27 as=0.26 ps=2.52 w=1 l=0.15
X5 r4 r3 VDD.t5 VDD.t4 sky130_fd_pr__pfet_01v8_hvt ad=0.135 pd=1.27 as=0.26 ps=2.52 w=1 l=0.15
X6 VDD.t35 r8 r9 VDD.t34 sky130_fd_pr__pfet_01v8_hvt ad=0.26 pd=2.52 as=0.135 ps=1.27 w=1 l=0.15
X7 VDD.t95 r22 out.t5 VDD.t94 sky130_fd_pr__pfet_01v8_hvt ad=0.135 pd=1.27 as=0.135 ps=1.27 w=1 l=0.15
X8 r4 r3 VSS VSS sky130_fd_pr__nfet_01v8 ad=0.08775 pd=0.92 as=0.169 ps=1.82 w=0.65 l=0.15
X9 r7 r6 VSS VSS sky130_fd_pr__nfet_01v8 ad=0.08775 pd=0.92 as=0.169 ps=1.82 w=0.65 l=0.15
X10 VSS r17 r18 VSS sky130_fd_pr__nfet_01v8 ad=0.169 pd=1.82 as=0.08775 ps=0.92 w=0.65 l=0.15
X11 r10 r9 VDD.t25 VDD.t24 sky130_fd_pr__pfet_01v8_hvt ad=0.135 pd=1.27 as=0.26 ps=2.52 w=1 l=0.15
X12 VDD.t87 out.t8 r1 VDD.t86 sky130_fd_pr__pfet_01v8_hvt ad=0.26 pd=2.52 as=0.135 ps=1.27 w=1 l=0.15
X13 r2 r1 VDD.t9 VDD.t8 sky130_fd_pr__pfet_01v8_hvt ad=0.135 pd=1.27 as=0.26 ps=2.52 w=1 l=0.15
X14 r2 r1 VSS VSS sky130_fd_pr__nfet_01v8 ad=0.08775 pd=0.92 as=0.169 ps=1.82 w=0.65 l=0.15
X15 r3 r2 VSS VSS sky130_fd_pr__nfet_01v8 ad=0.08775 pd=0.92 as=0.169 ps=1.82 w=0.65 l=0.15
X16 r22 r21 VSS VSS sky130_fd_pr__nfet_01v8 ad=0.08775 pd=0.92 as=0.169 ps=1.82 w=0.65 l=0.15
X17 r9 r8 VDD.t33 VDD.t32 sky130_fd_pr__pfet_01v8_hvt ad=0.135 pd=1.27 as=0.26 ps=2.52 w=1 l=0.15
X18 VDD.t59 r13 r14 VDD.t58 sky130_fd_pr__pfet_01v8_hvt ad=0.26 pd=2.52 as=0.135 ps=1.27 w=1 l=0.15
X19 out.t4 r22 VDD.t93 VDD.t92 sky130_fd_pr__pfet_01v8_hvt ad=0.135 pd=1.27 as=0.26 ps=2.52 w=1 l=0.15
X20 VSS r8 r9 VSS sky130_fd_pr__nfet_01v8 ad=0.169 pd=1.82 as=0.08775 ps=0.92 w=0.65 l=0.15
X21 VSS r9 r10 VSS sky130_fd_pr__nfet_01v8 ad=0.169 pd=1.82 as=0.08775 ps=0.92 w=0.65 l=0.15
X22 r1 out.t9 VDD.t85 VDD.t84 sky130_fd_pr__pfet_01v8_hvt ad=0.135 pd=1.27 as=0.26 ps=2.52 w=1 l=0.15
X23 r8 r7 VDD.t29 VDD.t28 sky130_fd_pr__pfet_01v8_hvt ad=0.135 pd=1.27 as=0.26 ps=2.52 w=1 l=0.15
X24 VDD.t79 r12 r13 VDD.t78 sky130_fd_pr__pfet_01v8_hvt ad=0.26 pd=2.52 as=0.135 ps=1.27 w=1 l=0.15
X25 r14 r13 VDD.t57 VDD.t56 sky130_fd_pr__pfet_01v8_hvt ad=0.135 pd=1.27 as=0.26 ps=2.52 w=1 l=0.15
X26 r13 r12 VSS VSS sky130_fd_pr__nfet_01v8 ad=0.08775 pd=0.92 as=0.169 ps=1.82 w=0.65 l=0.15
X27 r14 r13 VSS VSS sky130_fd_pr__nfet_01v8 ad=0.08775 pd=0.92 as=0.169 ps=1.82 w=0.65 l=0.15
X28 r20 r19 VDD.t45 VDD.t44 sky130_fd_pr__pfet_01v8_hvt ad=0.135 pd=1.27 as=0.26 ps=2.52 w=1 l=0.15
X29 VDD.t91 r18 r19 VDD.t90 sky130_fd_pr__pfet_01v8_hvt ad=0.26 pd=2.52 as=0.135 ps=1.27 w=1 l=0.15
X30 VSS r15 r16 VSS sky130_fd_pr__nfet_01v8 ad=0.169 pd=1.82 as=0.08775 ps=0.92 w=0.65 l=0.15
X31 r18 r17 VSS VSS sky130_fd_pr__nfet_01v8 ad=0.08775 pd=0.92 as=0.169 ps=1.82 w=0.65 l=0.15
X32 VDD.t19 r11 r12 VDD.t18 sky130_fd_pr__pfet_01v8_hvt ad=0.26 pd=2.52 as=0.135 ps=1.27 w=1 l=0.15
X33 r13 r12 VDD.t77 VDD.t76 sky130_fd_pr__pfet_01v8_hvt ad=0.135 pd=1.27 as=0.26 ps=2.52 w=1 l=0.15
X34 r19 r18 VSS VSS sky130_fd_pr__nfet_01v8 ad=0.08775 pd=0.92 as=0.169 ps=1.82 w=0.65 l=0.15
X35 r20 r19 VSS VSS sky130_fd_pr__nfet_01v8 ad=0.08775 pd=0.92 as=0.169 ps=1.82 w=0.65 l=0.15
X36 VDD.t67 r17 r18 VDD.t66 sky130_fd_pr__pfet_01v8_hvt ad=0.26 pd=2.52 as=0.135 ps=1.27 w=1 l=0.15
X37 r19 r18 VDD.t89 VDD.t88 sky130_fd_pr__pfet_01v8_hvt ad=0.135 pd=1.27 as=0.26 ps=2.52 w=1 l=0.15
X38 VSS r3 r4 VSS sky130_fd_pr__nfet_01v8 ad=0.169 pd=1.82 as=0.08775 ps=0.92 w=0.65 l=0.15
X39 VSS r4 r5 VSS sky130_fd_pr__nfet_01v8 ad=0.169 pd=1.82 as=0.08775 ps=0.92 w=0.65 l=0.15
X40 r8 r7 VSS VSS sky130_fd_pr__nfet_01v8 ad=0.08775 pd=0.92 as=0.169 ps=1.82 w=0.65 l=0.15
X41 VSS r2 r3 VSS sky130_fd_pr__nfet_01v8 ad=0.169 pd=1.82 as=0.08775 ps=0.92 w=0.65 l=0.15
X42 r10 r9 VSS VSS sky130_fd_pr__nfet_01v8 ad=0.08775 pd=0.92 as=0.169 ps=1.82 w=0.65 l=0.15
X43 VSS r21 r22 VSS sky130_fd_pr__nfet_01v8 ad=0.169 pd=1.82 as=0.08775 ps=0.92 w=0.65 l=0.15
X44 VDD.t75 r6 r7 VDD.t74 sky130_fd_pr__pfet_01v8_hvt ad=0.26 pd=2.52 as=0.135 ps=1.27 w=1 l=0.15
X45 VDD.t55 r15 r16 VDD.t54 sky130_fd_pr__pfet_01v8_hvt ad=0.26 pd=2.52 as=0.135 ps=1.27 w=1 l=0.15
X46 r18 r17 VDD.t65 VDD.t64 sky130_fd_pr__pfet_01v8_hvt ad=0.135 pd=1.27 as=0.26 ps=2.52 w=1 l=0.15
X47 VSS r13 r14 VSS sky130_fd_pr__nfet_01v8 ad=0.169 pd=1.82 as=0.08775 ps=0.92 w=0.65 l=0.15
X48 a_6375_47# r22 VSS VSS sky130_fd_pr__nfet_01v8 ad=0.08775 pd=0.92 as=0.08775 ps=0.92 w=0.65 l=0.15
X49 VDD.t71 r21 r22 VDD.t70 sky130_fd_pr__pfet_01v8_hvt ad=0.26 pd=2.52 as=0.135 ps=1.27 w=1 l=0.15
X50 VDD.t43 r5 r6 VDD.t42 sky130_fd_pr__pfet_01v8_hvt ad=0.26 pd=2.52 as=0.135 ps=1.27 w=1 l=0.15
X51 r7 r6 VDD.t73 VDD.t72 sky130_fd_pr__pfet_01v8_hvt ad=0.135 pd=1.27 as=0.26 ps=2.52 w=1 l=0.15
X52 r17 r16 VSS VSS sky130_fd_pr__nfet_01v8 ad=0.08775 pd=0.92 as=0.169 ps=1.82 w=0.65 l=0.15
X53 VSS r18 r19 VSS sky130_fd_pr__nfet_01v8 ad=0.169 pd=1.82 as=0.08775 ps=0.92 w=0.65 l=0.15
X54 r5 r4 VSS VSS sky130_fd_pr__nfet_01v8 ad=0.08775 pd=0.92 as=0.169 ps=1.82 w=0.65 l=0.15
X55 VDD.t15 r4 r5 VDD.t14 sky130_fd_pr__pfet_01v8_hvt ad=0.26 pd=2.52 as=0.135 ps=1.27 w=1 l=0.15
X56 r6 r5 VDD.t41 VDD.t40 sky130_fd_pr__pfet_01v8_hvt ad=0.135 pd=1.27 as=0.26 ps=2.52 w=1 l=0.15
X57 r22 r21 VDD.t69 VDD.t68 sky130_fd_pr__pfet_01v8_hvt ad=0.135 pd=1.27 as=0.26 ps=2.52 w=1 l=0.15
X58 r6 r5 VSS VSS sky130_fd_pr__nfet_01v8 ad=0.08775 pd=0.92 as=0.169 ps=1.82 w=0.65 l=0.15
X59 VSS r19 r20 VSS sky130_fd_pr__nfet_01v8 ad=0.169 pd=1.82 as=0.08775 ps=0.92 w=0.65 l=0.15
X60 r12 r11 VDD.t17 VDD.t16 sky130_fd_pr__pfet_01v8_hvt ad=0.135 pd=1.27 as=0.26 ps=2.52 w=1 l=0.15
X61 r1 out.t7 VSS VSS sky130_fd_pr__nfet_01v8 ad=0.08775 pd=0.92 as=0.169 ps=1.82 w=0.65 l=0.15
X62 VSS r7 r8 VSS sky130_fd_pr__nfet_01v8 ad=0.169 pd=1.82 as=0.08775 ps=0.92 w=0.65 l=0.15
X63 VSS r20 r21 VSS sky130_fd_pr__nfet_01v8 ad=0.169 pd=1.82 as=0.08775 ps=0.92 w=0.65 l=0.15
X64 VDD.t23 r10 r11 VDD.t22 sky130_fd_pr__pfet_01v8_hvt ad=0.26 pd=2.52 as=0.135 ps=1.27 w=1 l=0.15
X65 VDD.t51 en.t2 out.t0 VDD.t50 sky130_fd_pr__pfet_01v8_hvt ad=0.26 pd=2.52 as=0.135 ps=1.27 w=1 l=0.15
X66 r11 r10 VSS VSS sky130_fd_pr__nfet_01v8 ad=0.08775 pd=0.92 as=0.169 ps=1.82 w=0.65 l=0.15
X67 VDD.t7 r3 r4 VDD.t6 sky130_fd_pr__pfet_01v8_hvt ad=0.26 pd=2.52 as=0.135 ps=1.27 w=1 l=0.15
X68 r5 r4 VDD.t13 VDD.t12 sky130_fd_pr__pfet_01v8_hvt ad=0.135 pd=1.27 as=0.26 ps=2.52 w=1 l=0.15
X69 VDD.t63 r16 r17 VDD.t62 sky130_fd_pr__pfet_01v8_hvt ad=0.26 pd=2.52 as=0.135 ps=1.27 w=1 l=0.15
X70 r12 r11 VSS VSS sky130_fd_pr__nfet_01v8 ad=0.08775 pd=0.92 as=0.169 ps=1.82 w=0.65 l=0.15
X71 VSS r22 a_6375_47# VSS sky130_fd_pr__nfet_01v8 ad=0.08775 pd=0.92 as=0.169 ps=1.82 w=0.65 l=0.15
X72 out.t1 en.t3 VDD.t49 VDD.t48 sky130_fd_pr__pfet_01v8_hvt ad=0.135 pd=1.27 as=0.135 ps=1.27 w=1 l=0.15
X73 r11 r10 VDD.t21 VDD.t20 sky130_fd_pr__pfet_01v8_hvt ad=0.135 pd=1.27 as=0.26 ps=2.52 w=1 l=0.15
X74 r17 r16 VDD.t61 VDD.t60 sky130_fd_pr__pfet_01v8_hvt ad=0.135 pd=1.27 as=0.26 ps=2.52 w=1 l=0.15
X75 VSS r14 r15 VSS sky130_fd_pr__nfet_01v8 ad=0.169 pd=1.82 as=0.08775 ps=0.92 w=0.65 l=0.15
X76 out.t2 en.t1 a_6375_47# VSS sky130_fd_pr__nfet_01v8 ad=0.08775 pd=0.92 as=0.08775 ps=0.92 w=0.65 l=0.15
X77 VDD.t39 r14 r15 VDD.t38 sky130_fd_pr__pfet_01v8_hvt ad=0.26 pd=2.52 as=0.135 ps=1.27 w=1 l=0.15
X78 VSS r16 r17 VSS sky130_fd_pr__nfet_01v8 ad=0.169 pd=1.82 as=0.08775 ps=0.92 w=0.65 l=0.15
X79 r16 r15 VDD.t53 VDD.t52 sky130_fd_pr__pfet_01v8_hvt ad=0.135 pd=1.27 as=0.26 ps=2.52 w=1 l=0.15
X80 VDD.t83 r20 r21 VDD.t82 sky130_fd_pr__pfet_01v8_hvt ad=0.26 pd=2.52 as=0.135 ps=1.27 w=1 l=0.15
X81 VSS r5 r6 VSS sky130_fd_pr__nfet_01v8 ad=0.169 pd=1.82 as=0.08775 ps=0.92 w=0.65 l=0.15
X82 VSS r6 r7 VSS sky130_fd_pr__nfet_01v8 ad=0.169 pd=1.82 as=0.08775 ps=0.92 w=0.65 l=0.15
X83 r21 r20 VSS VSS sky130_fd_pr__nfet_01v8 ad=0.08775 pd=0.92 as=0.169 ps=1.82 w=0.65 l=0.15
X84 VDD.t31 r7 r8 VDD.t30 sky130_fd_pr__pfet_01v8_hvt ad=0.26 pd=2.52 as=0.135 ps=1.27 w=1 l=0.15
X85 VSS out.t6 r1 VSS sky130_fd_pr__nfet_01v8 ad=0.169 pd=1.82 as=0.08775 ps=0.92 w=0.65 l=0.15
X86 r15 r14 VDD.t37 VDD.t36 sky130_fd_pr__pfet_01v8_hvt ad=0.135 pd=1.27 as=0.26 ps=2.52 w=1 l=0.15
X87 VDD.t47 r19 r20 VDD.t46 sky130_fd_pr__pfet_01v8_hvt ad=0.26 pd=2.52 as=0.135 ps=1.27 w=1 l=0.15
X88 VSS r1 r2 VSS sky130_fd_pr__nfet_01v8 ad=0.169 pd=1.82 as=0.08775 ps=0.92 w=0.65 l=0.15
X89 r9 r8 VSS VSS sky130_fd_pr__nfet_01v8 ad=0.08775 pd=0.92 as=0.169 ps=1.82 w=0.65 l=0.15
X90 VSS r10 r11 VSS sky130_fd_pr__nfet_01v8 ad=0.169 pd=1.82 as=0.08775 ps=0.92 w=0.65 l=0.15
X91 r21 r20 VDD.t81 VDD.t80 sky130_fd_pr__pfet_01v8_hvt ad=0.135 pd=1.27 as=0.26 ps=2.52 w=1 l=0.15
X92 VDD.t3 r2 r3 VDD.t2 sky130_fd_pr__pfet_01v8_hvt ad=0.26 pd=2.52 as=0.135 ps=1.27 w=1 l=0.15
X93 VDD.t27 r9 r10 VDD.t26 sky130_fd_pr__pfet_01v8_hvt ad=0.26 pd=2.52 as=0.135 ps=1.27 w=1 l=0.15
X94 VSS r11 r12 VSS sky130_fd_pr__nfet_01v8 ad=0.169 pd=1.82 as=0.08775 ps=0.92 w=0.65 l=0.15
X95 r15 r14 VSS VSS sky130_fd_pr__nfet_01v8 ad=0.08775 pd=0.92 as=0.169 ps=1.82 w=0.65 l=0.15
R0 en.n0 en.t2 212.081
R1 en.n1 en.t3 212.081
R2 en en.n2 152.512
R3 en.n0 en.t0 139.78
R4 en.n1 en.t1 139.78
R5 en.n2 en.n0 30.6732
R6 en.n2 en.n1 30.6732
R7 out.n5 out.n3 243.68
R8 out.n0 out.t8 212.081
R9 out.n1 out.t9 212.081
R10 out.n7 out.n6 206.249
R11 out.n5 out.n4 205.28
R12 out.n2 out.n1 184.721
R13 out.n0 out.t6 139.78
R14 out.n1 out.t7 139.78
R15 out.n1 out.n0 61.346
R16 out.n3 out.t5 26.5955
R17 out.n3 out.t4 26.5955
R18 out.n4 out.t0 26.5955
R19 out.n4 out.t1 26.5955
R20 out out.n5 24.9955
R21 out.n6 out.t3 24.9236
R22 out.n6 out.t2 24.9236
R23 out out.n7 14.8576
R24 out out.n2 14.0913
R25 out.n9 out.n8 13.9858
R26 out.n9 out 12.8345
R27 out.n8 out 11.6576
R28 out.n2 out 4.3525
R29 out.n8 out 3.88621
R30 out out.n9 3.56877
R31 out.n7 out 0.686214
R32 VDD.t50 VDD.n66 686.639
R33 VDD.n151 VDD 435.082
R34 VDD.n67 VDD.t54 420.25
R35 VDD.t30 VDD.n150 420.25
R36 VDD.t70 VDD 372.897
R37 VDD.t82 VDD 369.938
R38 VDD.t46 VDD 369.938
R39 VDD.t90 VDD 369.938
R40 VDD.t66 VDD 369.938
R41 VDD.t62 VDD 369.938
R42 VDD VDD.t38 369.938
R43 VDD VDD.t58 369.938
R44 VDD VDD.t78 369.938
R45 VDD VDD.t18 369.938
R46 VDD VDD.t22 369.938
R47 VDD VDD.t26 369.938
R48 VDD VDD.t34 369.938
R49 VDD.t74 VDD 369.938
R50 VDD.t42 VDD 369.938
R51 VDD.t14 VDD 369.938
R52 VDD.t6 VDD 369.938
R53 VDD.t2 VDD 369.938
R54 VDD.t10 VDD 369.938
R55 VDD.t86 VDD 369.938
R56 VDD.n19 VDD.t51 342.377
R57 VDD.n61 VDD.n21 320.976
R58 VDD.n113 VDD.t87 255.905
R59 VDD.n118 VDD.t11 255.905
R60 VDD.n123 VDD.t3 255.905
R61 VDD.n128 VDD.t7 255.905
R62 VDD.n133 VDD.t15 255.905
R63 VDD.n138 VDD.t43 255.905
R64 VDD.n143 VDD.t75 255.905
R65 VDD.n1 VDD.t31 255.905
R66 VDD.n98 VDD.t35 255.905
R67 VDD.n5 VDD.t27 255.905
R68 VDD.n90 VDD.t23 255.905
R69 VDD.n9 VDD.t19 255.905
R70 VDD.n82 VDD.t79 255.905
R71 VDD.n13 VDD.t59 255.905
R72 VDD.n74 VDD.t39 255.905
R73 VDD.n17 VDD.t55 255.905
R74 VDD.n33 VDD.t63 255.905
R75 VDD.n38 VDD.t67 255.905
R76 VDD.n43 VDD.t91 255.905
R77 VDD.n48 VDD.t47 255.905
R78 VDD.n24 VDD.t83 255.905
R79 VDD.n56 VDD.t71 255.905
R80 VDD.n114 VDD.t9 252.95
R81 VDD.n119 VDD.t1 252.95
R82 VDD.n124 VDD.t5 252.95
R83 VDD.n129 VDD.t13 252.95
R84 VDD.n134 VDD.t41 252.95
R85 VDD.n139 VDD.t73 252.95
R86 VDD.n144 VDD.t29 252.95
R87 VDD.n2 VDD.t33 252.95
R88 VDD.n97 VDD.t25 252.95
R89 VDD.n92 VDD.t21 252.95
R90 VDD.n89 VDD.t17 252.95
R91 VDD.n84 VDD.t77 252.95
R92 VDD.n81 VDD.t57 252.95
R93 VDD.n76 VDD.t37 252.95
R94 VDD.n73 VDD.t53 252.95
R95 VDD.n18 VDD.t61 252.95
R96 VDD.n34 VDD.t65 252.95
R97 VDD.n39 VDD.t89 252.95
R98 VDD.n44 VDD.t45 252.95
R99 VDD.n49 VDD.t81 252.95
R100 VDD.n54 VDD.t69 252.95
R101 VDD.n0 VDD.t85 252.948
R102 VDD.n22 VDD.t93 249.363
R103 VDD.t48 VDD.t50 248.599
R104 VDD.t94 VDD.t48 248.599
R105 VDD.t92 VDD.t94 248.599
R106 VDD.t68 VDD.t70 248.599
R107 VDD.t80 VDD.t82 248.599
R108 VDD.t44 VDD.t46 248.599
R109 VDD.t88 VDD.t90 248.599
R110 VDD.t64 VDD.t66 248.599
R111 VDD.t60 VDD.t62 248.599
R112 VDD.t54 VDD.t52 248.599
R113 VDD.t38 VDD.t36 248.599
R114 VDD.t58 VDD.t56 248.599
R115 VDD.t78 VDD.t76 248.599
R116 VDD.t18 VDD.t16 248.599
R117 VDD.t22 VDD.t20 248.599
R118 VDD.t26 VDD.t24 248.599
R119 VDD.t34 VDD.t32 248.599
R120 VDD.t28 VDD.t30 248.599
R121 VDD.t72 VDD.t74 248.599
R122 VDD.t40 VDD.t42 248.599
R123 VDD.t12 VDD.t14 248.599
R124 VDD.t4 VDD.t6 248.599
R125 VDD.t0 VDD.t2 248.599
R126 VDD.t8 VDD.t10 248.599
R127 VDD.t84 VDD.t86 248.599
R128 VDD.n67 VDD 221.964
R129 VDD.n150 VDD 221.964
R130 VDD.n150 VDD.n149 213.119
R131 VDD.n68 VDD.n67 213.119
R132 VDD VDD.t68 198.287
R133 VDD VDD.t80 198.287
R134 VDD VDD.t44 198.287
R135 VDD VDD.t88 198.287
R136 VDD VDD.t64 198.287
R137 VDD VDD.t60 198.287
R138 VDD.t52 VDD 198.287
R139 VDD.t36 VDD 198.287
R140 VDD.t56 VDD 198.287
R141 VDD.t76 VDD 198.287
R142 VDD.t16 VDD 198.287
R143 VDD.t20 VDD 198.287
R144 VDD.t24 VDD 198.287
R145 VDD.t32 VDD 198.287
R146 VDD VDD.t28 198.287
R147 VDD VDD.t72 198.287
R148 VDD VDD.t40 198.287
R149 VDD VDD.t12 198.287
R150 VDD VDD.t4 198.287
R151 VDD VDD.t0 198.287
R152 VDD VDD.t8 198.287
R153 VDD VDD.t84 198.287
R154 VDD VDD.t92 189.409
R155 VDD.n63 VDD.n62 34.6358
R156 VDD.n61 VDD.n60 30.8711
R157 VDD.n21 VDD.t49 26.5955
R158 VDD.n21 VDD.t95 26.5955
R159 VDD.n60 VDD.n22 25.977
R160 VDD.n113 VDD.n109 25.224
R161 VDD.n109 VDD.n0 25.224
R162 VDD.n118 VDD.n108 25.224
R163 VDD.n114 VDD.n108 25.224
R164 VDD.n123 VDD.n107 25.224
R165 VDD.n119 VDD.n107 25.224
R166 VDD.n128 VDD.n106 25.224
R167 VDD.n124 VDD.n106 25.224
R168 VDD.n133 VDD.n105 25.224
R169 VDD.n129 VDD.n105 25.224
R170 VDD.n138 VDD.n104 25.224
R171 VDD.n134 VDD.n104 25.224
R172 VDD.n143 VDD.n103 25.224
R173 VDD.n139 VDD.n103 25.224
R174 VDD.n145 VDD.n1 25.224
R175 VDD.n145 VDD.n144 25.224
R176 VDD.n99 VDD.n98 25.224
R177 VDD.n99 VDD.n2 25.224
R178 VDD.n96 VDD.n5 25.224
R179 VDD.n97 VDD.n96 25.224
R180 VDD.n91 VDD.n90 25.224
R181 VDD.n92 VDD.n91 25.224
R182 VDD.n88 VDD.n9 25.224
R183 VDD.n89 VDD.n88 25.224
R184 VDD.n83 VDD.n82 25.224
R185 VDD.n84 VDD.n83 25.224
R186 VDD.n80 VDD.n13 25.224
R187 VDD.n81 VDD.n80 25.224
R188 VDD.n75 VDD.n74 25.224
R189 VDD.n76 VDD.n75 25.224
R190 VDD.n72 VDD.n17 25.224
R191 VDD.n73 VDD.n72 25.224
R192 VDD.n33 VDD.n29 25.224
R193 VDD.n29 VDD.n18 25.224
R194 VDD.n38 VDD.n28 25.224
R195 VDD.n34 VDD.n28 25.224
R196 VDD.n43 VDD.n27 25.224
R197 VDD.n39 VDD.n27 25.224
R198 VDD.n48 VDD.n26 25.224
R199 VDD.n44 VDD.n26 25.224
R200 VDD.n50 VDD.n24 25.224
R201 VDD.n50 VDD.n49 25.224
R202 VDD.n56 VDD.n55 25.224
R203 VDD.n55 VDD.n54 25.224
R204 VDD.n66 VDD.n19 20.7064
R205 VDD.n114 VDD.n113 20.3299
R206 VDD.n119 VDD.n118 20.3299
R207 VDD.n124 VDD.n123 20.3299
R208 VDD.n129 VDD.n128 20.3299
R209 VDD.n134 VDD.n133 20.3299
R210 VDD.n139 VDD.n138 20.3299
R211 VDD.n144 VDD.n143 20.3299
R212 VDD.n98 VDD.n97 20.3299
R213 VDD.n92 VDD.n5 20.3299
R214 VDD.n90 VDD.n89 20.3299
R215 VDD.n84 VDD.n9 20.3299
R216 VDD.n82 VDD.n81 20.3299
R217 VDD.n76 VDD.n13 20.3299
R218 VDD.n74 VDD.n73 20.3299
R219 VDD.n34 VDD.n33 20.3299
R220 VDD.n39 VDD.n38 20.3299
R221 VDD.n44 VDD.n43 20.3299
R222 VDD.n49 VDD.n48 20.3299
R223 VDD.n54 VDD.n24 20.3299
R224 VDD.n63 VDD.n19 18.4476
R225 VDD.n149 VDD.n1 17.3181
R226 VDD.n68 VDD.n17 17.3181
R227 VDD.n56 VDD.n22 17.3181
R228 VDD.n151 VDD.n0 15.8123
R229 VDD.n149 VDD.n2 15.8123
R230 VDD.n68 VDD.n18 15.8123
R231 VDD.n66 VDD 9.3155
R232 VDD.n65 VDD.n19 9.3005
R233 VDD.n64 VDD.n63 9.3005
R234 VDD.n62 VDD.n20 9.3005
R235 VDD.n60 VDD.n59 9.3005
R236 VDD.n58 VDD.n22 9.3005
R237 VDD.n57 VDD.n56 9.3005
R238 VDD.n55 VDD.n23 9.3005
R239 VDD.n54 VDD.n53 9.3005
R240 VDD.n52 VDD.n24 9.3005
R241 VDD.n51 VDD.n50 9.3005
R242 VDD.n49 VDD.n25 9.3005
R243 VDD.n48 VDD.n47 9.3005
R244 VDD.n46 VDD.n26 9.3005
R245 VDD.n45 VDD.n44 9.3005
R246 VDD.n43 VDD.n42 9.3005
R247 VDD.n41 VDD.n27 9.3005
R248 VDD.n40 VDD.n39 9.3005
R249 VDD.n38 VDD.n37 9.3005
R250 VDD.n36 VDD.n28 9.3005
R251 VDD.n35 VDD.n34 9.3005
R252 VDD.n33 VDD.n32 9.3005
R253 VDD.n31 VDD.n29 9.3005
R254 VDD.n30 VDD.n18 9.3005
R255 VDD.n69 VDD.n68 9.3005
R256 VDD.n70 VDD.n17 9.3005
R257 VDD.n72 VDD.n71 9.3005
R258 VDD.n73 VDD.n16 9.3005
R259 VDD.n74 VDD.n15 9.3005
R260 VDD.n75 VDD.n14 9.3005
R261 VDD.n77 VDD.n76 9.3005
R262 VDD.n78 VDD.n13 9.3005
R263 VDD.n80 VDD.n79 9.3005
R264 VDD.n81 VDD.n12 9.3005
R265 VDD.n82 VDD.n11 9.3005
R266 VDD.n83 VDD.n10 9.3005
R267 VDD.n85 VDD.n84 9.3005
R268 VDD.n86 VDD.n9 9.3005
R269 VDD.n88 VDD.n87 9.3005
R270 VDD.n89 VDD.n8 9.3005
R271 VDD.n90 VDD.n7 9.3005
R272 VDD.n91 VDD.n6 9.3005
R273 VDD.n93 VDD.n92 9.3005
R274 VDD.n94 VDD.n5 9.3005
R275 VDD.n96 VDD.n95 9.3005
R276 VDD.n97 VDD.n4 9.3005
R277 VDD.n98 VDD.n3 9.3005
R278 VDD.n100 VDD.n99 9.3005
R279 VDD.n101 VDD.n2 9.3005
R280 VDD.n149 VDD.n148 9.3005
R281 VDD.n147 VDD.n1 9.3005
R282 VDD.n146 VDD.n145 9.3005
R283 VDD.n144 VDD.n102 9.3005
R284 VDD.n143 VDD.n142 9.3005
R285 VDD.n141 VDD.n103 9.3005
R286 VDD.n140 VDD.n139 9.3005
R287 VDD.n138 VDD.n137 9.3005
R288 VDD.n136 VDD.n104 9.3005
R289 VDD.n135 VDD.n134 9.3005
R290 VDD.n133 VDD.n132 9.3005
R291 VDD.n131 VDD.n105 9.3005
R292 VDD.n130 VDD.n129 9.3005
R293 VDD.n128 VDD.n127 9.3005
R294 VDD.n126 VDD.n106 9.3005
R295 VDD.n125 VDD.n124 9.3005
R296 VDD.n123 VDD.n122 9.3005
R297 VDD.n121 VDD.n107 9.3005
R298 VDD.n120 VDD.n119 9.3005
R299 VDD.n118 VDD.n117 9.3005
R300 VDD.n116 VDD.n108 9.3005
R301 VDD.n115 VDD.n114 9.3005
R302 VDD.n113 VDD.n112 9.3005
R303 VDD.n111 VDD.n109 9.3005
R304 VDD.n110 VDD.n0 9.3005
R305 VDD.n152 VDD.n151 9.3005
R306 VDD.n62 VDD.n61 3.76521
R307 VDD.n86 VDD 0.845094
R308 VDD.n65 VDD.n64 0.058
R309 VDD.n64 VDD.n20 0.058
R310 VDD.n59 VDD.n20 0.058
R311 VDD.n59 VDD.n58 0.058
R312 VDD.n57 VDD.n23 0.058
R313 VDD.n53 VDD.n23 0.058
R314 VDD.n52 VDD.n51 0.058
R315 VDD.n51 VDD.n25 0.058
R316 VDD.n47 VDD.n46 0.058
R317 VDD.n46 VDD.n45 0.058
R318 VDD.n42 VDD.n41 0.058
R319 VDD.n41 VDD.n40 0.058
R320 VDD.n37 VDD.n36 0.058
R321 VDD.n36 VDD.n35 0.058
R322 VDD.n32 VDD.n31 0.058
R323 VDD.n31 VDD.n30 0.058
R324 VDD.n71 VDD.n70 0.058
R325 VDD.n71 VDD.n16 0.058
R326 VDD.n15 VDD.n14 0.058
R327 VDD.n77 VDD.n14 0.058
R328 VDD.n79 VDD.n78 0.058
R329 VDD.n79 VDD.n12 0.058
R330 VDD.n11 VDD.n10 0.058
R331 VDD.n85 VDD.n10 0.058
R332 VDD.n87 VDD.n86 0.058
R333 VDD.n87 VDD.n8 0.058
R334 VDD.n7 VDD.n6 0.058
R335 VDD.n93 VDD.n6 0.058
R336 VDD.n95 VDD.n94 0.058
R337 VDD.n95 VDD.n4 0.058
R338 VDD.n100 VDD.n3 0.058
R339 VDD.n101 VDD.n100 0.058
R340 VDD.n147 VDD.n146 0.058
R341 VDD.n146 VDD.n102 0.058
R342 VDD.n142 VDD.n141 0.058
R343 VDD.n141 VDD.n140 0.058
R344 VDD.n137 VDD.n136 0.058
R345 VDD.n136 VDD.n135 0.058
R346 VDD.n132 VDD.n131 0.058
R347 VDD.n131 VDD.n130 0.058
R348 VDD.n127 VDD.n126 0.058
R349 VDD.n126 VDD.n125 0.058
R350 VDD.n122 VDD.n121 0.058
R351 VDD.n121 VDD.n120 0.058
R352 VDD.n117 VDD.n116 0.058
R353 VDD.n116 VDD.n115 0.058
R354 VDD.n112 VDD.n111 0.058
R355 VDD.n111 VDD.n110 0.058
R356 VDD VDD.n57 0.048
R357 VDD VDD.n52 0.047375
R358 VDD.n47 VDD 0.047375
R359 VDD.n42 VDD 0.047375
R360 VDD.n37 VDD 0.047375
R361 VDD.n32 VDD 0.047375
R362 VDD.n69 VDD 0.047375
R363 VDD VDD.n15 0.047375
R364 VDD.n78 VDD 0.047375
R365 VDD VDD.n11 0.047375
R366 VDD.n86 VDD 0.047375
R367 VDD VDD.n7 0.047375
R368 VDD.n94 VDD 0.047375
R369 VDD VDD.n3 0.047375
R370 VDD.n148 VDD 0.047375
R371 VDD.n142 VDD 0.047375
R372 VDD.n137 VDD 0.047375
R373 VDD.n132 VDD 0.047375
R374 VDD.n127 VDD 0.047375
R375 VDD.n122 VDD 0.047375
R376 VDD.n117 VDD 0.047375
R377 VDD.n112 VDD 0.047375
R378 VDD.n152 VDD 0.047375
R379 VDD VDD.n65 0.043
R380 VDD.n70 VDD 0.043
R381 VDD VDD.n147 0.043
R382 VDD VDD.n69 0.0155
R383 VDD.n148 VDD 0.0155
R384 VDD VDD.n152 0.0155
R385 VDD.n53 VDD 0.011125
R386 VDD VDD.n25 0.011125
R387 VDD.n45 VDD 0.011125
R388 VDD.n40 VDD 0.011125
R389 VDD.n35 VDD 0.011125
R390 VDD.n30 VDD 0.011125
R391 VDD.n16 VDD 0.011125
R392 VDD VDD.n77 0.011125
R393 VDD.n12 VDD 0.011125
R394 VDD VDD.n85 0.011125
R395 VDD.n8 VDD 0.011125
R396 VDD VDD.n93 0.011125
R397 VDD.n4 VDD 0.011125
R398 VDD VDD.n101 0.011125
R399 VDD VDD.n102 0.011125
R400 VDD.n140 VDD 0.011125
R401 VDD.n135 VDD 0.011125
R402 VDD.n130 VDD 0.011125
R403 VDD.n125 VDD 0.011125
R404 VDD.n120 VDD 0.011125
R405 VDD.n115 VDD 0.011125
R406 VDD.n110 VDD 0.011125
R407 VDD.n58 VDD 0.0105
R408 VSS VSS.n0 6269.44
R409 VSS VSS.n10 3121.55
R410 VSS VSS.n20 3121.55
R411 VSS.n36 VSS 1997.28
R412 VSS.n71 VSS.n20 1198.25
R413 VSS.n112 VSS.n10 1198.25
R414 VSS.n10 VSS 799.032
R415 VSS.n20 VSS 799.032
R416 VSS.n149 VSS.n148 34.6358
R417 VSS.n148 VSS.n147 34.6358
R418 VSS.n147 VSS.n2 34.6358
R419 VSS.n143 VSS.n2 34.6358
R420 VSS.n143 VSS.n142 28.2358
R421 VSS.n76 VSS.n18 25.224
R422 VSS.n72 VSS.n18 25.224
R423 VSS.n81 VSS.n17 25.224
R424 VSS.n77 VSS.n17 25.224
R425 VSS.n86 VSS.n16 25.224
R426 VSS.n82 VSS.n16 25.224
R427 VSS.n91 VSS.n15 25.224
R428 VSS.n87 VSS.n15 25.224
R429 VSS.n96 VSS.n14 25.224
R430 VSS.n92 VSS.n14 25.224
R431 VSS.n101 VSS.n13 25.224
R432 VSS.n97 VSS.n13 25.224
R433 VSS.n106 VSS.n12 25.224
R434 VSS.n102 VSS.n12 25.224
R435 VSS.n108 VSS.n9 25.224
R436 VSS.n108 VSS.n107 25.224
R437 VSS.n117 VSS.n8 25.224
R438 VSS.n113 VSS.n8 25.224
R439 VSS.n122 VSS.n7 25.224
R440 VSS.n118 VSS.n7 25.224
R441 VSS.n127 VSS.n6 25.224
R442 VSS.n123 VSS.n6 25.224
R443 VSS.n132 VSS.n5 25.224
R444 VSS.n128 VSS.n5 25.224
R445 VSS.n137 VSS.n4 25.224
R446 VSS.n133 VSS.n4 25.224
R447 VSS.n142 VSS.n3 25.224
R448 VSS.n138 VSS.n3 25.224
R449 VSS.n67 VSS.n19 25.224
R450 VSS.n67 VSS.n66 25.224
R451 VSS.n65 VSS.n64 25.224
R452 VSS.n64 VSS.n23 25.224
R453 VSS.n60 VSS.n59 25.224
R454 VSS.n59 VSS.n58 25.224
R455 VSS.n57 VSS.n56 25.224
R456 VSS.n56 VSS.n27 25.224
R457 VSS.n52 VSS.n51 25.224
R458 VSS.n51 VSS.n50 25.224
R459 VSS.n49 VSS.n48 25.224
R460 VSS.n48 VSS.n31 25.224
R461 VSS.n44 VSS.n43 25.224
R462 VSS.n43 VSS.n42 25.224
R463 VSS.n41 VSS.n40 25.224
R464 VSS.n40 VSS.n35 25.224
R465 VSS.n149 VSS.n0 23.7181
R466 VSS.n77 VSS.n76 20.3299
R467 VSS.n82 VSS.n81 20.3299
R468 VSS.n87 VSS.n86 20.3299
R469 VSS.n92 VSS.n91 20.3299
R470 VSS.n97 VSS.n96 20.3299
R471 VSS.n102 VSS.n101 20.3299
R472 VSS.n107 VSS.n106 20.3299
R473 VSS.n118 VSS.n117 20.3299
R474 VSS.n123 VSS.n122 20.3299
R475 VSS.n128 VSS.n127 20.3299
R476 VSS.n133 VSS.n132 20.3299
R477 VSS.n138 VSS.n137 20.3299
R478 VSS.n66 VSS.n65 20.3299
R479 VSS.n60 VSS.n23 20.3299
R480 VSS.n58 VSS.n57 20.3299
R481 VSS.n52 VSS.n27 20.3299
R482 VSS.n50 VSS.n49 20.3299
R483 VSS.n44 VSS.n31 20.3299
R484 VSS.n42 VSS.n41 20.3299
R485 VSS.n112 VSS.n9 17.3181
R486 VSS.n71 VSS.n19 17.3181
R487 VSS.n72 VSS.n71 15.8123
R488 VSS.n113 VSS.n112 15.8123
R489 VSS.n36 VSS.n35 15.8123
R490 VSS VSS.n0 9.31613
R491 VSS.n37 VSS.n36 9.3005
R492 VSS.n38 VSS.n35 9.3005
R493 VSS.n150 VSS.n149 9.3005
R494 VSS.n148 VSS.n1 9.3005
R495 VSS.n147 VSS.n146 9.3005
R496 VSS.n145 VSS.n2 9.3005
R497 VSS.n144 VSS.n143 9.3005
R498 VSS.n142 VSS.n141 9.3005
R499 VSS.n140 VSS.n3 9.3005
R500 VSS.n139 VSS.n138 9.3005
R501 VSS.n137 VSS.n136 9.3005
R502 VSS.n135 VSS.n4 9.3005
R503 VSS.n134 VSS.n133 9.3005
R504 VSS.n132 VSS.n131 9.3005
R505 VSS.n130 VSS.n5 9.3005
R506 VSS.n129 VSS.n128 9.3005
R507 VSS.n127 VSS.n126 9.3005
R508 VSS.n125 VSS.n6 9.3005
R509 VSS.n124 VSS.n123 9.3005
R510 VSS.n122 VSS.n121 9.3005
R511 VSS.n120 VSS.n7 9.3005
R512 VSS.n119 VSS.n118 9.3005
R513 VSS.n117 VSS.n116 9.3005
R514 VSS.n115 VSS.n8 9.3005
R515 VSS.n114 VSS.n113 9.3005
R516 VSS.n112 VSS.n111 9.3005
R517 VSS.n110 VSS.n9 9.3005
R518 VSS.n109 VSS.n108 9.3005
R519 VSS.n107 VSS.n11 9.3005
R520 VSS.n106 VSS.n105 9.3005
R521 VSS.n104 VSS.n12 9.3005
R522 VSS.n103 VSS.n102 9.3005
R523 VSS.n101 VSS.n100 9.3005
R524 VSS.n99 VSS.n13 9.3005
R525 VSS.n98 VSS.n97 9.3005
R526 VSS.n96 VSS.n95 9.3005
R527 VSS.n94 VSS.n14 9.3005
R528 VSS.n93 VSS.n92 9.3005
R529 VSS.n91 VSS.n90 9.3005
R530 VSS.n89 VSS.n15 9.3005
R531 VSS.n88 VSS.n87 9.3005
R532 VSS.n86 VSS.n85 9.3005
R533 VSS.n84 VSS.n16 9.3005
R534 VSS.n83 VSS.n82 9.3005
R535 VSS.n81 VSS.n80 9.3005
R536 VSS.n79 VSS.n17 9.3005
R537 VSS.n78 VSS.n77 9.3005
R538 VSS.n76 VSS.n75 9.3005
R539 VSS.n74 VSS.n18 9.3005
R540 VSS.n73 VSS.n72 9.3005
R541 VSS.n71 VSS.n70 9.3005
R542 VSS.n69 VSS.n19 9.3005
R543 VSS.n68 VSS.n67 9.3005
R544 VSS.n66 VSS.n21 9.3005
R545 VSS.n65 VSS.n22 9.3005
R546 VSS.n64 VSS.n63 9.3005
R547 VSS.n62 VSS.n23 9.3005
R548 VSS.n61 VSS.n60 9.3005
R549 VSS.n59 VSS.n24 9.3005
R550 VSS.n58 VSS.n25 9.3005
R551 VSS.n57 VSS.n26 9.3005
R552 VSS.n56 VSS.n55 9.3005
R553 VSS.n54 VSS.n27 9.3005
R554 VSS.n53 VSS.n52 9.3005
R555 VSS.n51 VSS.n28 9.3005
R556 VSS.n50 VSS.n29 9.3005
R557 VSS.n49 VSS.n30 9.3005
R558 VSS.n48 VSS.n47 9.3005
R559 VSS.n46 VSS.n31 9.3005
R560 VSS.n45 VSS.n44 9.3005
R561 VSS.n43 VSS.n32 9.3005
R562 VSS.n42 VSS.n33 9.3005
R563 VSS.n41 VSS.n34 9.3005
R564 VSS.n40 VSS.n39 9.3005
R565 VSS.n90 VSS 0.845094
R566 VSS.n150 VSS.n1 0.058
R567 VSS.n146 VSS.n1 0.058
R568 VSS.n146 VSS.n145 0.058
R569 VSS.n145 VSS.n144 0.058
R570 VSS.n141 VSS.n140 0.058
R571 VSS.n140 VSS.n139 0.058
R572 VSS.n136 VSS.n135 0.058
R573 VSS.n135 VSS.n134 0.058
R574 VSS.n131 VSS.n130 0.058
R575 VSS.n130 VSS.n129 0.058
R576 VSS.n126 VSS.n125 0.058
R577 VSS.n125 VSS.n124 0.058
R578 VSS.n121 VSS.n120 0.058
R579 VSS.n120 VSS.n119 0.058
R580 VSS.n116 VSS.n115 0.058
R581 VSS.n115 VSS.n114 0.058
R582 VSS.n110 VSS.n109 0.058
R583 VSS.n109 VSS.n11 0.058
R584 VSS.n105 VSS.n104 0.058
R585 VSS.n104 VSS.n103 0.058
R586 VSS.n100 VSS.n99 0.058
R587 VSS.n99 VSS.n98 0.058
R588 VSS.n95 VSS.n94 0.058
R589 VSS.n94 VSS.n93 0.058
R590 VSS.n90 VSS.n89 0.058
R591 VSS.n89 VSS.n88 0.058
R592 VSS.n85 VSS.n84 0.058
R593 VSS.n84 VSS.n83 0.058
R594 VSS.n80 VSS.n79 0.058
R595 VSS.n79 VSS.n78 0.058
R596 VSS.n75 VSS.n74 0.058
R597 VSS.n74 VSS.n73 0.058
R598 VSS.n69 VSS.n68 0.058
R599 VSS.n68 VSS.n21 0.058
R600 VSS.n63 VSS.n22 0.058
R601 VSS.n63 VSS.n62 0.058
R602 VSS.n61 VSS.n24 0.058
R603 VSS.n25 VSS.n24 0.058
R604 VSS.n55 VSS.n26 0.058
R605 VSS.n55 VSS.n54 0.058
R606 VSS.n53 VSS.n28 0.058
R607 VSS.n29 VSS.n28 0.058
R608 VSS.n47 VSS.n30 0.058
R609 VSS.n47 VSS.n46 0.058
R610 VSS.n45 VSS.n32 0.058
R611 VSS.n33 VSS.n32 0.058
R612 VSS.n39 VSS.n34 0.058
R613 VSS.n39 VSS.n38 0.058
R614 VSS.n141 VSS 0.048
R615 VSS.n136 VSS 0.047375
R616 VSS.n131 VSS 0.047375
R617 VSS.n126 VSS 0.047375
R618 VSS.n121 VSS 0.047375
R619 VSS.n116 VSS 0.047375
R620 VSS.n111 VSS 0.047375
R621 VSS.n105 VSS 0.047375
R622 VSS.n100 VSS 0.047375
R623 VSS.n95 VSS 0.047375
R624 VSS.n90 VSS 0.047375
R625 VSS.n85 VSS 0.047375
R626 VSS.n80 VSS 0.047375
R627 VSS.n75 VSS 0.047375
R628 VSS.n70 VSS 0.047375
R629 VSS.n22 VSS 0.047375
R630 VSS VSS.n61 0.047375
R631 VSS.n26 VSS 0.047375
R632 VSS VSS.n53 0.047375
R633 VSS.n30 VSS 0.047375
R634 VSS VSS.n45 0.047375
R635 VSS.n34 VSS 0.047375
R636 VSS VSS.n37 0.047375
R637 VSS VSS.n150 0.042375
R638 VSS VSS.n110 0.042375
R639 VSS VSS.n69 0.042375
R640 VSS.n111 VSS 0.016125
R641 VSS.n70 VSS 0.016125
R642 VSS.n37 VSS 0.016125
R643 VSS.n139 VSS 0.011125
R644 VSS.n134 VSS 0.011125
R645 VSS.n129 VSS 0.011125
R646 VSS.n124 VSS 0.011125
R647 VSS.n119 VSS 0.011125
R648 VSS.n114 VSS 0.011125
R649 VSS VSS.n11 0.011125
R650 VSS.n103 VSS 0.011125
R651 VSS.n98 VSS 0.011125
R652 VSS.n93 VSS 0.011125
R653 VSS.n88 VSS 0.011125
R654 VSS.n83 VSS 0.011125
R655 VSS.n78 VSS 0.011125
R656 VSS.n73 VSS 0.011125
R657 VSS VSS.n21 0.011125
R658 VSS.n62 VSS 0.011125
R659 VSS VSS.n25 0.011125
R660 VSS.n54 VSS 0.011125
R661 VSS VSS.n29 0.011125
R662 VSS.n46 VSS 0.011125
R663 VSS VSS.n33 0.011125
R664 VSS.n38 VSS 0.011125
R665 VSS.n144 VSS 0.0105
C0 r4 out 0.06255f
C1 r17 VDD 0.44192f
C2 r12 en 0.02534f
C3 r16 VDD 0.47486f
C4 out r22 0.15495f
C5 r2 r4 0
C6 r17 en 0.02558f
C7 r7 out 0.06233f
C8 r16 en 0.02957f
C9 a_6375_47# r22 0.10263f
C10 r2 out 0.06404f
C11 r13 r12 0.15274f
C12 r15 r17 0
C13 out a_6375_47# 0.12727f
C14 r1 VDD 0.44162f
C15 r5 r3 0
C16 r15 r16 0.14426f
C17 r8 out 0.07757f
C18 r20 VDD 0.44054f
C19 r8 r7 0.14426f
C20 r19 VDD 0.44054f
C21 r10 out 0.06229f
C22 r21 VDD 0.44066f
C23 r1 en 0.02534f
C24 r14 out 0.06229f
C25 r3 VDD 0.44054f
C26 r4 r5 0.15274f
C27 r20 en 0.02696f
C28 r19 en 0.02628f
C29 r18 VDD 0.44054f
C30 r21 en 0.02861f
C31 r11 out 0.06229f
C32 r10 r8 0
C33 r5 out 0.06245f
C34 r3 en 0.02534f
C35 r4 VDD 0.44054f
C36 r5 r7 0
C37 r22 VDD 0.43365f
C38 r18 en 0.02595f
C39 out VDD 1.84565f
C40 r4 en 0.02534f
C41 r7 VDD 0.44302f
C42 r17 r16 0.15054f
C43 en r22 0.13183f
C44 r2 VDD 0.44054f
C45 r11 r10 0.15274f
C46 a_6375_47# VDD 0.00217f
C47 en out 0.82787f
C48 r9 out 0.06232f
C49 r7 en 0.02534f
C50 r8 VDD 0.47486f
C51 r9 r7 0
C52 r15 out 0.06233f
C53 r2 en 0.02534f
C54 r10 VDD 0.44054f
C55 en a_6375_47# 0.0438f
C56 r14 VDD 0.44054f
C57 r8 en 0.02957f
C58 r8 r9 0.15054f
C59 r6 r4 0
C60 r17 r19 0
C61 r13 out 0.06229f
C62 r10 en 0.02534f
C63 r11 VDD 0.44054f
C64 r10 r9 0.15274f
C65 r14 en 0.02534f
C66 r5 VDD 0.44054f
C67 r6 out 0.06233f
C68 r18 r17 0.15274f
C69 r6 r7 0.15274f
C70 r14 r15 0.15274f
C71 r18 r16 0
C72 r12 out 0.06229f
C73 r11 en 0.02534f
C74 r5 en 0.02534f
C75 r11 r9 0
C76 r6 r8 0
C77 r14 r13 0.15274f
C78 r20 r19 0.15274f
C79 r1 r3 0
C80 r21 r20 0.15274f
C81 r17 out 0.06235f
C82 en VDD 3.43327f
C83 r21 r19 0
C84 r16 out 0.07757f
C85 r9 VDD 0.44192f
C86 r13 r11 0
C87 r18 r20 0
C88 r15 VDD 0.44302f
C89 r12 r10 0
C90 r14 r12 0
C91 r18 r19 0.15274f
C92 r9 en 0.02534f
C93 r6 r5 0.15274f
C94 r20 r22 0
C95 r13 VDD 0.44054f
C96 r1 out 0.21896f
C97 r15 en 0.02534f
C98 r12 r11 0.15274f
C99 r4 r3 0.15274f
C100 r20 out 0.06317f
C101 r21 r22 0.15007f
C102 r14 r16 0
C103 r19 out 0.06285f
C104 r1 r2 0.15274f
C105 r6 VDD 0.44054f
C106 r21 out 0.06401f
C107 r13 en 0.02534f
C108 r3 out 0.06277f
C109 r12 VDD 0.44054f
C110 r13 r15 0
C111 r6 en 0.02534f
C112 r18 out 0.06257f
C113 r2 r3 0.15274f
C114 en VSS 6.55268f
C115 out VSS 6.18885f
C116 VDD VSS 15.12712f
C117 a_6375_47# VSS 0.34921f
C118 r22 VSS 0.40295f
C119 r21 VSS 0.45792f
C120 r20 VSS 0.45585f
C121 r19 VSS 0.45585f
C122 r18 VSS 0.45585f
C123 r17 VSS 0.45667f
C124 r16 VSS 0.49897f
C125 r15 VSS 0.46085f
C126 r14 VSS 0.45585f
C127 r13 VSS 0.45585f
C128 r12 VSS 0.45585f
C129 r11 VSS 0.45585f
C130 r10 VSS 0.45585f
C131 r9 VSS 0.45667f
C132 r8 VSS 0.49897f
C133 r7 VSS 0.46085f
C134 r6 VSS 0.45585f
C135 r5 VSS 0.45585f
C136 r4 VSS 0.45585f
C137 r3 VSS 0.45585f
C138 r2 VSS 0.45585f
C139 r1 VSS 0.46303f
C140 VDD.t85 VSS 0.02118f
C141 VDD.n0 VSS 0.02665f
C142 VDD.t31 VSS 0.02117f
C143 VDD.n1 VSS 0.02473f
C144 VDD.t33 VSS 0.02118f
C145 VDD.n2 VSS 0.02665f
C146 VDD.n3 VSS 0.03286f
C147 VDD.t35 VSS 0.02117f
C148 VDD.n4 VSS 0.02145f
C149 VDD.t25 VSS 0.02118f
C150 VDD.t27 VSS 0.02117f
C151 VDD.n5 VSS 0.025f
C152 VDD.n6 VSS 0.0362f
C153 VDD.t21 VSS 0.02118f
C154 VDD.n7 VSS 0.03286f
C155 VDD.t23 VSS 0.02117f
C156 VDD.n8 VSS 0.02145f
C157 VDD.t17 VSS 0.02118f
C158 VDD.t19 VSS 0.02117f
C159 VDD.n9 VSS 0.025f
C160 VDD.n10 VSS 0.0362f
C161 VDD.t77 VSS 0.02118f
C162 VDD.n11 VSS 0.03286f
C163 VDD.t79 VSS 0.02117f
C164 VDD.n12 VSS 0.02145f
C165 VDD.t57 VSS 0.02118f
C166 VDD.t59 VSS 0.02117f
C167 VDD.n13 VSS 0.025f
C168 VDD.n14 VSS 0.0362f
C169 VDD.t37 VSS 0.02118f
C170 VDD.n15 VSS 0.03286f
C171 VDD.t39 VSS 0.02117f
C172 VDD.n16 VSS 0.02145f
C173 VDD.t53 VSS 0.02118f
C174 VDD.t55 VSS 0.02117f
C175 VDD.n17 VSS 0.02473f
C176 VDD.t61 VSS 0.02118f
C177 VDD.n18 VSS 0.02665f
C178 VDD.t51 VSS 0.02023f
C179 VDD.n19 VSS 0.02318f
C180 VDD.n20 VSS 0.0362f
C181 VDD.t49 VSS 0.00531f
C182 VDD.t95 VSS 0.00531f
C183 VDD.n21 VSS 0.0114f
C184 VDD.t93 VSS 0.02119f
C185 VDD.n22 VSS 0.02993f
C186 VDD.n23 VSS 0.0362f
C187 VDD.t83 VSS 0.02117f
C188 VDD.n24 VSS 0.025f
C189 VDD.n25 VSS 0.02145f
C190 VDD.n26 VSS 0.00448f
C191 VDD.n27 VSS 0.00448f
C192 VDD.n28 VSS 0.00448f
C193 VDD.n29 VSS 0.00448f
C194 VDD.n30 VSS 0.02145f
C195 VDD.n31 VSS 0.0362f
C196 VDD.n32 VSS 0.03286f
C197 VDD.t63 VSS 0.02117f
C198 VDD.n33 VSS 0.025f
C199 VDD.t65 VSS 0.02118f
C200 VDD.n34 VSS 0.02705f
C201 VDD.n35 VSS 0.02145f
C202 VDD.n36 VSS 0.0362f
C203 VDD.n37 VSS 0.03286f
C204 VDD.t67 VSS 0.02117f
C205 VDD.n38 VSS 0.025f
C206 VDD.t89 VSS 0.02118f
C207 VDD.n39 VSS 0.02705f
C208 VDD.n40 VSS 0.02145f
C209 VDD.n41 VSS 0.0362f
C210 VDD.n42 VSS 0.03286f
C211 VDD.t91 VSS 0.02117f
C212 VDD.n43 VSS 0.025f
C213 VDD.t45 VSS 0.02118f
C214 VDD.n44 VSS 0.02705f
C215 VDD.n45 VSS 0.02145f
C216 VDD.n46 VSS 0.0362f
C217 VDD.n47 VSS 0.03286f
C218 VDD.t47 VSS 0.02117f
C219 VDD.n48 VSS 0.025f
C220 VDD.t81 VSS 0.02118f
C221 VDD.n49 VSS 0.02705f
C222 VDD.n50 VSS 0.00448f
C223 VDD.n51 VSS 0.0362f
C224 VDD.n52 VSS 0.03286f
C225 VDD.n53 VSS 0.02145f
C226 VDD.t69 VSS 0.02118f
C227 VDD.n54 VSS 0.02705f
C228 VDD.n55 VSS 0.00448f
C229 VDD.t71 VSS 0.02117f
C230 VDD.n56 VSS 0.02473f
C231 VDD.n57 VSS 0.03306f
C232 VDD.n58 VSS 0.02125f
C233 VDD.n59 VSS 0.0362f
C234 VDD.n60 VSS 0.00505f
C235 VDD.n61 VSS 0.013f
C236 VDD.n62 VSS 0.00341f
C237 VDD.n63 VSS 0.00472f
C238 VDD.n64 VSS 0.0362f
C239 VDD.n65 VSS 0.03148f
C240 VDD.n66 VSS 0.11137f
C241 VDD.t50 VSS 0.11219f
C242 VDD.t48 VSS 0.05306f
C243 VDD.t94 VSS 0.05306f
C244 VDD.t92 VSS 0.04674f
C245 VDD.t70 VSS 0.06632f
C246 VDD.t68 VSS 0.04769f
C247 VDD.t82 VSS 0.066f
C248 VDD.t80 VSS 0.04769f
C249 VDD.t46 VSS 0.066f
C250 VDD.t44 VSS 0.04769f
C251 VDD.t90 VSS 0.066f
C252 VDD.t88 VSS 0.04769f
C253 VDD.t66 VSS 0.066f
C254 VDD.t64 VSS 0.04769f
C255 VDD.t62 VSS 0.066f
C256 VDD.t60 VSS 0.04769f
C257 VDD.t32 VSS 0.04769f
C258 VDD.t34 VSS 0.066f
C259 VDD.t24 VSS 0.04769f
C260 VDD.t26 VSS 0.066f
C261 VDD.t20 VSS 0.04769f
C262 VDD.t22 VSS 0.066f
C263 VDD.t16 VSS 0.04769f
C264 VDD.t18 VSS 0.066f
C265 VDD.t76 VSS 0.04769f
C266 VDD.t78 VSS 0.066f
C267 VDD.t56 VSS 0.04769f
C268 VDD.t58 VSS 0.066f
C269 VDD.t36 VSS 0.04769f
C270 VDD.t38 VSS 0.066f
C271 VDD.t52 VSS 0.04769f
C272 VDD.t54 VSS 0.07137f
C273 VDD.n67 VSS 0.07813f
C274 VDD.n68 VSS 0.03552f
C275 VDD.n69 VSS 0.01948f
C276 VDD.n70 VSS 0.03148f
C277 VDD.n71 VSS 0.0362f
C278 VDD.n72 VSS 0.00448f
C279 VDD.n73 VSS 0.02705f
C280 VDD.n74 VSS 0.025f
C281 VDD.n75 VSS 0.00448f
C282 VDD.n76 VSS 0.02705f
C283 VDD.n77 VSS 0.02145f
C284 VDD.n78 VSS 0.03286f
C285 VDD.n79 VSS 0.0362f
C286 VDD.n80 VSS 0.00448f
C287 VDD.n81 VSS 0.02705f
C288 VDD.n82 VSS 0.025f
C289 VDD.n83 VSS 0.00448f
C290 VDD.n84 VSS 0.02705f
C291 VDD.n85 VSS 0.02145f
C292 VDD.n86 VSS 4.65808f
C293 VDD.n87 VSS 0.0362f
C294 VDD.n88 VSS 0.00448f
C295 VDD.n89 VSS 0.02705f
C296 VDD.n90 VSS 0.025f
C297 VDD.n91 VSS 0.00448f
C298 VDD.n92 VSS 0.02705f
C299 VDD.n93 VSS 0.02145f
C300 VDD.n94 VSS 0.03286f
C301 VDD.n95 VSS 0.0362f
C302 VDD.n96 VSS 0.00448f
C303 VDD.n97 VSS 0.02705f
C304 VDD.n98 VSS 0.025f
C305 VDD.n99 VSS 0.00448f
C306 VDD.n100 VSS 0.0362f
C307 VDD.n101 VSS 0.02145f
C308 VDD.n102 VSS 0.02145f
C309 VDD.n103 VSS 0.00448f
C310 VDD.n104 VSS 0.00448f
C311 VDD.n105 VSS 0.00448f
C312 VDD.n106 VSS 0.00448f
C313 VDD.n107 VSS 0.00448f
C314 VDD.n108 VSS 0.00448f
C315 VDD.n109 VSS 0.00448f
C316 VDD.n110 VSS 0.02145f
C317 VDD.n111 VSS 0.0362f
C318 VDD.n112 VSS 0.03286f
C319 VDD.t87 VSS 0.02117f
C320 VDD.n113 VSS 0.025f
C321 VDD.t9 VSS 0.02118f
C322 VDD.n114 VSS 0.02705f
C323 VDD.n115 VSS 0.02145f
C324 VDD.n116 VSS 0.0362f
C325 VDD.n117 VSS 0.03286f
C326 VDD.t11 VSS 0.02117f
C327 VDD.n118 VSS 0.025f
C328 VDD.t1 VSS 0.02118f
C329 VDD.n119 VSS 0.02705f
C330 VDD.n120 VSS 0.02145f
C331 VDD.n121 VSS 0.0362f
C332 VDD.n122 VSS 0.03286f
C333 VDD.t3 VSS 0.02117f
C334 VDD.n123 VSS 0.025f
C335 VDD.t5 VSS 0.02118f
C336 VDD.n124 VSS 0.02705f
C337 VDD.n125 VSS 0.02145f
C338 VDD.n126 VSS 0.0362f
C339 VDD.n127 VSS 0.03286f
C340 VDD.t7 VSS 0.02117f
C341 VDD.n128 VSS 0.025f
C342 VDD.t13 VSS 0.02118f
C343 VDD.n129 VSS 0.02705f
C344 VDD.n130 VSS 0.02145f
C345 VDD.n131 VSS 0.0362f
C346 VDD.n132 VSS 0.03286f
C347 VDD.t15 VSS 0.02117f
C348 VDD.n133 VSS 0.025f
C349 VDD.t41 VSS 0.02118f
C350 VDD.n134 VSS 0.02705f
C351 VDD.n135 VSS 0.02145f
C352 VDD.n136 VSS 0.0362f
C353 VDD.n137 VSS 0.03286f
C354 VDD.t43 VSS 0.02117f
C355 VDD.n138 VSS 0.025f
C356 VDD.t73 VSS 0.02118f
C357 VDD.n139 VSS 0.02705f
C358 VDD.n140 VSS 0.02145f
C359 VDD.n141 VSS 0.0362f
C360 VDD.n142 VSS 0.03286f
C361 VDD.t75 VSS 0.02117f
C362 VDD.n143 VSS 0.025f
C363 VDD.t29 VSS 0.02118f
C364 VDD.n144 VSS 0.02705f
C365 VDD.n145 VSS 0.00448f
C366 VDD.n146 VSS 0.0362f
C367 VDD.n147 VSS 0.03148f
C368 VDD.n148 VSS 0.01948f
C369 VDD.n149 VSS 0.03552f
C370 VDD.n150 VSS 0.07813f
C371 VDD.t30 VSS 0.07137f
C372 VDD.t28 VSS 0.04769f
C373 VDD.t74 VSS 0.066f
C374 VDD.t72 VSS 0.04769f
C375 VDD.t42 VSS 0.066f
C376 VDD.t40 VSS 0.04769f
C377 VDD.t14 VSS 0.066f
C378 VDD.t12 VSS 0.04769f
C379 VDD.t6 VSS 0.066f
C380 VDD.t4 VSS 0.04769f
C381 VDD.t2 VSS 0.066f
C382 VDD.t0 VSS 0.04769f
C383 VDD.t10 VSS 0.066f
C384 VDD.t8 VSS 0.04769f
C385 VDD.t86 VSS 0.066f
C386 VDD.t84 VSS 0.04769f
C387 VDD.n151 VSS 0.07689f
C388 VDD.n152 VSS 0.01948f
C389 out.t9 VSS 0.03251f
C390 out.t7 VSS 0.01916f
C391 out.t8 VSS 0.03251f
C392 out.t6 VSS 0.01916f
C393 out.n0 VSS 0.05455f
C394 out.n1 VSS 0.08079f
C395 out.n2 VSS 0.04487f
C396 out.t5 VSS 0.0209f
C397 out.t4 VSS 0.0209f
C398 out.n3 VSS 0.06346f
C399 out.t0 VSS 0.0209f
C400 out.t1 VSS 0.0209f
C401 out.n4 VSS 0.04646f
C402 out.n5 VSS 0.21023f
C403 out.t3 VSS 0.01359f
C404 out.t2 VSS 0.01359f
C405 out.n6 VSS 0.03014f
C406 out.n7 VSS 0.05667f
C407 out.n8 VSS 0.0355f
C408 out.n9 VSS 1.76366f
C409 en.t2 VSS 0.03794f
C410 en.t0 VSS 0.02236f
C411 en.n0 VSS 0.05114f
C412 en.t3 VSS 0.03794f
C413 en.t1 VSS 0.02236f
C414 en.n1 VSS 0.05114f
C415 en.n2 VSS 0.0252f
.ends
