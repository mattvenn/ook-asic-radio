* tx_drv: magic R+C extraction of layout/tx_drv.gds (layout/pex.sh)
.subckt tx_drv in en out VAPWR VSS
X0 VAPWR.t35 a_2360_n1712# out.t18 VAPWR.t34 sky130_fd_pr__pfet_g5v0d10v5 ad=1.2 pd=8.3 as=1.2 ps=8.3 w=8 l=0.5
X1 out.t26 a_2360_n1712# VAPWR.t41 VAPWR.t40 sky130_fd_pr__pfet_g5v0d10v5 ad=1.2 pd=8.3 as=1.2 ps=8.3 w=8 l=0.5
X2 out.t12 a_2360_n1712# VSS.t14 VSS.t13 sky130_fd_pr__nfet_g5v0d10v5 ad=0.65475 pd=4.665 as=0.65475 ps=4.665 w=4.365 l=0.5
X3 VAPWR.t3 a_1240_n1152# a_1640_n1488# VAPWR.t2 sky130_fd_pr__pfet_g5v0d10v5 ad=1.008 pd=7.02 as=1.008 ps=7.02 w=6.72 l=0.5
X4 out.t5 a_2360_n1712# VAPWR.t21 VAPWR.t20 sky130_fd_pr__pfet_g5v0d10v5 ad=1.2 pd=8.3 as=1.2 ps=8.3 w=8 l=0.5
X5 VSS.t20 a_2360_n1712# out.t14 VSS.t19 sky130_fd_pr__nfet_g5v0d10v5 ad=0.65475 pd=4.665 as=0.65475 ps=4.665 w=4.365 l=0.5
X6 VAPWR.t27 a_2360_n1712# out.t4 VAPWR.t26 sky130_fd_pr__pfet_g5v0d10v5 ad=1.2 pd=8.3 as=1.2 ps=8.3 w=8 l=0.5
X7 VAPWR.t61 a_1640_n1488# a_2360_n1712# VAPWR.t60 sky130_fd_pr__pfet_g5v0d10v5 ad=1.0995 pd=7.63 as=1.0995 ps=7.63 w=7.33 l=0.5
X8 VSS.t8 a_2360_n1712# out.t3 VSS.t7 sky130_fd_pr__nfet_g5v0d10v5 ad=0.65475 pd=4.665 as=0.65475 ps=4.665 w=4.365 l=0.5
X9 VAPWR.t49 en.t1 a_120_n984# VAPWR.t48 sky130_fd_pr__pfet_g5v0d10v5 ad=0.378 pd=3.12 as=0.189 ps=1.56 w=1.26 l=0.5
X10 a_2360_n1712# a_1640_n1488# VAPWR.t67 VAPWR.t66 sky130_fd_pr__pfet_g5v0d10v5 ad=1.0995 pd=7.63 as=1.0995 ps=7.63 w=7.33 l=0.5
X11 a_1640_n1488# a_1240_n1152# VAPWR.t5 VAPWR.t4 sky130_fd_pr__pfet_g5v0d10v5 ad=2.016 pd=14.04 as=1.008 ps=7.02 w=6.72 l=0.5
X12 VAPWR.t53 a_1640_n1488# a_2360_n1712# VAPWR.t52 sky130_fd_pr__pfet_g5v0d10v5 ad=1.0995 pd=7.63 as=1.0995 ps=7.63 w=7.33 l=0.5
X13 a_2360_n1712# a_1640_n1488# VAPWR.t59 VAPWR.t58 sky130_fd_pr__pfet_g5v0d10v5 ad=1.0995 pd=7.63 as=1.0995 ps=7.63 w=7.33 l=0.5
X14 VAPWR.t43 a_2360_n1712# out.t19 VAPWR.t42 sky130_fd_pr__pfet_g5v0d10v5 ad=2.4 pd=16.6 as=1.2 ps=8.3 w=8 l=0.5
X15 VSS.t36 a_1640_n1488# a_2360_n1712# VSS.t35 sky130_fd_pr__nfet_g5v0d10v5 ad=0.672 pd=4.78 as=0.672 ps=4.78 w=4.48 l=0.5
X16 VAPWR.t23 a_2360_n1712# out.t2 VAPWR.t22 sky130_fd_pr__pfet_g5v0d10v5 ad=1.2 pd=8.3 as=1.2 ps=8.3 w=8 l=0.5
X17 out.t23 a_2360_n1712# VAPWR.t29 VAPWR.t28 sky130_fd_pr__pfet_g5v0d10v5 ad=1.2 pd=8.3 as=1.2 ps=8.3 w=8 l=0.5
X18 a_2360_n1712# a_1640_n1488# VSS.t42 VSS.t41 sky130_fd_pr__nfet_g5v0d10v5 ad=0.672 pd=4.78 as=0.672 ps=4.78 w=4.48 l=0.5
X19 out.t9 a_2360_n1712# VAPWR.t9 VAPWR.t8 sky130_fd_pr__pfet_g5v0d10v5 ad=1.2 pd=8.3 as=2.4 ps=16.6 w=8 l=0.5
X20 VSS.t3 a_1240_n1152# a_1640_n1488# VSS.t2 sky130_fd_pr__nfet_g5v0d10v5 ad=1.008 pd=7.32 as=0.504 ps=3.66 w=3.36 l=0.5
X21 out.t10 a_2360_n1712# VSS.t18 VSS.t17 sky130_fd_pr__nfet_g5v0d10v5 ad=0.65475 pd=4.665 as=0.65475 ps=4.665 w=4.365 l=0.5
X22 VAPWR.t15 a_2360_n1712# out.t17 VAPWR.t14 sky130_fd_pr__pfet_g5v0d10v5 ad=1.2 pd=8.3 as=1.2 ps=8.3 w=8 l=0.5
X23 out.t11 a_2360_n1712# VSS.t6 VSS.t5 sky130_fd_pr__nfet_g5v0d10v5 ad=0.65475 pd=4.665 as=1.3095 ps=9.33 w=4.365 l=0.5
X24 VSS.t24 a_2360_n1712# out.t6 VSS.t23 sky130_fd_pr__nfet_g5v0d10v5 ad=0.65475 pd=4.665 as=0.65475 ps=4.665 w=4.365 l=0.5
X25 VSS.t12 a_2360_n1712# out.t28 VSS.t11 sky130_fd_pr__nfet_g5v0d10v5 ad=0.65475 pd=4.665 as=0.65475 ps=4.665 w=4.365 l=0.5
X26 a_2360_n1712# a_1640_n1488# VAPWR.t55 VAPWR.t54 sky130_fd_pr__pfet_g5v0d10v5 ad=1.0995 pd=7.63 as=1.0995 ps=7.63 w=7.33 l=0.5
X27 VAPWR.t31 a_2360_n1712# out.t25 VAPWR.t30 sky130_fd_pr__pfet_g5v0d10v5 ad=1.2 pd=8.3 as=1.2 ps=8.3 w=8 l=0.5
X28 out.t16 a_2360_n1712# VAPWR.t37 VAPWR.t36 sky130_fd_pr__pfet_g5v0d10v5 ad=1.2 pd=8.3 as=1.2 ps=8.3 w=8 l=0.5
X29 a_2360_n1712# a_1640_n1488# VSS.t34 VSS.t33 sky130_fd_pr__nfet_g5v0d10v5 ad=0.672 pd=4.78 as=1.344 ps=9.56 w=4.48 l=0.5
X30 a_1640_n1488# a_1240_n1152# VSS.t1 VSS.t0 sky130_fd_pr__nfet_g5v0d10v5 ad=0.504 pd=3.66 as=1.008 ps=7.32 w=3.36 l=0.5
X31 VSS.t40 a_1640_n1488# a_2360_n1712# VSS.t39 sky130_fd_pr__nfet_g5v0d10v5 ad=0.672 pd=4.78 as=0.672 ps=4.78 w=4.48 l=0.5
X32 VSS.t16 a_2360_n1712# out.t1 VSS.t15 sky130_fd_pr__nfet_g5v0d10v5 ad=0.65475 pd=4.665 as=0.65475 ps=4.665 w=4.365 l=0.5
X33 VSS.t32 en.t0 a_280_n984# VSS.t31 sky130_fd_pr__nfet_g5v0d10v5 ad=0.252 pd=2.28 as=0.126 ps=1.14 w=0.84 l=0.5
X34 out.t13 a_2360_n1712# VSS.t22 VSS.t21 sky130_fd_pr__nfet_g5v0d10v5 ad=0.65475 pd=4.665 as=0.65475 ps=4.665 w=4.365 l=0.5
X35 a_2360_n1712# a_1640_n1488# VAPWR.t63 VAPWR.t62 sky130_fd_pr__pfet_g5v0d10v5 ad=1.0995 pd=7.63 as=1.0995 ps=7.63 w=7.33 l=0.5
X36 a_840_n900# a_120_n984# VSS.t28 VSS.t27 sky130_fd_pr__nfet_g5v0d10v5 ad=0.126 pd=1.44 as=0.126 ps=1.44 w=0.42 l=0.5
X37 VAPWR.t69 a_1640_n1488# a_2360_n1712# VAPWR.t68 sky130_fd_pr__pfet_g5v0d10v5 ad=1.0995 pd=7.63 as=1.0995 ps=7.63 w=7.33 l=0.5
X38 out.t8 a_2360_n1712# VAPWR.t33 VAPWR.t32 sky130_fd_pr__pfet_g5v0d10v5 ad=1.2 pd=8.3 as=1.2 ps=8.3 w=8 l=0.5
X39 VSS.t44 a_1640_n1488# a_2360_n1712# VSS.t43 sky130_fd_pr__nfet_g5v0d10v5 ad=1.344 pd=9.56 as=0.672 ps=4.78 w=4.48 l=0.5
X40 a_1640_n1488# a_1240_n1152# VAPWR.t1 VAPWR.t0 sky130_fd_pr__pfet_g5v0d10v5 ad=1.008 pd=7.02 as=2.016 ps=14.04 w=6.72 l=0.5
X41 VAPWR.t39 a_2360_n1712# out.t21 VAPWR.t38 sky130_fd_pr__pfet_g5v0d10v5 ad=1.2 pd=8.3 as=1.2 ps=8.3 w=8 l=0.5
X42 VAPWR.t19 a_2360_n1712# out.t22 VAPWR.t18 sky130_fd_pr__pfet_g5v0d10v5 ad=1.2 pd=8.3 as=1.2 ps=8.3 w=8 l=0.5
X43 out.t24 a_2360_n1712# VAPWR.t25 VAPWR.t24 sky130_fd_pr__pfet_g5v0d10v5 ad=1.2 pd=8.3 as=1.2 ps=8.3 w=8 l=0.5
X44 a_1240_n1152# a_840_n900# VSS.t30 VSS.t29 sky130_fd_pr__nfet_g5v0d10v5 ad=0.504 pd=3.96 as=0.504 ps=3.96 w=1.68 l=0.5
X45 a_2360_n1712# a_1640_n1488# VSS.t38 VSS.t37 sky130_fd_pr__nfet_g5v0d10v5 ad=0.672 pd=4.78 as=0.672 ps=4.78 w=4.48 l=0.5
X46 a_120_n984# in.t1 VAPWR.t7 VAPWR.t6 sky130_fd_pr__pfet_g5v0d10v5 ad=0.189 pd=1.56 as=0.378 ps=3.12 w=1.26 l=0.5
X47 VAPWR.t65 a_1640_n1488# a_2360_n1712# VAPWR.t64 sky130_fd_pr__pfet_g5v0d10v5 ad=1.0995 pd=7.63 as=1.0995 ps=7.63 w=7.33 l=0.5
X48 VAPWR.t11 a_2360_n1712# out.t0 VAPWR.t10 sky130_fd_pr__pfet_g5v0d10v5 ad=1.2 pd=8.3 as=1.2 ps=8.3 w=8 l=0.5
X49 a_2360_n1712# a_1640_n1488# VAPWR.t71 VAPWR.t70 sky130_fd_pr__pfet_g5v0d10v5 ad=2.199 pd=15.26 as=1.0995 ps=7.63 w=7.33 l=0.5
X50 out.t20 a_2360_n1712# VAPWR.t17 VAPWR.t16 sky130_fd_pr__pfet_g5v0d10v5 ad=1.2 pd=8.3 as=1.2 ps=8.3 w=8 l=0.5
X51 out.t27 a_2360_n1712# VSS.t26 VSS.t25 sky130_fd_pr__nfet_g5v0d10v5 ad=1.3095 pd=9.33 as=0.65475 ps=4.665 w=4.365 l=0.5
X52 a_2360_n1712# a_1640_n1488# VAPWR.t51 VAPWR.t50 sky130_fd_pr__pfet_g5v0d10v5 ad=1.0995 pd=7.63 as=2.199 ps=15.26 w=7.33 l=0.5
X53 a_280_n984# in.t0 a_120_n984# VSS.t4 sky130_fd_pr__nfet_g5v0d10v5 ad=0.126 pd=1.14 as=0.252 ps=2.28 w=0.84 l=0.5
X54 VAPWR.t57 a_1640_n1488# a_2360_n1712# VAPWR.t56 sky130_fd_pr__pfet_g5v0d10v5 ad=1.0995 pd=7.63 as=1.0995 ps=7.63 w=7.33 l=0.5
X55 a_1240_n1152# a_840_n900# VAPWR.t47 VAPWR.t46 sky130_fd_pr__pfet_g5v0d10v5 ad=1.512 pd=10.68 as=1.512 ps=10.68 w=5.04 l=0.5
X56 out.t15 a_2360_n1712# VAPWR.t13 VAPWR.t12 sky130_fd_pr__pfet_g5v0d10v5 ad=1.2 pd=8.3 as=1.2 ps=8.3 w=8 l=0.5
X57 out.t7 a_2360_n1712# VSS.t10 VSS.t9 sky130_fd_pr__nfet_g5v0d10v5 ad=0.65475 pd=4.665 as=0.65475 ps=4.665 w=4.365 l=0.5
X58 a_840_n900# a_120_n984# VAPWR.t45 VAPWR.t44 sky130_fd_pr__pfet_g5v0d10v5 ad=0.378 pd=3.12 as=0.378 ps=3.12 w=1.26 l=0.5
R0 out.n40 out.n39 285.877
R1 out.n39 out.n38 285.877
R2 out.n39 out.n31 285.877
R3 out.n39 out.n26 285.877
R4 out.n64 out.n60 285.877
R5 out.n64 out.n55 285.877
R6 out.n64 out.n50 285.877
R7 out.n65 out.n64 285.877
R8 out.n89 out.n85 285.877
R9 out.n89 out.n80 285.877
R10 out.n89 out.n75 285.877
R11 out.n90 out.n89 285.877
R12 out.n114 out.n110 285.877
R13 out.n114 out.n105 285.877
R14 out.n114 out.n100 285.877
R15 out.n115 out.n114 285.877
R16 out.n139 out.n135 285.877
R17 out.n139 out.n130 285.877
R18 out.n139 out.n125 285.877
R19 out.n140 out.n139 285.877
R20 out.n182 out.n178 285.877
R21 out.n182 out.n173 285.877
R22 out.n182 out.n168 285.877
R23 out.n183 out.n182 285.877
R24 out.n207 out.n203 285.877
R25 out.n207 out.n198 285.877
R26 out.n207 out.n193 285.877
R27 out.n208 out.n207 285.877
R28 out.n232 out.n228 285.877
R29 out.n232 out.n223 285.877
R30 out.n232 out.n218 285.877
R31 out.n233 out.n232 285.877
R32 out.n257 out.n253 285.877
R33 out.n257 out.n248 285.877
R34 out.n257 out.n243 285.877
R35 out.n258 out.n257 285.877
R36 out.n359 out.n358 248.305
R37 out.n370 out.n359 185
R38 out.n368 out.n360 185
R39 out.n366 out.n361 185
R40 out.n364 out.n362 185
R41 out.n363 out.t27 173.29
R42 out.n360 out.n359 136.8
R43 out.n361 out.n360 136.8
R44 out.n362 out.n361 136.8
R45 out.n288 out.n282 86.1871
R46 out.n289 out.n288 86.1871
R47 out.n303 out.n297 86.1871
R48 out.n304 out.n303 86.1871
R49 out.n318 out.n312 86.1871
R50 out.n319 out.n318 86.1871
R51 out.n334 out.n328 86.1871
R52 out.n335 out.n334 86.1871
R53 out.n349 out.n343 86.1871
R54 out.n350 out.n349 86.1871
R55 out.t27 out.n362 70.3005
R56 out.n64 out.n63 42.1782
R57 out.n89 out.n88 42.1782
R58 out.n114 out.n113 42.1782
R59 out.n139 out.n138 42.1782
R60 out.n182 out.n181 42.1782
R61 out.n207 out.n206 42.1782
R62 out.n232 out.n231 42.1782
R63 out.n257 out.n256 42.1782
R64 out.n39 out.n23 42.1782
R65 out.n41 out.n23 33.6553
R66 out.n63 out.n62 33.6553
R67 out.n88 out.n87 33.6553
R68 out.n113 out.n112 33.6553
R69 out.n138 out.n137 33.6553
R70 out.n181 out.n180 33.6553
R71 out.n206 out.n205 33.6553
R72 out.n231 out.n230 33.6553
R73 out.n256 out.n255 33.6553
R74 out.n37 out.n25 27.1064
R75 out.n35 out.n33 27.1064
R76 out.n30 out.n28 27.1064
R77 out.n59 out.n57 27.1064
R78 out.n54 out.n52 27.1064
R79 out.n66 out.n49 27.1064
R80 out.n84 out.n82 27.1064
R81 out.n79 out.n77 27.1064
R82 out.n91 out.n74 27.1064
R83 out.n109 out.n107 27.1064
R84 out.n104 out.n102 27.1064
R85 out.n116 out.n99 27.1064
R86 out.n134 out.n132 27.1064
R87 out.n129 out.n127 27.1064
R88 out.n141 out.n124 27.1064
R89 out.n177 out.n175 27.1064
R90 out.n172 out.n170 27.1064
R91 out.n184 out.n167 27.1064
R92 out.n202 out.n200 27.1064
R93 out.n197 out.n195 27.1064
R94 out.n209 out.n192 27.1064
R95 out.n227 out.n225 27.1064
R96 out.n222 out.n220 27.1064
R97 out.n234 out.n217 27.1064
R98 out.n252 out.n250 27.1064
R99 out.n247 out.n245 27.1064
R100 out.n259 out.n242 27.1064
R101 out.n292 out.n291 27.1064
R102 out.n286 out.n284 27.1064
R103 out.n307 out.n306 27.1064
R104 out.n301 out.n299 27.1064
R105 out.n322 out.n321 27.1064
R106 out.n316 out.n314 27.1064
R107 out.n338 out.n337 27.1064
R108 out.n332 out.n330 27.1064
R109 out.n353 out.n352 27.1064
R110 out.n347 out.n345 27.1064
R111 out.n371 out.n370 27.1064
R112 out.n370 out.n368 27.1064
R113 out.n368 out.n366 27.1064
R114 out.n366 out.n364 27.1064
R115 out.n373 out.n358 25.6774
R116 out.n287 out.n286 24.8637
R117 out.n302 out.n301 24.8637
R118 out.n317 out.n316 24.8637
R119 out.n333 out.n332 24.8637
R120 out.n348 out.n347 24.8637
R121 out.n26 out.n16 22.586
R122 out.n65 out.n12 22.586
R123 out.n90 out.n8 22.586
R124 out.n115 out.n4 22.586
R125 out.n140 out.n0 22.586
R126 out.n183 out.n159 22.586
R127 out.n208 out.n155 22.586
R128 out.n233 out.n151 22.586
R129 out.n258 out.n147 22.586
R130 out.n294 out.n282 21.9677
R131 out.n309 out.n297 21.9677
R132 out.n324 out.n312 21.9677
R133 out.n340 out.n328 21.9677
R134 out.n355 out.n343 21.9677
R135 out.n288 out.n287 20.1233
R136 out.n303 out.n302 20.1233
R137 out.n318 out.n317 20.1233
R138 out.n334 out.n333 20.1233
R139 out.n349 out.n348 20.1233
R140 out.n40 out.n25 13.2471
R141 out.n38 out.n35 13.2471
R142 out.n31 out.n30 13.2471
R143 out.n41 out.n40 13.2471
R144 out.n38 out.n37 13.2471
R145 out.n33 out.n31 13.2471
R146 out.n28 out.n26 13.2471
R147 out.n60 out.n59 13.2471
R148 out.n55 out.n54 13.2471
R149 out.n50 out.n49 13.2471
R150 out.n62 out.n60 13.2471
R151 out.n57 out.n55 13.2471
R152 out.n52 out.n50 13.2471
R153 out.n66 out.n65 13.2471
R154 out.n85 out.n84 13.2471
R155 out.n80 out.n79 13.2471
R156 out.n75 out.n74 13.2471
R157 out.n87 out.n85 13.2471
R158 out.n82 out.n80 13.2471
R159 out.n77 out.n75 13.2471
R160 out.n91 out.n90 13.2471
R161 out.n110 out.n109 13.2471
R162 out.n105 out.n104 13.2471
R163 out.n100 out.n99 13.2471
R164 out.n112 out.n110 13.2471
R165 out.n107 out.n105 13.2471
R166 out.n102 out.n100 13.2471
R167 out.n116 out.n115 13.2471
R168 out.n135 out.n134 13.2471
R169 out.n130 out.n129 13.2471
R170 out.n125 out.n124 13.2471
R171 out.n137 out.n135 13.2471
R172 out.n132 out.n130 13.2471
R173 out.n127 out.n125 13.2471
R174 out.n141 out.n140 13.2471
R175 out.n178 out.n177 13.2471
R176 out.n173 out.n172 13.2471
R177 out.n168 out.n167 13.2471
R178 out.n180 out.n178 13.2471
R179 out.n175 out.n173 13.2471
R180 out.n170 out.n168 13.2471
R181 out.n184 out.n183 13.2471
R182 out.n203 out.n202 13.2471
R183 out.n198 out.n197 13.2471
R184 out.n193 out.n192 13.2471
R185 out.n205 out.n203 13.2471
R186 out.n200 out.n198 13.2471
R187 out.n195 out.n193 13.2471
R188 out.n209 out.n208 13.2471
R189 out.n228 out.n227 13.2471
R190 out.n223 out.n222 13.2471
R191 out.n218 out.n217 13.2471
R192 out.n230 out.n228 13.2471
R193 out.n225 out.n223 13.2471
R194 out.n220 out.n218 13.2471
R195 out.n234 out.n233 13.2471
R196 out.n253 out.n252 13.2471
R197 out.n248 out.n247 13.2471
R198 out.n243 out.n242 13.2471
R199 out.n255 out.n253 13.2471
R200 out.n250 out.n248 13.2471
R201 out.n245 out.n243 13.2471
R202 out.n259 out.n258 13.2471
R203 out.n292 out.n282 12.6288
R204 out.n289 out.n284 12.6288
R205 out.n291 out.n289 12.6288
R206 out.n307 out.n297 12.6288
R207 out.n304 out.n299 12.6288
R208 out.n306 out.n304 12.6288
R209 out.n322 out.n312 12.6288
R210 out.n319 out.n314 12.6288
R211 out.n321 out.n319 12.6288
R212 out.n338 out.n328 12.6288
R213 out.n335 out.n330 12.6288
R214 out.n337 out.n335 12.6288
R215 out.n353 out.n343 12.6288
R216 out.n350 out.n345 12.6288
R217 out.n352 out.n350 12.6288
R218 out.n371 out.n358 9.39327
R219 out.n28 out.n27 9.3005
R220 out.n30 out.n29 9.3005
R221 out.n33 out.n32 9.3005
R222 out.n35 out.n34 9.3005
R223 out.n37 out.n36 9.3005
R224 out.n25 out.n24 9.3005
R225 out.n42 out.n41 9.3005
R226 out.n62 out.n61 9.3005
R227 out.n59 out.n58 9.3005
R228 out.n57 out.n56 9.3005
R229 out.n54 out.n53 9.3005
R230 out.n52 out.n51 9.3005
R231 out.n49 out.n48 9.3005
R232 out.n67 out.n66 9.3005
R233 out.n87 out.n86 9.3005
R234 out.n84 out.n83 9.3005
R235 out.n82 out.n81 9.3005
R236 out.n79 out.n78 9.3005
R237 out.n77 out.n76 9.3005
R238 out.n74 out.n73 9.3005
R239 out.n92 out.n91 9.3005
R240 out.n112 out.n111 9.3005
R241 out.n109 out.n108 9.3005
R242 out.n107 out.n106 9.3005
R243 out.n104 out.n103 9.3005
R244 out.n102 out.n101 9.3005
R245 out.n99 out.n98 9.3005
R246 out.n117 out.n116 9.3005
R247 out.n137 out.n136 9.3005
R248 out.n134 out.n133 9.3005
R249 out.n132 out.n131 9.3005
R250 out.n129 out.n128 9.3005
R251 out.n127 out.n126 9.3005
R252 out.n124 out.n123 9.3005
R253 out.n142 out.n141 9.3005
R254 out.n180 out.n179 9.3005
R255 out.n177 out.n176 9.3005
R256 out.n175 out.n174 9.3005
R257 out.n172 out.n171 9.3005
R258 out.n170 out.n169 9.3005
R259 out.n167 out.n166 9.3005
R260 out.n185 out.n184 9.3005
R261 out.n205 out.n204 9.3005
R262 out.n202 out.n201 9.3005
R263 out.n200 out.n199 9.3005
R264 out.n197 out.n196 9.3005
R265 out.n195 out.n194 9.3005
R266 out.n192 out.n191 9.3005
R267 out.n210 out.n209 9.3005
R268 out.n230 out.n229 9.3005
R269 out.n227 out.n226 9.3005
R270 out.n225 out.n224 9.3005
R271 out.n222 out.n221 9.3005
R272 out.n220 out.n219 9.3005
R273 out.n217 out.n216 9.3005
R274 out.n235 out.n234 9.3005
R275 out.n255 out.n254 9.3005
R276 out.n252 out.n251 9.3005
R277 out.n250 out.n249 9.3005
R278 out.n247 out.n246 9.3005
R279 out.n245 out.n244 9.3005
R280 out.n242 out.n241 9.3005
R281 out.n260 out.n259 9.3005
R282 out.n293 out.n292 9.3005
R283 out.n291 out.n290 9.3005
R284 out.n284 out.n283 9.3005
R285 out.n286 out.n285 9.3005
R286 out.n308 out.n307 9.3005
R287 out.n306 out.n305 9.3005
R288 out.n299 out.n298 9.3005
R289 out.n301 out.n300 9.3005
R290 out.n323 out.n322 9.3005
R291 out.n321 out.n320 9.3005
R292 out.n314 out.n313 9.3005
R293 out.n316 out.n315 9.3005
R294 out.n339 out.n338 9.3005
R295 out.n337 out.n336 9.3005
R296 out.n330 out.n329 9.3005
R297 out.n332 out.n331 9.3005
R298 out.n354 out.n353 9.3005
R299 out.n352 out.n351 9.3005
R300 out.n345 out.n344 9.3005
R301 out.n347 out.n346 9.3005
R302 out.n372 out.n371 9.3005
R303 out.n370 out.n369 9.3005
R304 out.n368 out.n367 9.3005
R305 out.n366 out.n365 9.3005
R306 out.n364 out.n363 6.33766
R307 out.n287 out.n278 4.94917
R308 out.n302 out.n275 4.94917
R309 out.n317 out.n272 4.94917
R310 out.n333 out.n269 4.94917
R311 out.n348 out.n266 4.94917
R312 out.n374 out.n357 4.5005
R313 out.n374 out.n264 4.5005
R314 out.n374 out.n373 4.5005
R315 out.n374 out.n263 4.5005
R316 out.n356 out.n342 4.5005
R317 out.n356 out.n267 4.5005
R318 out.n356 out.n355 4.5005
R319 out.n356 out.n266 4.5005
R320 out.n341 out.n327 4.5005
R321 out.n341 out.n270 4.5005
R322 out.n341 out.n340 4.5005
R323 out.n341 out.n269 4.5005
R324 out.n325 out.n311 4.5005
R325 out.n325 out.n273 4.5005
R326 out.n325 out.n324 4.5005
R327 out.n325 out.n272 4.5005
R328 out.n310 out.n296 4.5005
R329 out.n310 out.n276 4.5005
R330 out.n310 out.n309 4.5005
R331 out.n310 out.n275 4.5005
R332 out.n295 out.n281 4.5005
R333 out.n295 out.n279 4.5005
R334 out.n295 out.n294 4.5005
R335 out.n295 out.n278 4.5005
R336 out.n262 out.n150 4.5005
R337 out.n262 out.n239 4.5005
R338 out.n262 out.n149 4.5005
R339 out.n262 out.n240 4.5005
R340 out.n262 out.n148 4.5005
R341 out.n262 out.n261 4.5005
R342 out.n262 out.n147 4.5005
R343 out.n237 out.n154 4.5005
R344 out.n237 out.n214 4.5005
R345 out.n237 out.n153 4.5005
R346 out.n237 out.n215 4.5005
R347 out.n237 out.n152 4.5005
R348 out.n237 out.n236 4.5005
R349 out.n237 out.n151 4.5005
R350 out.n212 out.n158 4.5005
R351 out.n212 out.n189 4.5005
R352 out.n212 out.n157 4.5005
R353 out.n212 out.n190 4.5005
R354 out.n212 out.n156 4.5005
R355 out.n212 out.n211 4.5005
R356 out.n212 out.n155 4.5005
R357 out.n187 out.n162 4.5005
R358 out.n187 out.n164 4.5005
R359 out.n187 out.n161 4.5005
R360 out.n187 out.n165 4.5005
R361 out.n187 out.n160 4.5005
R362 out.n187 out.n186 4.5005
R363 out.n187 out.n159 4.5005
R364 out.n144 out.n3 4.5005
R365 out.n144 out.n121 4.5005
R366 out.n144 out.n2 4.5005
R367 out.n144 out.n122 4.5005
R368 out.n144 out.n1 4.5005
R369 out.n144 out.n143 4.5005
R370 out.n144 out.n0 4.5005
R371 out.n119 out.n7 4.5005
R372 out.n119 out.n96 4.5005
R373 out.n119 out.n6 4.5005
R374 out.n119 out.n97 4.5005
R375 out.n119 out.n5 4.5005
R376 out.n119 out.n118 4.5005
R377 out.n119 out.n4 4.5005
R378 out.n94 out.n11 4.5005
R379 out.n94 out.n71 4.5005
R380 out.n94 out.n10 4.5005
R381 out.n94 out.n72 4.5005
R382 out.n94 out.n9 4.5005
R383 out.n94 out.n93 4.5005
R384 out.n94 out.n8 4.5005
R385 out.n69 out.n15 4.5005
R386 out.n69 out.n46 4.5005
R387 out.n69 out.n14 4.5005
R388 out.n69 out.n47 4.5005
R389 out.n69 out.n13 4.5005
R390 out.n69 out.n68 4.5005
R391 out.n69 out.n12 4.5005
R392 out.n44 out.n20 4.5005
R393 out.n44 out.n19 4.5005
R394 out.n44 out.n21 4.5005
R395 out.n44 out.n17 4.5005
R396 out.n44 out.n22 4.5005
R397 out.n44 out.n16 4.5005
R398 out.n44 out.n43 4.5005
R399 out.n288 out.t3 3.91803
R400 out.n288 out.t11 3.91803
R401 out.n303 out.t28 3.91803
R402 out.n303 out.t7 3.91803
R403 out.n318 out.t1 3.91803
R404 out.n318 out.t12 3.91803
R405 out.n334 out.t14 3.91803
R406 out.n334 out.t10 3.91803
R407 out.n349 out.t6 3.91803
R408 out.n349 out.t13 3.91803
R409 out.n39 out.t0 3.58175
R410 out.n39 out.t9 3.58175
R411 out.n64 out.t17 3.58175
R412 out.n64 out.t15 3.58175
R413 out.n89 out.t22 3.58175
R414 out.n89 out.t20 3.58175
R415 out.n114 out.t2 3.58175
R416 out.n114 out.t5 3.58175
R417 out.n139 out.t4 3.58175
R418 out.n139 out.t24 3.58175
R419 out.n182 out.t25 3.58175
R420 out.n182 out.t23 3.58175
R421 out.n207 out.t18 3.58175
R422 out.n207 out.t8 3.58175
R423 out.n232 out.t21 3.58175
R424 out.n232 out.t16 3.58175
R425 out.n257 out.t19 3.58175
R426 out.n257 out.t26 3.58175
R427 out.n374 out.n265 2.229
R428 out.n356 out.n268 2.229
R429 out.n341 out.n271 2.229
R430 out.n325 out.n274 2.229
R431 out.n310 out.n277 2.229
R432 out.n295 out.n280 2.229
R433 out.n262 out.n238 2.229
R434 out.n237 out.n213 2.229
R435 out.n212 out.n188 2.229
R436 out.n187 out.n163 2.229
R437 out.n144 out.n120 2.229
R438 out.n119 out.n95 2.229
R439 out.n94 out.n70 2.229
R440 out.n69 out.n45 2.229
R441 out.n44 out.n18 2.229
R442 out.n363 out.n263 1.00351
R443 out.n63 out.n47 0.745877
R444 out.n88 out.n72 0.745877
R445 out.n113 out.n97 0.745877
R446 out.n138 out.n122 0.745877
R447 out.n181 out.n165 0.745877
R448 out.n206 out.n190 0.745877
R449 out.n231 out.n215 0.745877
R450 out.n256 out.n240 0.745877
R451 out.n43 out.n23 0.745877
R452 out.n375 out.n374 0.338833
R453 out.n375 out.n262 0.318
R454 out.n326 out.n146 0.144419
R455 out.n374 out.n356 0.1005
R456 out.n356 out.n341 0.1005
R457 out.n325 out.n310 0.1005
R458 out.n310 out.n295 0.1005
R459 out.n326 out.n325 0.0933125
R460 out.n376 out.n146 0.0901133
R461 out.n34 out.n21 0.0838333
R462 out.n32 out.n17 0.0838333
R463 out.n53 out.n15 0.0838333
R464 out.n51 out.n13 0.0838333
R465 out.n78 out.n11 0.0838333
R466 out.n76 out.n9 0.0838333
R467 out.n103 out.n7 0.0838333
R468 out.n101 out.n5 0.0838333
R469 out.n128 out.n3 0.0838333
R470 out.n126 out.n1 0.0838333
R471 out.n171 out.n162 0.0838333
R472 out.n169 out.n160 0.0838333
R473 out.n196 out.n158 0.0838333
R474 out.n194 out.n156 0.0838333
R475 out.n221 out.n154 0.0838333
R476 out.n219 out.n152 0.0838333
R477 out.n246 out.n150 0.0838333
R478 out.n244 out.n148 0.0838333
R479 out.n283 out.n281 0.0838333
R480 out.n285 out.n278 0.0838333
R481 out.n298 out.n296 0.0838333
R482 out.n300 out.n275 0.0838333
R483 out.n313 out.n311 0.0838333
R484 out.n315 out.n272 0.0838333
R485 out.n329 out.n327 0.0838333
R486 out.n331 out.n269 0.0838333
R487 out.n344 out.n342 0.0838333
R488 out.n346 out.n266 0.0838333
R489 out.n367 out.n357 0.0838333
R490 out.n365 out.n263 0.0838333
R491 out.n36 out.n19 0.0727222
R492 out.n29 out.n22 0.0727222
R493 out.n56 out.n46 0.0727222
R494 out.n68 out.n48 0.0727222
R495 out.n81 out.n71 0.0727222
R496 out.n93 out.n73 0.0727222
R497 out.n106 out.n96 0.0727222
R498 out.n118 out.n98 0.0727222
R499 out.n131 out.n121 0.0727222
R500 out.n143 out.n123 0.0727222
R501 out.n174 out.n164 0.0727222
R502 out.n186 out.n166 0.0727222
R503 out.n199 out.n189 0.0727222
R504 out.n211 out.n191 0.0727222
R505 out.n224 out.n214 0.0727222
R506 out.n236 out.n216 0.0727222
R507 out.n249 out.n239 0.0727222
R508 out.n261 out.n241 0.0727222
R509 out.n290 out.n279 0.0727222
R510 out.n305 out.n276 0.0727222
R511 out.n320 out.n273 0.0727222
R512 out.n336 out.n270 0.0727222
R513 out.n351 out.n267 0.0727222
R514 out.n369 out.n264 0.0727222
R515 out.n262 out.n237 0.0671667
R516 out.n237 out.n212 0.0671667
R517 out.n212 out.n187 0.0671667
R518 out.n144 out.n119 0.0671667
R519 out.n119 out.n94 0.0671667
R520 out.n94 out.n69 0.0671667
R521 out.n69 out.n44 0.0671667
R522 out.n24 out.n20 0.0616111
R523 out.n27 out.n16 0.0616111
R524 out.n58 out.n14 0.0616111
R525 out.n67 out.n12 0.0616111
R526 out.n83 out.n10 0.0616111
R527 out.n92 out.n8 0.0616111
R528 out.n108 out.n6 0.0616111
R529 out.n117 out.n4 0.0616111
R530 out.n133 out.n2 0.0616111
R531 out.n142 out.n0 0.0616111
R532 out.n176 out.n161 0.0616111
R533 out.n185 out.n159 0.0616111
R534 out.n201 out.n157 0.0616111
R535 out.n210 out.n155 0.0616111
R536 out.n226 out.n153 0.0616111
R537 out.n235 out.n151 0.0616111
R538 out.n251 out.n149 0.0616111
R539 out.n260 out.n147 0.0616111
R540 out.n294 out.n293 0.0616111
R541 out.n309 out.n308 0.0616111
R542 out.n324 out.n323 0.0616111
R543 out.n340 out.n339 0.0616111
R544 out.n355 out.n354 0.0616111
R545 out.n373 out.n372 0.0616111
R546 out.n377 out.n376 0.05878
R547 out.n34 out.n18 0.0505653
R548 out.n32 out.n18 0.0505653
R549 out.n53 out.n45 0.0505653
R550 out.n51 out.n45 0.0505653
R551 out.n78 out.n70 0.0505653
R552 out.n76 out.n70 0.0505653
R553 out.n103 out.n95 0.0505653
R554 out.n101 out.n95 0.0505653
R555 out.n128 out.n120 0.0505653
R556 out.n126 out.n120 0.0505653
R557 out.n171 out.n163 0.0505653
R558 out.n169 out.n163 0.0505653
R559 out.n196 out.n188 0.0505653
R560 out.n194 out.n188 0.0505653
R561 out.n221 out.n213 0.0505653
R562 out.n219 out.n213 0.0505653
R563 out.n246 out.n238 0.0505653
R564 out.n244 out.n238 0.0505653
R565 out.n283 out.n280 0.0505653
R566 out.n285 out.n280 0.0505653
R567 out.n298 out.n277 0.0505653
R568 out.n300 out.n277 0.0505653
R569 out.n313 out.n274 0.0505653
R570 out.n315 out.n274 0.0505653
R571 out.n329 out.n271 0.0505653
R572 out.n331 out.n271 0.0505653
R573 out.n344 out.n268 0.0505653
R574 out.n346 out.n268 0.0505653
R575 out.n367 out.n265 0.0505653
R576 out.n365 out.n265 0.0505653
R577 out.n43 out.n42 0.0505
R578 out.n61 out.n47 0.0505
R579 out.n86 out.n72 0.0505
R580 out.n111 out.n97 0.0505
R581 out.n136 out.n122 0.0505
R582 out.n179 out.n165 0.0505
R583 out.n204 out.n190 0.0505
R584 out.n229 out.n215 0.0505
R585 out.n254 out.n240 0.0505
R586 out.n145 out.n144 0.0459167
R587 out.n42 out.n20 0.0393889
R588 out.n61 out.n14 0.0393889
R589 out.n86 out.n10 0.0393889
R590 out.n111 out.n6 0.0393889
R591 out.n136 out.n2 0.0393889
R592 out.n179 out.n161 0.0393889
R593 out.n204 out.n157 0.0393889
R594 out.n229 out.n153 0.0393889
R595 out.n254 out.n149 0.0393889
R596 out.n24 out.n19 0.0282778
R597 out.n27 out.n22 0.0282778
R598 out.n58 out.n46 0.0282778
R599 out.n68 out.n67 0.0282778
R600 out.n83 out.n71 0.0282778
R601 out.n93 out.n92 0.0282778
R602 out.n108 out.n96 0.0282778
R603 out.n118 out.n117 0.0282778
R604 out.n133 out.n121 0.0282778
R605 out.n143 out.n142 0.0282778
R606 out.n176 out.n164 0.0282778
R607 out.n186 out.n185 0.0282778
R608 out.n201 out.n189 0.0282778
R609 out.n211 out.n210 0.0282778
R610 out.n226 out.n214 0.0282778
R611 out.n236 out.n235 0.0282778
R612 out.n251 out.n239 0.0282778
R613 out.n261 out.n260 0.0282778
R614 out.n293 out.n279 0.0282778
R615 out.n308 out.n276 0.0282778
R616 out.n323 out.n273 0.0282778
R617 out.n339 out.n270 0.0282778
R618 out.n354 out.n267 0.0282778
R619 out.n372 out.n264 0.0282778
R620 out out.n377 0.0271312
R621 out.n187 out.n145 0.02175
R622 out.n36 out.n21 0.0171667
R623 out.n29 out.n17 0.0171667
R624 out.n56 out.n15 0.0171667
R625 out.n48 out.n13 0.0171667
R626 out.n81 out.n11 0.0171667
R627 out.n73 out.n9 0.0171667
R628 out.n106 out.n7 0.0171667
R629 out.n98 out.n5 0.0171667
R630 out.n131 out.n3 0.0171667
R631 out.n123 out.n1 0.0171667
R632 out.n174 out.n162 0.0171667
R633 out.n166 out.n160 0.0171667
R634 out.n199 out.n158 0.0171667
R635 out.n191 out.n156 0.0171667
R636 out.n224 out.n154 0.0171667
R637 out.n216 out.n152 0.0171667
R638 out.n249 out.n150 0.0171667
R639 out.n241 out.n148 0.0171667
R640 out.n290 out.n281 0.0171667
R641 out.n305 out.n296 0.0171667
R642 out.n320 out.n311 0.0171667
R643 out.n336 out.n327 0.0171667
R644 out.n351 out.n342 0.0171667
R645 out.n369 out.n357 0.0171667
R646 out.n377 out.n145 0.0171459
R647 out.n146 out 0.0161667
R648 out.n376 out.n375 0.0152619
R649 out.n341 out.n326 0.0076875
R650 en.n0 en.t1 330.18
R651 en.n0 en.t0 310.478
R652 en en.n0 3.56599
R653 in.n0 in.t1 262.637
R654 in.n0 in.t0 243.643
R655 in in.n0 3.51531
R656 VAPWR.n126 VAPWR.n125 585
R657 VAPWR.n113 VAPWR.n112 585
R658 VAPWR.n121 VAPWR.n115 585
R659 VAPWR.n120 VAPWR.n116 585
R660 VAPWR.n119 VAPWR.n117 585
R661 VAPWR.n102 VAPWR.n101 585
R662 VAPWR.n83 VAPWR.n82 585
R663 VAPWR.n97 VAPWR.n85 585
R664 VAPWR.n96 VAPWR.n86 585
R665 VAPWR.n95 VAPWR.n87 585
R666 VAPWR.n89 VAPWR.n88 585
R667 VAPWR.n91 VAPWR.n90 585
R668 VAPWR.n62 VAPWR.n61 585
R669 VAPWR.n40 VAPWR.n39 585
R670 VAPWR.n57 VAPWR.n42 585
R671 VAPWR.n56 VAPWR.n43 585
R672 VAPWR.n55 VAPWR.n44 585
R673 VAPWR.n47 VAPWR.n45 585
R674 VAPWR.n51 VAPWR.n48 585
R675 VAPWR.n50 VAPWR.n49 585
R676 VAPWR.n299 VAPWR.n298 585
R677 VAPWR.n274 VAPWR.n273 585
R678 VAPWR.n294 VAPWR.n276 585
R679 VAPWR.n293 VAPWR.n277 585
R680 VAPWR.n292 VAPWR.n278 585
R681 VAPWR.n281 VAPWR.n279 585
R682 VAPWR.n288 VAPWR.n282 585
R683 VAPWR.n287 VAPWR.n283 585
R684 VAPWR.n286 VAPWR.n284 585
R685 VAPWR.n454 VAPWR.n453 585
R686 VAPWR.n429 VAPWR.n428 585
R687 VAPWR.n449 VAPWR.n431 585
R688 VAPWR.n448 VAPWR.n432 585
R689 VAPWR.n447 VAPWR.n433 585
R690 VAPWR.n436 VAPWR.n434 585
R691 VAPWR.n443 VAPWR.n437 585
R692 VAPWR.n442 VAPWR.n438 585
R693 VAPWR.n441 VAPWR.n439 585
R694 VAPWR.n127 VAPWR.n126 563.145
R695 VAPWR.n103 VAPWR.n102 563.145
R696 VAPWR.n63 VAPWR.n62 563.145
R697 VAPWR.n300 VAPWR.n299 563.145
R698 VAPWR.n455 VAPWR.n454 563.145
R699 VAPWR.n118 VAPWR.t47 385.421
R700 VAPWR.n92 VAPWR.t1 385.286
R701 VAPWR.t51 VAPWR.n46 385.277
R702 VAPWR.n285 VAPWR.t9 385.274
R703 VAPWR.n440 VAPWR.t43 385.274
R704 VAPWR.n902 VAPWR.n152 316.351
R705 VAPWR.n187 VAPWR.n182 316.351
R706 VAPWR.n550 VAPWR.n461 316.351
R707 VAPWR.n553 VAPWR.n459 316.351
R708 VAPWR.n126 VAPWR.n112 229.201
R709 VAPWR.n115 VAPWR.n112 229.201
R710 VAPWR.n116 VAPWR.n115 229.201
R711 VAPWR.n117 VAPWR.n116 229.201
R712 VAPWR.n102 VAPWR.n82 229.201
R713 VAPWR.n85 VAPWR.n82 229.201
R714 VAPWR.n86 VAPWR.n85 229.201
R715 VAPWR.n87 VAPWR.n86 229.201
R716 VAPWR.n89 VAPWR.n87 229.201
R717 VAPWR.n90 VAPWR.n89 229.201
R718 VAPWR.n62 VAPWR.n39 229.201
R719 VAPWR.n42 VAPWR.n39 229.201
R720 VAPWR.n43 VAPWR.n42 229.201
R721 VAPWR.n44 VAPWR.n43 229.201
R722 VAPWR.n47 VAPWR.n44 229.201
R723 VAPWR.n48 VAPWR.n47 229.201
R724 VAPWR.n49 VAPWR.n48 229.201
R725 VAPWR.n299 VAPWR.n273 229.201
R726 VAPWR.n276 VAPWR.n273 229.201
R727 VAPWR.n277 VAPWR.n276 229.201
R728 VAPWR.n278 VAPWR.n277 229.201
R729 VAPWR.n281 VAPWR.n278 229.201
R730 VAPWR.n282 VAPWR.n281 229.201
R731 VAPWR.n283 VAPWR.n282 229.201
R732 VAPWR.n284 VAPWR.n283 229.201
R733 VAPWR.n454 VAPWR.n428 229.201
R734 VAPWR.n431 VAPWR.n428 229.201
R735 VAPWR.n432 VAPWR.n431 229.201
R736 VAPWR.n433 VAPWR.n432 229.201
R737 VAPWR.n436 VAPWR.n433 229.201
R738 VAPWR.n437 VAPWR.n436 229.201
R739 VAPWR.n438 VAPWR.n437 229.201
R740 VAPWR.n439 VAPWR.n438 229.201
R741 VAPWR.n952 VAPWR.t7 222.975
R742 VAPWR.n144 VAPWR.t49 222.975
R743 VAPWR.n965 VAPWR.t45 222.975
R744 VAPWR.n554 VAPWR.n553 185
R745 VAPWR.n553 VAPWR.n552 185
R746 VAPWR.n425 VAPWR.n424 185
R747 VAPWR.n551 VAPWR.n424 185
R748 VAPWR.n560 VAPWR.n559 185
R749 VAPWR.n561 VAPWR.n560 185
R750 VAPWR.n417 VAPWR.n416 185
R751 VAPWR.n418 VAPWR.n417 185
R752 VAPWR.n570 VAPWR.n569 185
R753 VAPWR.n569 VAPWR.t40 185
R754 VAPWR.n413 VAPWR.n412 185
R755 VAPWR.n412 VAPWR.n411 185
R756 VAPWR.n576 VAPWR.n575 185
R757 VAPWR.n577 VAPWR.n576 185
R758 VAPWR.n404 VAPWR.n403 185
R759 VAPWR.n405 VAPWR.n404 185
R760 VAPWR.n587 VAPWR.n586 185
R761 VAPWR.n586 VAPWR.n585 185
R762 VAPWR.n400 VAPWR.n399 185
R763 VAPWR.n399 VAPWR.n398 185
R764 VAPWR.n593 VAPWR.n592 185
R765 VAPWR.n594 VAPWR.n593 185
R766 VAPWR.n391 VAPWR.n390 185
R767 VAPWR.n392 VAPWR.n391 185
R768 VAPWR.n604 VAPWR.n603 185
R769 VAPWR.n603 VAPWR.n602 185
R770 VAPWR.n387 VAPWR.n386 185
R771 VAPWR.n386 VAPWR.n384 185
R772 VAPWR.n609 VAPWR.n608 185
R773 VAPWR.n610 VAPWR.n609 185
R774 VAPWR.n378 VAPWR.n377 185
R775 VAPWR.n385 VAPWR.n378 185
R776 VAPWR.n621 VAPWR.n620 185
R777 VAPWR.n620 VAPWR.n619 185
R778 VAPWR.n375 VAPWR.n374 185
R779 VAPWR.n618 VAPWR.n374 185
R780 VAPWR.n628 VAPWR.n627 185
R781 VAPWR.n629 VAPWR.n628 185
R782 VAPWR.n367 VAPWR.n366 185
R783 VAPWR.n373 VAPWR.n367 185
R784 VAPWR.n640 VAPWR.n639 185
R785 VAPWR.n639 VAPWR.n638 185
R786 VAPWR.n364 VAPWR.n363 185
R787 VAPWR.n637 VAPWR.n363 185
R788 VAPWR.n647 VAPWR.n646 185
R789 VAPWR.n648 VAPWR.n647 185
R790 VAPWR.n356 VAPWR.n355 185
R791 VAPWR.n357 VAPWR.n356 185
R792 VAPWR.n657 VAPWR.n656 185
R793 VAPWR.n656 VAPWR.t22 185
R794 VAPWR.n353 VAPWR.n352 185
R795 VAPWR.n352 VAPWR.n351 185
R796 VAPWR.n663 VAPWR.n662 185
R797 VAPWR.n664 VAPWR.n663 185
R798 VAPWR.n344 VAPWR.n343 185
R799 VAPWR.n345 VAPWR.n344 185
R800 VAPWR.n674 VAPWR.n673 185
R801 VAPWR.n673 VAPWR.n672 185
R802 VAPWR.n340 VAPWR.n339 185
R803 VAPWR.n339 VAPWR.n338 185
R804 VAPWR.n680 VAPWR.n679 185
R805 VAPWR.n681 VAPWR.n680 185
R806 VAPWR.n329 VAPWR.n328 185
R807 VAPWR.n330 VAPWR.n329 185
R808 VAPWR.n692 VAPWR.n691 185
R809 VAPWR.n691 VAPWR.n690 185
R810 VAPWR.n325 VAPWR.n324 185
R811 VAPWR.n324 VAPWR.n323 185
R812 VAPWR.n697 VAPWR.n696 185
R813 VAPWR.n698 VAPWR.n697 185
R814 VAPWR.n317 VAPWR.n316 185
R815 VAPWR.n699 VAPWR.n317 185
R816 VAPWR.n710 VAPWR.n709 185
R817 VAPWR.n709 VAPWR.n708 185
R818 VAPWR.n313 VAPWR.n312 185
R819 VAPWR.n707 VAPWR.n312 185
R820 VAPWR.n716 VAPWR.n715 185
R821 VAPWR.n717 VAPWR.n716 185
R822 VAPWR.n304 VAPWR.n303 185
R823 VAPWR.n718 VAPWR.n304 185
R824 VAPWR.n732 VAPWR.n731 185
R825 VAPWR.n731 VAPWR.n730 185
R826 VAPWR.n270 VAPWR.n269 185
R827 VAPWR.n729 VAPWR.n269 185
R828 VAPWR.n738 VAPWR.n737 185
R829 VAPWR.n738 VAPWR.n267 185
R830 VAPWR.n739 VAPWR.n2 185
R831 VAPWR.n740 VAPWR.n739 185
R832 VAPWR.n1039 VAPWR.n3 185
R833 VAPWR.n741 VAPWR.n3 185
R834 VAPWR.n1038 VAPWR.n4 185
R835 VAPWR.n742 VAPWR.n4 185
R836 VAPWR.n1037 VAPWR.n5 185
R837 VAPWR.n261 VAPWR.n5 185
R838 VAPWR.n750 VAPWR.n6 185
R839 VAPWR.n751 VAPWR.n750 185
R840 VAPWR.n1032 VAPWR.n9 185
R841 VAPWR.n752 VAPWR.n9 185
R842 VAPWR.n1031 VAPWR.n10 185
R843 VAPWR.n753 VAPWR.n10 185
R844 VAPWR.n1030 VAPWR.n11 185
R845 VAPWR.n255 VAPWR.n11 185
R846 VAPWR.n761 VAPWR.n12 185
R847 VAPWR.n762 VAPWR.n761 185
R848 VAPWR.n1025 VAPWR.n15 185
R849 VAPWR.n763 VAPWR.n15 185
R850 VAPWR.n1024 VAPWR.n16 185
R851 VAPWR.n764 VAPWR.n16 185
R852 VAPWR.n1023 VAPWR.n17 185
R853 VAPWR.t62 VAPWR.n17 185
R854 VAPWR.n772 VAPWR.n18 185
R855 VAPWR.n773 VAPWR.n772 185
R856 VAPWR.n1018 VAPWR.n21 185
R857 VAPWR.n774 VAPWR.n21 185
R858 VAPWR.n1017 VAPWR.n22 185
R859 VAPWR.n776 VAPWR.n22 185
R860 VAPWR.n1016 VAPWR.n23 185
R861 VAPWR.n775 VAPWR.n23 185
R862 VAPWR.n784 VAPWR.n24 185
R863 VAPWR.n785 VAPWR.n784 185
R864 VAPWR.n1011 VAPWR.n27 185
R865 VAPWR.n786 VAPWR.n27 185
R866 VAPWR.n1010 VAPWR.n28 185
R867 VAPWR.n788 VAPWR.n28 185
R868 VAPWR.n1009 VAPWR.n29 185
R869 VAPWR.n787 VAPWR.n29 185
R870 VAPWR.n796 VAPWR.n30 185
R871 VAPWR.n797 VAPWR.n796 185
R872 VAPWR.n1005 VAPWR.n33 185
R873 VAPWR.n798 VAPWR.n33 185
R874 VAPWR.n1004 VAPWR.n34 185
R875 VAPWR.n799 VAPWR.n34 185
R876 VAPWR.n1003 VAPWR.n35 185
R877 VAPWR.n234 VAPWR.n35 185
R878 VAPWR.n807 VAPWR.n36 185
R879 VAPWR.n808 VAPWR.n807 185
R880 VAPWR.n999 VAPWR.n66 185
R881 VAPWR.n809 VAPWR.n66 185
R882 VAPWR.n998 VAPWR.n67 185
R883 VAPWR.n810 VAPWR.n67 185
R884 VAPWR.n227 VAPWR.n68 185
R885 VAPWR.n228 VAPWR.n227 185
R886 VAPWR.n994 VAPWR.n70 185
R887 VAPWR.n818 VAPWR.n70 185
R888 VAPWR.n993 VAPWR.n71 185
R889 VAPWR.n819 VAPWR.n71 185
R890 VAPWR.n992 VAPWR.n72 185
R891 VAPWR.n820 VAPWR.n72 185
R892 VAPWR.n220 VAPWR.n73 185
R893 VAPWR.n221 VAPWR.n220 185
R894 VAPWR.n988 VAPWR.n76 185
R895 VAPWR.n828 VAPWR.n76 185
R896 VAPWR.n987 VAPWR.n77 185
R897 VAPWR.n829 VAPWR.n77 185
R898 VAPWR.n986 VAPWR.n78 185
R899 VAPWR.n830 VAPWR.n78 185
R900 VAPWR.n213 VAPWR.n79 185
R901 VAPWR.n214 VAPWR.n213 185
R902 VAPWR.n981 VAPWR.n106 185
R903 VAPWR.n838 VAPWR.n106 185
R904 VAPWR.n980 VAPWR.n107 185
R905 VAPWR.n839 VAPWR.n107 185
R906 VAPWR.n979 VAPWR.n108 185
R907 VAPWR.n842 VAPWR.n108 185
R908 VAPWR.n840 VAPWR.n109 185
R909 VAPWR.n841 VAPWR.n840 185
R910 VAPWR.n975 VAPWR.n130 185
R911 VAPWR.n850 VAPWR.n130 185
R912 VAPWR.n974 VAPWR.n131 185
R913 VAPWR.n851 VAPWR.n131 185
R914 VAPWR.n973 VAPWR.n132 185
R915 VAPWR.n852 VAPWR.n132 185
R916 VAPWR.n201 VAPWR.n133 185
R917 VAPWR.n202 VAPWR.n201 185
R918 VAPWR.n969 VAPWR.n135 185
R919 VAPWR.n860 VAPWR.n135 185
R920 VAPWR.n968 VAPWR.n136 185
R921 VAPWR.n861 VAPWR.n136 185
R922 VAPWR.n967 VAPWR.n137 185
R923 VAPWR.n862 VAPWR.n137 185
R924 VAPWR.n194 VAPWR.n138 185
R925 VAPWR.n195 VAPWR.n194 185
R926 VAPWR.n962 VAPWR.n140 185
R927 VAPWR.n870 VAPWR.n140 185
R928 VAPWR.n961 VAPWR.n141 185
R929 VAPWR.n871 VAPWR.n141 185
R930 VAPWR.n960 VAPWR.n142 185
R931 VAPWR.n872 VAPWR.n142 185
R932 VAPWR.n188 VAPWR.n143 185
R933 VAPWR.t48 VAPWR.n188 185
R934 VAPWR.n956 VAPWR.n146 185
R935 VAPWR.n880 VAPWR.n146 185
R936 VAPWR.n955 VAPWR.n147 185
R937 VAPWR.n881 VAPWR.n147 185
R938 VAPWR.n954 VAPWR.n148 185
R939 VAPWR.n904 VAPWR.n148 185
R940 VAPWR.n902 VAPWR.n149 185
R941 VAPWR.n903 VAPWR.n902 185
R942 VAPWR.n459 VAPWR.n458 185
R943 VAPWR.n489 VAPWR.n487 185
R944 VAPWR.n490 VAPWR.n485 185
R945 VAPWR.n490 VAPWR.n460 185
R946 VAPWR.n493 VAPWR.n492 185
R947 VAPWR.n483 VAPWR.n482 185
R948 VAPWR.n498 VAPWR.n497 185
R949 VAPWR.n500 VAPWR.n481 185
R950 VAPWR.n503 VAPWR.n502 185
R951 VAPWR.n479 VAPWR.n478 185
R952 VAPWR.n508 VAPWR.n507 185
R953 VAPWR.n510 VAPWR.n477 185
R954 VAPWR.n513 VAPWR.n512 185
R955 VAPWR.n475 VAPWR.n474 185
R956 VAPWR.n518 VAPWR.n517 185
R957 VAPWR.n520 VAPWR.n473 185
R958 VAPWR.n523 VAPWR.n522 185
R959 VAPWR.n471 VAPWR.n470 185
R960 VAPWR.n528 VAPWR.n527 185
R961 VAPWR.n530 VAPWR.n469 185
R962 VAPWR.n533 VAPWR.n532 185
R963 VAPWR.n467 VAPWR.n466 185
R964 VAPWR.n539 VAPWR.n538 185
R965 VAPWR.n541 VAPWR.n465 185
R966 VAPWR.n542 VAPWR.n464 185
R967 VAPWR.n545 VAPWR.n544 185
R968 VAPWR.n462 VAPWR.n461 185
R969 VAPWR.n461 VAPWR.n460 185
R970 VAPWR.n187 VAPWR.n183 185
R971 VAPWR.n903 VAPWR.n187 185
R972 VAPWR.n906 VAPWR.n905 185
R973 VAPWR.n905 VAPWR.n904 185
R974 VAPWR.n186 VAPWR.n185 185
R975 VAPWR.n881 VAPWR.n186 185
R976 VAPWR.n879 VAPWR.n878 185
R977 VAPWR.n880 VAPWR.n879 185
R978 VAPWR.n190 VAPWR.n189 185
R979 VAPWR.n189 VAPWR.t48 185
R980 VAPWR.n874 VAPWR.n873 185
R981 VAPWR.n873 VAPWR.n872 185
R982 VAPWR.n193 VAPWR.n192 185
R983 VAPWR.n871 VAPWR.n193 185
R984 VAPWR.n869 VAPWR.n868 185
R985 VAPWR.n870 VAPWR.n869 185
R986 VAPWR.n197 VAPWR.n196 185
R987 VAPWR.n196 VAPWR.n195 185
R988 VAPWR.n864 VAPWR.n863 185
R989 VAPWR.n863 VAPWR.n862 185
R990 VAPWR.n200 VAPWR.n199 185
R991 VAPWR.n861 VAPWR.n200 185
R992 VAPWR.n859 VAPWR.n858 185
R993 VAPWR.n860 VAPWR.n859 185
R994 VAPWR.n204 VAPWR.n203 185
R995 VAPWR.n203 VAPWR.n202 185
R996 VAPWR.n854 VAPWR.n853 185
R997 VAPWR.n853 VAPWR.n852 185
R998 VAPWR.n207 VAPWR.n206 185
R999 VAPWR.n851 VAPWR.n207 185
R1000 VAPWR.n849 VAPWR.n848 185
R1001 VAPWR.n850 VAPWR.n849 185
R1002 VAPWR.n209 VAPWR.n208 185
R1003 VAPWR.n841 VAPWR.n208 185
R1004 VAPWR.n844 VAPWR.n843 185
R1005 VAPWR.n843 VAPWR.n842 185
R1006 VAPWR.n212 VAPWR.n211 185
R1007 VAPWR.n839 VAPWR.n212 185
R1008 VAPWR.n837 VAPWR.n836 185
R1009 VAPWR.n838 VAPWR.n837 185
R1010 VAPWR.n216 VAPWR.n215 185
R1011 VAPWR.n215 VAPWR.n214 185
R1012 VAPWR.n832 VAPWR.n831 185
R1013 VAPWR.n831 VAPWR.n830 185
R1014 VAPWR.n219 VAPWR.n218 185
R1015 VAPWR.n829 VAPWR.n219 185
R1016 VAPWR.n827 VAPWR.n826 185
R1017 VAPWR.n828 VAPWR.n827 185
R1018 VAPWR.n223 VAPWR.n222 185
R1019 VAPWR.n222 VAPWR.n221 185
R1020 VAPWR.n822 VAPWR.n821 185
R1021 VAPWR.n821 VAPWR.n820 185
R1022 VAPWR.n226 VAPWR.n225 185
R1023 VAPWR.n819 VAPWR.n226 185
R1024 VAPWR.n817 VAPWR.n816 185
R1025 VAPWR.n818 VAPWR.n817 185
R1026 VAPWR.n230 VAPWR.n229 185
R1027 VAPWR.n229 VAPWR.n228 185
R1028 VAPWR.n812 VAPWR.n811 185
R1029 VAPWR.n811 VAPWR.n810 185
R1030 VAPWR.n233 VAPWR.n232 185
R1031 VAPWR.n809 VAPWR.n233 185
R1032 VAPWR.n806 VAPWR.n805 185
R1033 VAPWR.n808 VAPWR.n806 185
R1034 VAPWR.n236 VAPWR.n235 185
R1035 VAPWR.n235 VAPWR.n234 185
R1036 VAPWR.n801 VAPWR.n800 185
R1037 VAPWR.n800 VAPWR.n799 185
R1038 VAPWR.n239 VAPWR.n238 185
R1039 VAPWR.n798 VAPWR.n239 185
R1040 VAPWR.n795 VAPWR.n794 185
R1041 VAPWR.n797 VAPWR.n795 185
R1042 VAPWR.n241 VAPWR.n240 185
R1043 VAPWR.n787 VAPWR.n240 185
R1044 VAPWR.n790 VAPWR.n789 185
R1045 VAPWR.n789 VAPWR.n788 185
R1046 VAPWR.n244 VAPWR.n243 185
R1047 VAPWR.n786 VAPWR.n244 185
R1048 VAPWR.n783 VAPWR.n782 185
R1049 VAPWR.n785 VAPWR.n783 185
R1050 VAPWR.n246 VAPWR.n245 185
R1051 VAPWR.n775 VAPWR.n245 185
R1052 VAPWR.n778 VAPWR.n777 185
R1053 VAPWR.n777 VAPWR.n776 185
R1054 VAPWR.n249 VAPWR.n248 185
R1055 VAPWR.n774 VAPWR.n249 185
R1056 VAPWR.n771 VAPWR.n770 185
R1057 VAPWR.n773 VAPWR.n771 185
R1058 VAPWR.n251 VAPWR.n250 185
R1059 VAPWR.n250 VAPWR.t62 185
R1060 VAPWR.n766 VAPWR.n765 185
R1061 VAPWR.n765 VAPWR.n764 185
R1062 VAPWR.n254 VAPWR.n253 185
R1063 VAPWR.n763 VAPWR.n254 185
R1064 VAPWR.n760 VAPWR.n759 185
R1065 VAPWR.n762 VAPWR.n760 185
R1066 VAPWR.n257 VAPWR.n256 185
R1067 VAPWR.n256 VAPWR.n255 185
R1068 VAPWR.n755 VAPWR.n754 185
R1069 VAPWR.n754 VAPWR.n753 185
R1070 VAPWR.n260 VAPWR.n259 185
R1071 VAPWR.n752 VAPWR.n260 185
R1072 VAPWR.n749 VAPWR.n748 185
R1073 VAPWR.n751 VAPWR.n749 185
R1074 VAPWR.n263 VAPWR.n262 185
R1075 VAPWR.n262 VAPWR.n261 185
R1076 VAPWR.n744 VAPWR.n743 185
R1077 VAPWR.n743 VAPWR.n742 185
R1078 VAPWR.n266 VAPWR.n265 185
R1079 VAPWR.n741 VAPWR.n266 185
R1080 VAPWR.n723 VAPWR.n268 185
R1081 VAPWR.n740 VAPWR.n268 185
R1082 VAPWR.n308 VAPWR.n306 185
R1083 VAPWR.n306 VAPWR.n267 185
R1084 VAPWR.n728 VAPWR.n727 185
R1085 VAPWR.n729 VAPWR.n728 185
R1086 VAPWR.n307 VAPWR.n305 185
R1087 VAPWR.n730 VAPWR.n305 185
R1088 VAPWR.n720 VAPWR.n719 185
R1089 VAPWR.n719 VAPWR.n718 185
R1090 VAPWR.n311 VAPWR.n310 185
R1091 VAPWR.n717 VAPWR.n311 185
R1092 VAPWR.n706 VAPWR.n705 185
R1093 VAPWR.n707 VAPWR.n706 185
R1094 VAPWR.n319 VAPWR.n318 185
R1095 VAPWR.n708 VAPWR.n318 185
R1096 VAPWR.n701 VAPWR.n700 185
R1097 VAPWR.n700 VAPWR.n699 185
R1098 VAPWR.n322 VAPWR.n321 185
R1099 VAPWR.n698 VAPWR.n322 185
R1100 VAPWR.n334 VAPWR.n332 185
R1101 VAPWR.n332 VAPWR.n323 185
R1102 VAPWR.n689 VAPWR.n688 185
R1103 VAPWR.n690 VAPWR.n689 185
R1104 VAPWR.n333 VAPWR.n331 185
R1105 VAPWR.n331 VAPWR.n330 185
R1106 VAPWR.n683 VAPWR.n682 185
R1107 VAPWR.n682 VAPWR.n681 185
R1108 VAPWR.n337 VAPWR.n336 185
R1109 VAPWR.n338 VAPWR.n337 185
R1110 VAPWR.n671 VAPWR.n670 185
R1111 VAPWR.n672 VAPWR.n671 185
R1112 VAPWR.n347 VAPWR.n346 185
R1113 VAPWR.n346 VAPWR.n345 185
R1114 VAPWR.n666 VAPWR.n665 185
R1115 VAPWR.n665 VAPWR.n664 185
R1116 VAPWR.n350 VAPWR.n349 185
R1117 VAPWR.n351 VAPWR.n350 185
R1118 VAPWR.n655 VAPWR.n654 185
R1119 VAPWR.t22 VAPWR.n655 185
R1120 VAPWR.n359 VAPWR.n358 185
R1121 VAPWR.n358 VAPWR.n357 185
R1122 VAPWR.n650 VAPWR.n649 185
R1123 VAPWR.n649 VAPWR.n648 185
R1124 VAPWR.n362 VAPWR.n361 185
R1125 VAPWR.n637 VAPWR.n362 185
R1126 VAPWR.n636 VAPWR.n635 185
R1127 VAPWR.n638 VAPWR.n636 185
R1128 VAPWR.n369 VAPWR.n368 185
R1129 VAPWR.n373 VAPWR.n368 185
R1130 VAPWR.n631 VAPWR.n630 185
R1131 VAPWR.n630 VAPWR.n629 185
R1132 VAPWR.n372 VAPWR.n371 185
R1133 VAPWR.n618 VAPWR.n372 185
R1134 VAPWR.n617 VAPWR.n616 185
R1135 VAPWR.n619 VAPWR.n617 185
R1136 VAPWR.n380 VAPWR.n379 185
R1137 VAPWR.n385 VAPWR.n379 185
R1138 VAPWR.n612 VAPWR.n611 185
R1139 VAPWR.n611 VAPWR.n610 185
R1140 VAPWR.n383 VAPWR.n382 185
R1141 VAPWR.n384 VAPWR.n383 185
R1142 VAPWR.n601 VAPWR.n600 185
R1143 VAPWR.n602 VAPWR.n601 185
R1144 VAPWR.n394 VAPWR.n393 185
R1145 VAPWR.n393 VAPWR.n392 185
R1146 VAPWR.n596 VAPWR.n595 185
R1147 VAPWR.n595 VAPWR.n594 185
R1148 VAPWR.n397 VAPWR.n396 185
R1149 VAPWR.n398 VAPWR.n397 185
R1150 VAPWR.n584 VAPWR.n583 185
R1151 VAPWR.n585 VAPWR.n584 185
R1152 VAPWR.n407 VAPWR.n406 185
R1153 VAPWR.n406 VAPWR.n405 185
R1154 VAPWR.n579 VAPWR.n578 185
R1155 VAPWR.n578 VAPWR.n577 185
R1156 VAPWR.n410 VAPWR.n409 185
R1157 VAPWR.n411 VAPWR.n410 185
R1158 VAPWR.n568 VAPWR.n567 185
R1159 VAPWR.t40 VAPWR.n568 185
R1160 VAPWR.n420 VAPWR.n419 185
R1161 VAPWR.n419 VAPWR.n418 185
R1162 VAPWR.n563 VAPWR.n562 185
R1163 VAPWR.n562 VAPWR.n561 185
R1164 VAPWR.n423 VAPWR.n422 185
R1165 VAPWR.n551 VAPWR.n423 185
R1166 VAPWR.n550 VAPWR.n549 185
R1167 VAPWR.n552 VAPWR.n550 185
R1168 VAPWR.n911 VAPWR.n182 185
R1169 VAPWR.n912 VAPWR.n181 185
R1170 VAPWR.n913 VAPWR.n180 185
R1171 VAPWR.n898 VAPWR.n178 185
R1172 VAPWR.n917 VAPWR.n177 185
R1173 VAPWR.n918 VAPWR.n176 185
R1174 VAPWR.n919 VAPWR.n175 185
R1175 VAPWR.n895 VAPWR.n173 185
R1176 VAPWR.n923 VAPWR.n172 185
R1177 VAPWR.n924 VAPWR.n171 185
R1178 VAPWR.n925 VAPWR.n170 185
R1179 VAPWR.n892 VAPWR.n168 185
R1180 VAPWR.n929 VAPWR.n167 185
R1181 VAPWR.n930 VAPWR.n166 185
R1182 VAPWR.n889 VAPWR.n165 185
R1183 VAPWR.n934 VAPWR.n164 185
R1184 VAPWR.n935 VAPWR.n163 185
R1185 VAPWR.n936 VAPWR.n162 185
R1186 VAPWR.n886 VAPWR.n160 185
R1187 VAPWR.n940 VAPWR.n159 185
R1188 VAPWR.n941 VAPWR.n158 185
R1189 VAPWR.n942 VAPWR.n157 185
R1190 VAPWR.n883 VAPWR.n155 185
R1191 VAPWR.n946 VAPWR.n154 185
R1192 VAPWR.n947 VAPWR.n153 185
R1193 VAPWR.n948 VAPWR.n152 185
R1194 VAPWR.t47 VAPWR.n117 114.6
R1195 VAPWR.n90 VAPWR.t1 114.6
R1196 VAPWR.n49 VAPWR.t51 114.6
R1197 VAPWR.t9 VAPWR.n284 114.6
R1198 VAPWR.t43 VAPWR.n439 114.6
R1199 VAPWR.n154 VAPWR.n153 102.6
R1200 VAPWR.n883 VAPWR.n157 102.6
R1201 VAPWR.n159 VAPWR.n158 102.6
R1202 VAPWR.n886 VAPWR.n162 102.6
R1203 VAPWR.n164 VAPWR.n163 102.6
R1204 VAPWR.n889 VAPWR.n166 102.6
R1205 VAPWR.n892 VAPWR.n167 102.6
R1206 VAPWR.n171 VAPWR.n170 102.6
R1207 VAPWR.n895 VAPWR.n172 102.6
R1208 VAPWR.n176 VAPWR.n175 102.6
R1209 VAPWR.n898 VAPWR.n177 102.6
R1210 VAPWR.n181 VAPWR.n180 102.6
R1211 VAPWR.n550 VAPWR.n423 102.6
R1212 VAPWR.n562 VAPWR.n423 102.6
R1213 VAPWR.n562 VAPWR.n419 102.6
R1214 VAPWR.n568 VAPWR.n419 102.6
R1215 VAPWR.n568 VAPWR.n410 102.6
R1216 VAPWR.n578 VAPWR.n410 102.6
R1217 VAPWR.n578 VAPWR.n406 102.6
R1218 VAPWR.n584 VAPWR.n406 102.6
R1219 VAPWR.n584 VAPWR.n397 102.6
R1220 VAPWR.n595 VAPWR.n397 102.6
R1221 VAPWR.n595 VAPWR.n393 102.6
R1222 VAPWR.n601 VAPWR.n393 102.6
R1223 VAPWR.n601 VAPWR.n383 102.6
R1224 VAPWR.n611 VAPWR.n383 102.6
R1225 VAPWR.n611 VAPWR.n379 102.6
R1226 VAPWR.n617 VAPWR.n379 102.6
R1227 VAPWR.n617 VAPWR.n372 102.6
R1228 VAPWR.n630 VAPWR.n372 102.6
R1229 VAPWR.n630 VAPWR.n368 102.6
R1230 VAPWR.n636 VAPWR.n368 102.6
R1231 VAPWR.n636 VAPWR.n362 102.6
R1232 VAPWR.n649 VAPWR.n362 102.6
R1233 VAPWR.n649 VAPWR.n358 102.6
R1234 VAPWR.n655 VAPWR.n358 102.6
R1235 VAPWR.n655 VAPWR.n350 102.6
R1236 VAPWR.n665 VAPWR.n350 102.6
R1237 VAPWR.n665 VAPWR.n346 102.6
R1238 VAPWR.n671 VAPWR.n346 102.6
R1239 VAPWR.n671 VAPWR.n337 102.6
R1240 VAPWR.n682 VAPWR.n337 102.6
R1241 VAPWR.n682 VAPWR.n331 102.6
R1242 VAPWR.n689 VAPWR.n331 102.6
R1243 VAPWR.n689 VAPWR.n332 102.6
R1244 VAPWR.n332 VAPWR.n322 102.6
R1245 VAPWR.n700 VAPWR.n322 102.6
R1246 VAPWR.n700 VAPWR.n318 102.6
R1247 VAPWR.n706 VAPWR.n318 102.6
R1248 VAPWR.n706 VAPWR.n311 102.6
R1249 VAPWR.n719 VAPWR.n311 102.6
R1250 VAPWR.n719 VAPWR.n305 102.6
R1251 VAPWR.n728 VAPWR.n305 102.6
R1252 VAPWR.n728 VAPWR.n306 102.6
R1253 VAPWR.n306 VAPWR.n268 102.6
R1254 VAPWR.n268 VAPWR.n266 102.6
R1255 VAPWR.n743 VAPWR.n266 102.6
R1256 VAPWR.n743 VAPWR.n262 102.6
R1257 VAPWR.n749 VAPWR.n262 102.6
R1258 VAPWR.n749 VAPWR.n260 102.6
R1259 VAPWR.n754 VAPWR.n260 102.6
R1260 VAPWR.n754 VAPWR.n256 102.6
R1261 VAPWR.n760 VAPWR.n256 102.6
R1262 VAPWR.n760 VAPWR.n254 102.6
R1263 VAPWR.n765 VAPWR.n254 102.6
R1264 VAPWR.n765 VAPWR.n250 102.6
R1265 VAPWR.n771 VAPWR.n250 102.6
R1266 VAPWR.n771 VAPWR.n249 102.6
R1267 VAPWR.n777 VAPWR.n249 102.6
R1268 VAPWR.n777 VAPWR.n245 102.6
R1269 VAPWR.n783 VAPWR.n245 102.6
R1270 VAPWR.n783 VAPWR.n244 102.6
R1271 VAPWR.n789 VAPWR.n244 102.6
R1272 VAPWR.n789 VAPWR.n240 102.6
R1273 VAPWR.n795 VAPWR.n240 102.6
R1274 VAPWR.n795 VAPWR.n239 102.6
R1275 VAPWR.n800 VAPWR.n239 102.6
R1276 VAPWR.n800 VAPWR.n235 102.6
R1277 VAPWR.n806 VAPWR.n235 102.6
R1278 VAPWR.n806 VAPWR.n233 102.6
R1279 VAPWR.n811 VAPWR.n233 102.6
R1280 VAPWR.n811 VAPWR.n229 102.6
R1281 VAPWR.n817 VAPWR.n229 102.6
R1282 VAPWR.n817 VAPWR.n226 102.6
R1283 VAPWR.n821 VAPWR.n226 102.6
R1284 VAPWR.n821 VAPWR.n222 102.6
R1285 VAPWR.n827 VAPWR.n222 102.6
R1286 VAPWR.n827 VAPWR.n219 102.6
R1287 VAPWR.n831 VAPWR.n219 102.6
R1288 VAPWR.n831 VAPWR.n215 102.6
R1289 VAPWR.n837 VAPWR.n215 102.6
R1290 VAPWR.n837 VAPWR.n212 102.6
R1291 VAPWR.n843 VAPWR.n212 102.6
R1292 VAPWR.n843 VAPWR.n208 102.6
R1293 VAPWR.n849 VAPWR.n208 102.6
R1294 VAPWR.n849 VAPWR.n207 102.6
R1295 VAPWR.n853 VAPWR.n207 102.6
R1296 VAPWR.n853 VAPWR.n203 102.6
R1297 VAPWR.n859 VAPWR.n203 102.6
R1298 VAPWR.n859 VAPWR.n200 102.6
R1299 VAPWR.n863 VAPWR.n200 102.6
R1300 VAPWR.n863 VAPWR.n196 102.6
R1301 VAPWR.n869 VAPWR.n196 102.6
R1302 VAPWR.n869 VAPWR.n193 102.6
R1303 VAPWR.n873 VAPWR.n193 102.6
R1304 VAPWR.n873 VAPWR.n189 102.6
R1305 VAPWR.n879 VAPWR.n189 102.6
R1306 VAPWR.n879 VAPWR.n186 102.6
R1307 VAPWR.n905 VAPWR.n186 102.6
R1308 VAPWR.n905 VAPWR.n187 102.6
R1309 VAPWR.n490 VAPWR.n489 102.6
R1310 VAPWR.n492 VAPWR.n490 102.6
R1311 VAPWR.n498 VAPWR.n482 102.6
R1312 VAPWR.n502 VAPWR.n500 102.6
R1313 VAPWR.n508 VAPWR.n478 102.6
R1314 VAPWR.n512 VAPWR.n510 102.6
R1315 VAPWR.n518 VAPWR.n474 102.6
R1316 VAPWR.n522 VAPWR.n520 102.6
R1317 VAPWR.n528 VAPWR.n470 102.6
R1318 VAPWR.n532 VAPWR.n530 102.6
R1319 VAPWR.n539 VAPWR.n466 102.6
R1320 VAPWR.n542 VAPWR.n541 102.6
R1321 VAPWR.n544 VAPWR.n461 102.6
R1322 VAPWR.n553 VAPWR.n424 102.6
R1323 VAPWR.n560 VAPWR.n424 102.6
R1324 VAPWR.n560 VAPWR.n417 102.6
R1325 VAPWR.n569 VAPWR.n417 102.6
R1326 VAPWR.n569 VAPWR.n412 102.6
R1327 VAPWR.n576 VAPWR.n412 102.6
R1328 VAPWR.n576 VAPWR.n404 102.6
R1329 VAPWR.n586 VAPWR.n404 102.6
R1330 VAPWR.n586 VAPWR.n399 102.6
R1331 VAPWR.n593 VAPWR.n399 102.6
R1332 VAPWR.n593 VAPWR.n391 102.6
R1333 VAPWR.n603 VAPWR.n391 102.6
R1334 VAPWR.n603 VAPWR.n386 102.6
R1335 VAPWR.n609 VAPWR.n386 102.6
R1336 VAPWR.n609 VAPWR.n378 102.6
R1337 VAPWR.n620 VAPWR.n378 102.6
R1338 VAPWR.n620 VAPWR.n374 102.6
R1339 VAPWR.n628 VAPWR.n374 102.6
R1340 VAPWR.n628 VAPWR.n367 102.6
R1341 VAPWR.n639 VAPWR.n367 102.6
R1342 VAPWR.n639 VAPWR.n363 102.6
R1343 VAPWR.n647 VAPWR.n363 102.6
R1344 VAPWR.n647 VAPWR.n356 102.6
R1345 VAPWR.n656 VAPWR.n356 102.6
R1346 VAPWR.n656 VAPWR.n352 102.6
R1347 VAPWR.n663 VAPWR.n352 102.6
R1348 VAPWR.n663 VAPWR.n344 102.6
R1349 VAPWR.n673 VAPWR.n344 102.6
R1350 VAPWR.n673 VAPWR.n339 102.6
R1351 VAPWR.n680 VAPWR.n339 102.6
R1352 VAPWR.n680 VAPWR.n329 102.6
R1353 VAPWR.n691 VAPWR.n329 102.6
R1354 VAPWR.n691 VAPWR.n324 102.6
R1355 VAPWR.n697 VAPWR.n324 102.6
R1356 VAPWR.n697 VAPWR.n317 102.6
R1357 VAPWR.n709 VAPWR.n317 102.6
R1358 VAPWR.n709 VAPWR.n312 102.6
R1359 VAPWR.n716 VAPWR.n312 102.6
R1360 VAPWR.n716 VAPWR.n304 102.6
R1361 VAPWR.n731 VAPWR.n304 102.6
R1362 VAPWR.n731 VAPWR.n269 102.6
R1363 VAPWR.n738 VAPWR.n269 102.6
R1364 VAPWR.n739 VAPWR.n738 102.6
R1365 VAPWR.n739 VAPWR.n3 102.6
R1366 VAPWR.n4 VAPWR.n3 102.6
R1367 VAPWR.n5 VAPWR.n4 102.6
R1368 VAPWR.n750 VAPWR.n5 102.6
R1369 VAPWR.n750 VAPWR.n9 102.6
R1370 VAPWR.n10 VAPWR.n9 102.6
R1371 VAPWR.n11 VAPWR.n10 102.6
R1372 VAPWR.n761 VAPWR.n11 102.6
R1373 VAPWR.n761 VAPWR.n15 102.6
R1374 VAPWR.n16 VAPWR.n15 102.6
R1375 VAPWR.n17 VAPWR.n16 102.6
R1376 VAPWR.n772 VAPWR.n17 102.6
R1377 VAPWR.n772 VAPWR.n21 102.6
R1378 VAPWR.n22 VAPWR.n21 102.6
R1379 VAPWR.n23 VAPWR.n22 102.6
R1380 VAPWR.n784 VAPWR.n23 102.6
R1381 VAPWR.n784 VAPWR.n27 102.6
R1382 VAPWR.n28 VAPWR.n27 102.6
R1383 VAPWR.n29 VAPWR.n28 102.6
R1384 VAPWR.n796 VAPWR.n29 102.6
R1385 VAPWR.n796 VAPWR.n33 102.6
R1386 VAPWR.n34 VAPWR.n33 102.6
R1387 VAPWR.n35 VAPWR.n34 102.6
R1388 VAPWR.n807 VAPWR.n35 102.6
R1389 VAPWR.n807 VAPWR.n66 102.6
R1390 VAPWR.n67 VAPWR.n66 102.6
R1391 VAPWR.n227 VAPWR.n67 102.6
R1392 VAPWR.n227 VAPWR.n70 102.6
R1393 VAPWR.n71 VAPWR.n70 102.6
R1394 VAPWR.n72 VAPWR.n71 102.6
R1395 VAPWR.n220 VAPWR.n72 102.6
R1396 VAPWR.n220 VAPWR.n76 102.6
R1397 VAPWR.n77 VAPWR.n76 102.6
R1398 VAPWR.n78 VAPWR.n77 102.6
R1399 VAPWR.n213 VAPWR.n78 102.6
R1400 VAPWR.n213 VAPWR.n106 102.6
R1401 VAPWR.n107 VAPWR.n106 102.6
R1402 VAPWR.n108 VAPWR.n107 102.6
R1403 VAPWR.n840 VAPWR.n108 102.6
R1404 VAPWR.n840 VAPWR.n130 102.6
R1405 VAPWR.n131 VAPWR.n130 102.6
R1406 VAPWR.n132 VAPWR.n131 102.6
R1407 VAPWR.n201 VAPWR.n132 102.6
R1408 VAPWR.n201 VAPWR.n135 102.6
R1409 VAPWR.n136 VAPWR.n135 102.6
R1410 VAPWR.n137 VAPWR.n136 102.6
R1411 VAPWR.n194 VAPWR.n137 102.6
R1412 VAPWR.n194 VAPWR.n140 102.6
R1413 VAPWR.n141 VAPWR.n140 102.6
R1414 VAPWR.n142 VAPWR.n141 102.6
R1415 VAPWR.n188 VAPWR.n142 102.6
R1416 VAPWR.n188 VAPWR.n146 102.6
R1417 VAPWR.n147 VAPWR.n146 102.6
R1418 VAPWR.n148 VAPWR.n147 102.6
R1419 VAPWR.n902 VAPWR.n148 102.6
R1420 VAPWR.n488 VAPWR.n460 72.4195
R1421 VAPWR.n491 VAPWR.n460 72.4195
R1422 VAPWR.n499 VAPWR.n460 72.4195
R1423 VAPWR.n501 VAPWR.n460 72.4195
R1424 VAPWR.n509 VAPWR.n460 72.4195
R1425 VAPWR.n511 VAPWR.n460 72.4195
R1426 VAPWR.n519 VAPWR.n460 72.4195
R1427 VAPWR.n521 VAPWR.n460 72.4195
R1428 VAPWR.n529 VAPWR.n460 72.4195
R1429 VAPWR.n531 VAPWR.n460 72.4195
R1430 VAPWR.n540 VAPWR.n460 72.4195
R1431 VAPWR.n543 VAPWR.n460 72.4195
R1432 VAPWR.n901 VAPWR.n900 72.4195
R1433 VAPWR.n901 VAPWR.n899 72.4195
R1434 VAPWR.n901 VAPWR.n897 72.4195
R1435 VAPWR.n901 VAPWR.n896 72.4195
R1436 VAPWR.n901 VAPWR.n894 72.4195
R1437 VAPWR.n901 VAPWR.n893 72.4195
R1438 VAPWR.n901 VAPWR.n891 72.4195
R1439 VAPWR.n901 VAPWR.n890 72.4195
R1440 VAPWR.n901 VAPWR.n888 72.4195
R1441 VAPWR.n901 VAPWR.n887 72.4195
R1442 VAPWR.n901 VAPWR.n885 72.4195
R1443 VAPWR.n901 VAPWR.n884 72.4195
R1444 VAPWR.n901 VAPWR.n882 72.4195
R1445 VAPWR.n552 VAPWR.n460 44.7064
R1446 VAPWR.n903 VAPWR.n901 44.7064
R1447 VAPWR.n882 VAPWR.n153 40.1639
R1448 VAPWR.n884 VAPWR.n883 40.1639
R1449 VAPWR.n885 VAPWR.n158 40.1639
R1450 VAPWR.n887 VAPWR.n886 40.1639
R1451 VAPWR.n888 VAPWR.n163 40.1639
R1452 VAPWR.n890 VAPWR.n889 40.1639
R1453 VAPWR.n891 VAPWR.n167 40.1639
R1454 VAPWR.n893 VAPWR.n170 40.1639
R1455 VAPWR.n894 VAPWR.n172 40.1639
R1456 VAPWR.n896 VAPWR.n175 40.1639
R1457 VAPWR.n897 VAPWR.n177 40.1639
R1458 VAPWR.n899 VAPWR.n180 40.1639
R1459 VAPWR.n900 VAPWR.n182 40.1639
R1460 VAPWR.n488 VAPWR.n459 40.1639
R1461 VAPWR.n492 VAPWR.n491 40.1639
R1462 VAPWR.n499 VAPWR.n498 40.1639
R1463 VAPWR.n502 VAPWR.n501 40.1639
R1464 VAPWR.n509 VAPWR.n508 40.1639
R1465 VAPWR.n512 VAPWR.n511 40.1639
R1466 VAPWR.n519 VAPWR.n518 40.1639
R1467 VAPWR.n522 VAPWR.n521 40.1639
R1468 VAPWR.n529 VAPWR.n528 40.1639
R1469 VAPWR.n532 VAPWR.n531 40.1639
R1470 VAPWR.n540 VAPWR.n539 40.1639
R1471 VAPWR.n543 VAPWR.n542 40.1639
R1472 VAPWR.n489 VAPWR.n488 40.1639
R1473 VAPWR.n491 VAPWR.n482 40.1639
R1474 VAPWR.n500 VAPWR.n499 40.1639
R1475 VAPWR.n501 VAPWR.n478 40.1639
R1476 VAPWR.n510 VAPWR.n509 40.1639
R1477 VAPWR.n511 VAPWR.n474 40.1639
R1478 VAPWR.n520 VAPWR.n519 40.1639
R1479 VAPWR.n521 VAPWR.n470 40.1639
R1480 VAPWR.n530 VAPWR.n529 40.1639
R1481 VAPWR.n531 VAPWR.n466 40.1639
R1482 VAPWR.n541 VAPWR.n540 40.1639
R1483 VAPWR.n544 VAPWR.n543 40.1639
R1484 VAPWR.n900 VAPWR.n181 40.1639
R1485 VAPWR.n899 VAPWR.n898 40.1639
R1486 VAPWR.n897 VAPWR.n176 40.1639
R1487 VAPWR.n896 VAPWR.n895 40.1639
R1488 VAPWR.n894 VAPWR.n171 40.1639
R1489 VAPWR.n893 VAPWR.n892 40.1639
R1490 VAPWR.n891 VAPWR.n166 40.1639
R1491 VAPWR.n890 VAPWR.n164 40.1639
R1492 VAPWR.n888 VAPWR.n162 40.1639
R1493 VAPWR.n887 VAPWR.n159 40.1639
R1494 VAPWR.n885 VAPWR.n157 40.1639
R1495 VAPWR.n884 VAPWR.n154 40.1639
R1496 VAPWR.n882 VAPWR.n152 40.1639
R1497 VAPWR.n554 VAPWR.n458 35.5205
R1498 VAPWR.n948 VAPWR.n149 35.5205
R1499 VAPWR.n549 VAPWR.n462 35.5205
R1500 VAPWR.n911 VAPWR.n183 35.5205
R1501 VAPWR.n990 VAPWR.n74 34.1431
R1502 VAPWR.n1006 VAPWR.n31 30.7232
R1503 VAPWR.n1013 VAPWR.n25 30.7232
R1504 VAPWR.n1020 VAPWR.n19 30.7232
R1505 VAPWR.n1028 VAPWR.n13 30.7232
R1506 VAPWR.n1035 VAPWR.n7 30.7232
R1507 VAPWR.n552 VAPWR.n551 28.74
R1508 VAPWR.n561 VAPWR.n418 28.74
R1509 VAPWR.t40 VAPWR.n418 28.74
R1510 VAPWR.t40 VAPWR.n411 28.74
R1511 VAPWR.n577 VAPWR.n411 28.74
R1512 VAPWR.n585 VAPWR.n405 28.74
R1513 VAPWR.n594 VAPWR.n398 28.74
R1514 VAPWR.n602 VAPWR.n392 28.74
R1515 VAPWR.n610 VAPWR.n384 28.74
R1516 VAPWR.n610 VAPWR.n385 28.74
R1517 VAPWR.n619 VAPWR.n618 28.74
R1518 VAPWR.n629 VAPWR.n373 28.74
R1519 VAPWR.n638 VAPWR.n637 28.74
R1520 VAPWR.n648 VAPWR.n357 28.74
R1521 VAPWR.t22 VAPWR.n357 28.74
R1522 VAPWR.t22 VAPWR.n351 28.74
R1523 VAPWR.n664 VAPWR.n351 28.74
R1524 VAPWR.n672 VAPWR.n345 28.74
R1525 VAPWR.n681 VAPWR.n338 28.74
R1526 VAPWR.n690 VAPWR.n330 28.74
R1527 VAPWR.n698 VAPWR.n323 28.74
R1528 VAPWR.n699 VAPWR.n698 28.74
R1529 VAPWR.n708 VAPWR.n707 28.74
R1530 VAPWR.n718 VAPWR.n717 28.74
R1531 VAPWR.n730 VAPWR.n729 28.74
R1532 VAPWR.n729 VAPWR.n267 28.74
R1533 VAPWR.n740 VAPWR.n267 28.74
R1534 VAPWR.n741 VAPWR.n740 28.74
R1535 VAPWR.n742 VAPWR.n741 28.74
R1536 VAPWR.n751 VAPWR.n261 28.74
R1537 VAPWR.n753 VAPWR.n752 28.74
R1538 VAPWR.n762 VAPWR.n255 28.74
R1539 VAPWR.n764 VAPWR.n763 28.74
R1540 VAPWR.n764 VAPWR.t62 28.74
R1541 VAPWR.n773 VAPWR.t62 28.74
R1542 VAPWR.n774 VAPWR.n773 28.74
R1543 VAPWR.n776 VAPWR.n775 28.74
R1544 VAPWR.n786 VAPWR.n785 28.74
R1545 VAPWR.n788 VAPWR.n787 28.74
R1546 VAPWR.n798 VAPWR.n797 28.74
R1547 VAPWR.n799 VAPWR.n798 28.74
R1548 VAPWR.n808 VAPWR.n234 28.74
R1549 VAPWR.n810 VAPWR.n809 28.74
R1550 VAPWR.n810 VAPWR.n228 28.74
R1551 VAPWR.n818 VAPWR.n228 28.74
R1552 VAPWR.n819 VAPWR.n818 28.74
R1553 VAPWR.n820 VAPWR.n221 28.74
R1554 VAPWR.n828 VAPWR.n221 28.74
R1555 VAPWR.n830 VAPWR.n829 28.74
R1556 VAPWR.n838 VAPWR.n214 28.74
R1557 VAPWR.n839 VAPWR.n838 28.74
R1558 VAPWR.n842 VAPWR.n839 28.74
R1559 VAPWR.n842 VAPWR.n841 28.74
R1560 VAPWR.n851 VAPWR.n850 28.74
R1561 VAPWR.n852 VAPWR.n851 28.74
R1562 VAPWR.n852 VAPWR.n202 28.74
R1563 VAPWR.n860 VAPWR.n202 28.74
R1564 VAPWR.n861 VAPWR.n860 28.74
R1565 VAPWR.n862 VAPWR.n195 28.74
R1566 VAPWR.n870 VAPWR.n195 28.74
R1567 VAPWR.n871 VAPWR.n870 28.74
R1568 VAPWR.n872 VAPWR.n871 28.74
R1569 VAPWR.n872 VAPWR.t48 28.74
R1570 VAPWR.n880 VAPWR.t48 28.74
R1571 VAPWR.n881 VAPWR.n880 28.74
R1572 VAPWR.n904 VAPWR.n903 28.74
R1573 VAPWR.n607 VAPWR.n388 27.8951
R1574 VAPWR.n712 VAPWR.n314 27.8951
R1575 VAPWR.n327 VAPWR.n326 27.8951
R1576 VAPWR.n342 VAPWR.n341 27.8951
R1577 VAPWR.n644 VAPWR.n643 27.8951
R1578 VAPWR.n625 VAPWR.n624 27.8951
R1579 VAPWR.n590 VAPWR.n401 27.8951
R1580 VAPWR.n573 VAPWR.n414 27.8951
R1581 VAPWR.n125 VAPWR.n111 27.1064
R1582 VAPWR.n125 VAPWR.n113 27.1064
R1583 VAPWR.n121 VAPWR.n113 27.1064
R1584 VAPWR.n121 VAPWR.n120 27.1064
R1585 VAPWR.n120 VAPWR.n119 27.1064
R1586 VAPWR.n101 VAPWR.n81 27.1064
R1587 VAPWR.n101 VAPWR.n83 27.1064
R1588 VAPWR.n97 VAPWR.n83 27.1064
R1589 VAPWR.n97 VAPWR.n96 27.1064
R1590 VAPWR.n96 VAPWR.n95 27.1064
R1591 VAPWR.n95 VAPWR.n88 27.1064
R1592 VAPWR.n91 VAPWR.n88 27.1064
R1593 VAPWR.n61 VAPWR.n38 27.1064
R1594 VAPWR.n61 VAPWR.n40 27.1064
R1595 VAPWR.n57 VAPWR.n40 27.1064
R1596 VAPWR.n57 VAPWR.n56 27.1064
R1597 VAPWR.n56 VAPWR.n55 27.1064
R1598 VAPWR.n55 VAPWR.n45 27.1064
R1599 VAPWR.n51 VAPWR.n45 27.1064
R1600 VAPWR.n51 VAPWR.n50 27.1064
R1601 VAPWR.n298 VAPWR.n272 27.1064
R1602 VAPWR.n298 VAPWR.n274 27.1064
R1603 VAPWR.n294 VAPWR.n274 27.1064
R1604 VAPWR.n294 VAPWR.n293 27.1064
R1605 VAPWR.n293 VAPWR.n292 27.1064
R1606 VAPWR.n292 VAPWR.n279 27.1064
R1607 VAPWR.n288 VAPWR.n279 27.1064
R1608 VAPWR.n288 VAPWR.n287 27.1064
R1609 VAPWR.n287 VAPWR.n286 27.1064
R1610 VAPWR.n453 VAPWR.n427 27.1064
R1611 VAPWR.n453 VAPWR.n429 27.1064
R1612 VAPWR.n449 VAPWR.n429 27.1064
R1613 VAPWR.n449 VAPWR.n448 27.1064
R1614 VAPWR.n448 VAPWR.n447 27.1064
R1615 VAPWR.n447 VAPWR.n434 27.1064
R1616 VAPWR.n443 VAPWR.n434 27.1064
R1617 VAPWR.n443 VAPWR.n442 27.1064
R1618 VAPWR.n442 VAPWR.n441 27.1064
R1619 VAPWR.n602 VAPWR.t32 25.5467
R1620 VAPWR.n619 VAPWR.t30 25.5467
R1621 VAPWR.n690 VAPWR.t14 25.5467
R1622 VAPWR.n708 VAPWR.t12 25.5467
R1623 VAPWR.t70 VAPWR.n261 25.5467
R1624 VAPWR.n787 VAPWR.t54 25.5467
R1625 VAPWR.t52 VAPWR.n234 25.5467
R1626 VAPWR.t4 VAPWR.n819 25.5467
R1627 VAPWR.n829 VAPWR.t2 25.5467
R1628 VAPWR.n841 VAPWR.t46 25.5467
R1629 VAPWR.n128 VAPWR.n127 24.7743
R1630 VAPWR.n104 VAPWR.n103 24.7743
R1631 VAPWR.n64 VAPWR.n63 24.7743
R1632 VAPWR.n301 VAPWR.n300 24.7743
R1633 VAPWR.n456 VAPWR.n455 24.7743
R1634 VAPWR.n551 VAPWR.t42 22.3534
R1635 VAPWR.t38 VAPWR.n405 22.3534
R1636 VAPWR.n637 VAPWR.t24 22.3534
R1637 VAPWR.t20 VAPWR.n345 22.3534
R1638 VAPWR.t64 VAPWR.n762 22.3534
R1639 VAPWR.n776 VAPWR.t60 22.3534
R1640 VAPWR.n904 VAPWR.t6 22.3534
R1641 VAPWR.n594 VAPWR.t34 19.1602
R1642 VAPWR.n629 VAPWR.t28 19.1602
R1643 VAPWR.n681 VAPWR.t16 19.1602
R1644 VAPWR.n717 VAPWR.t10 19.1602
R1645 VAPWR.n752 VAPWR.t68 19.1602
R1646 VAPWR.t56 VAPWR.n786 19.1602
R1647 VAPWR.n809 VAPWR.t50 19.1602
R1648 VAPWR.t0 VAPWR.n214 19.1602
R1649 VAPWR.t36 VAPWR.n398 15.9669
R1650 VAPWR.n373 VAPWR.t26 15.9669
R1651 VAPWR.t18 VAPWR.n338 15.9669
R1652 VAPWR.n718 VAPWR.t8 15.9669
R1653 VAPWR.n753 VAPWR.t66 15.9669
R1654 VAPWR.n785 VAPWR.t58 15.9669
R1655 VAPWR.n862 VAPWR.t44 15.9669
R1656 VAPWR.n585 VAPWR.t36 12.7736
R1657 VAPWR.n638 VAPWR.t26 12.7736
R1658 VAPWR.n672 VAPWR.t18 12.7736
R1659 VAPWR.n730 VAPWR.t8 12.7736
R1660 VAPWR.t66 VAPWR.n255 12.7736
R1661 VAPWR.n775 VAPWR.t58 12.7736
R1662 VAPWR.t44 VAPWR.n861 12.7736
R1663 VAPWR.n554 VAPWR.n425 11.5205
R1664 VAPWR.n559 VAPWR.n425 11.5205
R1665 VAPWR.n559 VAPWR.n416 11.5205
R1666 VAPWR.n570 VAPWR.n416 11.5205
R1667 VAPWR.n570 VAPWR.n413 11.5205
R1668 VAPWR.n575 VAPWR.n413 11.5205
R1669 VAPWR.n575 VAPWR.n403 11.5205
R1670 VAPWR.n587 VAPWR.n403 11.5205
R1671 VAPWR.n587 VAPWR.n400 11.5205
R1672 VAPWR.n592 VAPWR.n400 11.5205
R1673 VAPWR.n592 VAPWR.n390 11.5205
R1674 VAPWR.n604 VAPWR.n390 11.5205
R1675 VAPWR.n604 VAPWR.n387 11.5205
R1676 VAPWR.n608 VAPWR.n387 11.5205
R1677 VAPWR.n608 VAPWR.n377 11.5205
R1678 VAPWR.n621 VAPWR.n377 11.5205
R1679 VAPWR.n621 VAPWR.n375 11.5205
R1680 VAPWR.n627 VAPWR.n375 11.5205
R1681 VAPWR.n627 VAPWR.n366 11.5205
R1682 VAPWR.n640 VAPWR.n366 11.5205
R1683 VAPWR.n640 VAPWR.n364 11.5205
R1684 VAPWR.n646 VAPWR.n364 11.5205
R1685 VAPWR.n646 VAPWR.n355 11.5205
R1686 VAPWR.n657 VAPWR.n355 11.5205
R1687 VAPWR.n657 VAPWR.n353 11.5205
R1688 VAPWR.n662 VAPWR.n353 11.5205
R1689 VAPWR.n662 VAPWR.n343 11.5205
R1690 VAPWR.n674 VAPWR.n343 11.5205
R1691 VAPWR.n674 VAPWR.n340 11.5205
R1692 VAPWR.n679 VAPWR.n340 11.5205
R1693 VAPWR.n679 VAPWR.n328 11.5205
R1694 VAPWR.n692 VAPWR.n328 11.5205
R1695 VAPWR.n692 VAPWR.n325 11.5205
R1696 VAPWR.n696 VAPWR.n325 11.5205
R1697 VAPWR.n696 VAPWR.n316 11.5205
R1698 VAPWR.n710 VAPWR.n316 11.5205
R1699 VAPWR.n710 VAPWR.n313 11.5205
R1700 VAPWR.n715 VAPWR.n313 11.5205
R1701 VAPWR.n715 VAPWR.n303 11.5205
R1702 VAPWR.n732 VAPWR.n303 11.5205
R1703 VAPWR.n732 VAPWR.n270 11.5205
R1704 VAPWR.n737 VAPWR.n270 11.5205
R1705 VAPWR.n737 VAPWR.n2 11.5205
R1706 VAPWR.n1039 VAPWR.n2 11.5205
R1707 VAPWR.n1039 VAPWR.n1038 11.5205
R1708 VAPWR.n1038 VAPWR.n1037 11.5205
R1709 VAPWR.n1037 VAPWR.n6 11.5205
R1710 VAPWR.n1032 VAPWR.n6 11.5205
R1711 VAPWR.n1032 VAPWR.n1031 11.5205
R1712 VAPWR.n1031 VAPWR.n1030 11.5205
R1713 VAPWR.n1030 VAPWR.n12 11.5205
R1714 VAPWR.n1025 VAPWR.n12 11.5205
R1715 VAPWR.n1025 VAPWR.n1024 11.5205
R1716 VAPWR.n1024 VAPWR.n1023 11.5205
R1717 VAPWR.n1023 VAPWR.n18 11.5205
R1718 VAPWR.n1018 VAPWR.n18 11.5205
R1719 VAPWR.n1018 VAPWR.n1017 11.5205
R1720 VAPWR.n1017 VAPWR.n1016 11.5205
R1721 VAPWR.n1016 VAPWR.n24 11.5205
R1722 VAPWR.n1011 VAPWR.n24 11.5205
R1723 VAPWR.n1011 VAPWR.n1010 11.5205
R1724 VAPWR.n1010 VAPWR.n1009 11.5205
R1725 VAPWR.n1009 VAPWR.n30 11.5205
R1726 VAPWR.n1005 VAPWR.n30 11.5205
R1727 VAPWR.n1005 VAPWR.n1004 11.5205
R1728 VAPWR.n1004 VAPWR.n1003 11.5205
R1729 VAPWR.n1003 VAPWR.n36 11.5205
R1730 VAPWR.n999 VAPWR.n36 11.5205
R1731 VAPWR.n999 VAPWR.n998 11.5205
R1732 VAPWR.n998 VAPWR.n68 11.5205
R1733 VAPWR.n994 VAPWR.n68 11.5205
R1734 VAPWR.n994 VAPWR.n993 11.5205
R1735 VAPWR.n993 VAPWR.n992 11.5205
R1736 VAPWR.n992 VAPWR.n73 11.5205
R1737 VAPWR.n988 VAPWR.n73 11.5205
R1738 VAPWR.n988 VAPWR.n987 11.5205
R1739 VAPWR.n987 VAPWR.n986 11.5205
R1740 VAPWR.n986 VAPWR.n79 11.5205
R1741 VAPWR.n981 VAPWR.n79 11.5205
R1742 VAPWR.n981 VAPWR.n980 11.5205
R1743 VAPWR.n980 VAPWR.n979 11.5205
R1744 VAPWR.n979 VAPWR.n109 11.5205
R1745 VAPWR.n975 VAPWR.n109 11.5205
R1746 VAPWR.n975 VAPWR.n974 11.5205
R1747 VAPWR.n974 VAPWR.n973 11.5205
R1748 VAPWR.n973 VAPWR.n133 11.5205
R1749 VAPWR.n969 VAPWR.n133 11.5205
R1750 VAPWR.n969 VAPWR.n968 11.5205
R1751 VAPWR.n968 VAPWR.n967 11.5205
R1752 VAPWR.n967 VAPWR.n138 11.5205
R1753 VAPWR.n962 VAPWR.n138 11.5205
R1754 VAPWR.n962 VAPWR.n961 11.5205
R1755 VAPWR.n961 VAPWR.n960 11.5205
R1756 VAPWR.n960 VAPWR.n143 11.5205
R1757 VAPWR.n956 VAPWR.n143 11.5205
R1758 VAPWR.n956 VAPWR.n955 11.5205
R1759 VAPWR.n955 VAPWR.n954 11.5205
R1760 VAPWR.n954 VAPWR.n149 11.5205
R1761 VAPWR.n487 VAPWR.n458 11.5205
R1762 VAPWR.n487 VAPWR.n485 11.5205
R1763 VAPWR.n493 VAPWR.n485 11.5205
R1764 VAPWR.n493 VAPWR.n483 11.5205
R1765 VAPWR.n497 VAPWR.n483 11.5205
R1766 VAPWR.n497 VAPWR.n481 11.5205
R1767 VAPWR.n503 VAPWR.n481 11.5205
R1768 VAPWR.n503 VAPWR.n479 11.5205
R1769 VAPWR.n507 VAPWR.n479 11.5205
R1770 VAPWR.n507 VAPWR.n477 11.5205
R1771 VAPWR.n513 VAPWR.n477 11.5205
R1772 VAPWR.n513 VAPWR.n475 11.5205
R1773 VAPWR.n517 VAPWR.n475 11.5205
R1774 VAPWR.n517 VAPWR.n473 11.5205
R1775 VAPWR.n523 VAPWR.n473 11.5205
R1776 VAPWR.n523 VAPWR.n471 11.5205
R1777 VAPWR.n527 VAPWR.n471 11.5205
R1778 VAPWR.n527 VAPWR.n469 11.5205
R1779 VAPWR.n533 VAPWR.n469 11.5205
R1780 VAPWR.n533 VAPWR.n467 11.5205
R1781 VAPWR.n538 VAPWR.n467 11.5205
R1782 VAPWR.n538 VAPWR.n465 11.5205
R1783 VAPWR.n465 VAPWR.n464 11.5205
R1784 VAPWR.n545 VAPWR.n464 11.5205
R1785 VAPWR.n545 VAPWR.n462 11.5205
R1786 VAPWR.n549 VAPWR.n422 11.5205
R1787 VAPWR.n563 VAPWR.n422 11.5205
R1788 VAPWR.n563 VAPWR.n420 11.5205
R1789 VAPWR.n567 VAPWR.n420 11.5205
R1790 VAPWR.n567 VAPWR.n409 11.5205
R1791 VAPWR.n579 VAPWR.n409 11.5205
R1792 VAPWR.n579 VAPWR.n407 11.5205
R1793 VAPWR.n583 VAPWR.n407 11.5205
R1794 VAPWR.n583 VAPWR.n396 11.5205
R1795 VAPWR.n596 VAPWR.n396 11.5205
R1796 VAPWR.n596 VAPWR.n394 11.5205
R1797 VAPWR.n600 VAPWR.n394 11.5205
R1798 VAPWR.n600 VAPWR.n382 11.5205
R1799 VAPWR.n612 VAPWR.n382 11.5205
R1800 VAPWR.n612 VAPWR.n380 11.5205
R1801 VAPWR.n616 VAPWR.n380 11.5205
R1802 VAPWR.n616 VAPWR.n371 11.5205
R1803 VAPWR.n631 VAPWR.n371 11.5205
R1804 VAPWR.n631 VAPWR.n369 11.5205
R1805 VAPWR.n635 VAPWR.n369 11.5205
R1806 VAPWR.n635 VAPWR.n361 11.5205
R1807 VAPWR.n650 VAPWR.n361 11.5205
R1808 VAPWR.n650 VAPWR.n359 11.5205
R1809 VAPWR.n654 VAPWR.n359 11.5205
R1810 VAPWR.n654 VAPWR.n349 11.5205
R1811 VAPWR.n666 VAPWR.n349 11.5205
R1812 VAPWR.n666 VAPWR.n347 11.5205
R1813 VAPWR.n670 VAPWR.n347 11.5205
R1814 VAPWR.n670 VAPWR.n336 11.5205
R1815 VAPWR.n683 VAPWR.n336 11.5205
R1816 VAPWR.n683 VAPWR.n333 11.5205
R1817 VAPWR.n688 VAPWR.n333 11.5205
R1818 VAPWR.n688 VAPWR.n334 11.5205
R1819 VAPWR.n334 VAPWR.n321 11.5205
R1820 VAPWR.n701 VAPWR.n321 11.5205
R1821 VAPWR.n701 VAPWR.n319 11.5205
R1822 VAPWR.n705 VAPWR.n319 11.5205
R1823 VAPWR.n705 VAPWR.n310 11.5205
R1824 VAPWR.n720 VAPWR.n310 11.5205
R1825 VAPWR.n720 VAPWR.n307 11.5205
R1826 VAPWR.n727 VAPWR.n307 11.5205
R1827 VAPWR.n727 VAPWR.n308 11.5205
R1828 VAPWR.n723 VAPWR.n308 11.5205
R1829 VAPWR.n723 VAPWR.n265 11.5205
R1830 VAPWR.n744 VAPWR.n265 11.5205
R1831 VAPWR.n744 VAPWR.n263 11.5205
R1832 VAPWR.n748 VAPWR.n263 11.5205
R1833 VAPWR.n748 VAPWR.n259 11.5205
R1834 VAPWR.n755 VAPWR.n259 11.5205
R1835 VAPWR.n755 VAPWR.n257 11.5205
R1836 VAPWR.n759 VAPWR.n257 11.5205
R1837 VAPWR.n759 VAPWR.n253 11.5205
R1838 VAPWR.n766 VAPWR.n253 11.5205
R1839 VAPWR.n766 VAPWR.n251 11.5205
R1840 VAPWR.n770 VAPWR.n251 11.5205
R1841 VAPWR.n770 VAPWR.n248 11.5205
R1842 VAPWR.n778 VAPWR.n248 11.5205
R1843 VAPWR.n778 VAPWR.n246 11.5205
R1844 VAPWR.n782 VAPWR.n246 11.5205
R1845 VAPWR.n782 VAPWR.n243 11.5205
R1846 VAPWR.n790 VAPWR.n243 11.5205
R1847 VAPWR.n790 VAPWR.n241 11.5205
R1848 VAPWR.n794 VAPWR.n241 11.5205
R1849 VAPWR.n794 VAPWR.n238 11.5205
R1850 VAPWR.n801 VAPWR.n238 11.5205
R1851 VAPWR.n801 VAPWR.n236 11.5205
R1852 VAPWR.n805 VAPWR.n236 11.5205
R1853 VAPWR.n805 VAPWR.n232 11.5205
R1854 VAPWR.n812 VAPWR.n232 11.5205
R1855 VAPWR.n812 VAPWR.n230 11.5205
R1856 VAPWR.n816 VAPWR.n230 11.5205
R1857 VAPWR.n816 VAPWR.n225 11.5205
R1858 VAPWR.n822 VAPWR.n225 11.5205
R1859 VAPWR.n822 VAPWR.n223 11.5205
R1860 VAPWR.n826 VAPWR.n223 11.5205
R1861 VAPWR.n826 VAPWR.n218 11.5205
R1862 VAPWR.n832 VAPWR.n218 11.5205
R1863 VAPWR.n832 VAPWR.n216 11.5205
R1864 VAPWR.n836 VAPWR.n216 11.5205
R1865 VAPWR.n836 VAPWR.n211 11.5205
R1866 VAPWR.n844 VAPWR.n211 11.5205
R1867 VAPWR.n844 VAPWR.n209 11.5205
R1868 VAPWR.n848 VAPWR.n209 11.5205
R1869 VAPWR.n848 VAPWR.n206 11.5205
R1870 VAPWR.n854 VAPWR.n206 11.5205
R1871 VAPWR.n854 VAPWR.n204 11.5205
R1872 VAPWR.n858 VAPWR.n204 11.5205
R1873 VAPWR.n858 VAPWR.n199 11.5205
R1874 VAPWR.n864 VAPWR.n199 11.5205
R1875 VAPWR.n864 VAPWR.n197 11.5205
R1876 VAPWR.n868 VAPWR.n197 11.5205
R1877 VAPWR.n868 VAPWR.n192 11.5205
R1878 VAPWR.n874 VAPWR.n192 11.5205
R1879 VAPWR.n874 VAPWR.n190 11.5205
R1880 VAPWR.n878 VAPWR.n190 11.5205
R1881 VAPWR.n878 VAPWR.n185 11.5205
R1882 VAPWR.n906 VAPWR.n185 11.5205
R1883 VAPWR.n906 VAPWR.n183 11.5205
R1884 VAPWR.n948 VAPWR.n947 11.5205
R1885 VAPWR.n947 VAPWR.n946 11.5205
R1886 VAPWR.n946 VAPWR.n155 11.5205
R1887 VAPWR.n942 VAPWR.n155 11.5205
R1888 VAPWR.n942 VAPWR.n941 11.5205
R1889 VAPWR.n941 VAPWR.n940 11.5205
R1890 VAPWR.n940 VAPWR.n160 11.5205
R1891 VAPWR.n936 VAPWR.n160 11.5205
R1892 VAPWR.n936 VAPWR.n935 11.5205
R1893 VAPWR.n935 VAPWR.n934 11.5205
R1894 VAPWR.n934 VAPWR.n165 11.5205
R1895 VAPWR.n930 VAPWR.n165 11.5205
R1896 VAPWR.n930 VAPWR.n929 11.5205
R1897 VAPWR.n929 VAPWR.n168 11.5205
R1898 VAPWR.n925 VAPWR.n168 11.5205
R1899 VAPWR.n925 VAPWR.n924 11.5205
R1900 VAPWR.n924 VAPWR.n923 11.5205
R1901 VAPWR.n923 VAPWR.n173 11.5205
R1902 VAPWR.n919 VAPWR.n173 11.5205
R1903 VAPWR.n919 VAPWR.n918 11.5205
R1904 VAPWR.n918 VAPWR.n917 11.5205
R1905 VAPWR.n917 VAPWR.n178 11.5205
R1906 VAPWR.n913 VAPWR.n178 11.5205
R1907 VAPWR.n913 VAPWR.n912 11.5205
R1908 VAPWR.n912 VAPWR.n911 11.5205
R1909 VAPWR.n127 VAPWR.n111 11.1185
R1910 VAPWR.n103 VAPWR.n81 11.1185
R1911 VAPWR.n63 VAPWR.n38 11.1185
R1912 VAPWR.n300 VAPWR.n272 11.1185
R1913 VAPWR.n455 VAPWR.n427 11.1185
R1914 VAPWR.t34 VAPWR.n392 9.58033
R1915 VAPWR.n618 VAPWR.t28 9.58033
R1916 VAPWR.t16 VAPWR.n330 9.58033
R1917 VAPWR.n707 VAPWR.t10 9.58033
R1918 VAPWR.t68 VAPWR.n751 9.58033
R1919 VAPWR.n788 VAPWR.t56 9.58033
R1920 VAPWR.t50 VAPWR.n808 9.58033
R1921 VAPWR.n830 VAPWR.t0 9.58033
R1922 VAPWR.n111 VAPWR.n110 9.3005
R1923 VAPWR.n125 VAPWR.n124 9.3005
R1924 VAPWR.n123 VAPWR.n113 9.3005
R1925 VAPWR.n122 VAPWR.n121 9.3005
R1926 VAPWR.n120 VAPWR.n114 9.3005
R1927 VAPWR.n81 VAPWR.n80 9.3005
R1928 VAPWR.n101 VAPWR.n100 9.3005
R1929 VAPWR.n99 VAPWR.n83 9.3005
R1930 VAPWR.n98 VAPWR.n97 9.3005
R1931 VAPWR.n96 VAPWR.n84 9.3005
R1932 VAPWR.n95 VAPWR.n94 9.3005
R1933 VAPWR.n93 VAPWR.n88 9.3005
R1934 VAPWR.n38 VAPWR.n37 9.3005
R1935 VAPWR.n61 VAPWR.n60 9.3005
R1936 VAPWR.n59 VAPWR.n40 9.3005
R1937 VAPWR.n58 VAPWR.n57 9.3005
R1938 VAPWR.n56 VAPWR.n41 9.3005
R1939 VAPWR.n55 VAPWR.n54 9.3005
R1940 VAPWR.n53 VAPWR.n45 9.3005
R1941 VAPWR.n52 VAPWR.n51 9.3005
R1942 VAPWR.n272 VAPWR.n271 9.3005
R1943 VAPWR.n298 VAPWR.n297 9.3005
R1944 VAPWR.n296 VAPWR.n274 9.3005
R1945 VAPWR.n295 VAPWR.n294 9.3005
R1946 VAPWR.n293 VAPWR.n275 9.3005
R1947 VAPWR.n292 VAPWR.n291 9.3005
R1948 VAPWR.n290 VAPWR.n279 9.3005
R1949 VAPWR.n289 VAPWR.n288 9.3005
R1950 VAPWR.n287 VAPWR.n280 9.3005
R1951 VAPWR.n427 VAPWR.n426 9.3005
R1952 VAPWR.n453 VAPWR.n452 9.3005
R1953 VAPWR.n451 VAPWR.n429 9.3005
R1954 VAPWR.n450 VAPWR.n449 9.3005
R1955 VAPWR.n448 VAPWR.n430 9.3005
R1956 VAPWR.n447 VAPWR.n446 9.3005
R1957 VAPWR.n445 VAPWR.n434 9.3005
R1958 VAPWR.n444 VAPWR.n443 9.3005
R1959 VAPWR.n442 VAPWR.n435 9.3005
R1960 VAPWR.n911 VAPWR.n910 9.3005
R1961 VAPWR.n912 VAPWR.n179 9.3005
R1962 VAPWR.n914 VAPWR.n913 9.3005
R1963 VAPWR.n915 VAPWR.n178 9.3005
R1964 VAPWR.n917 VAPWR.n916 9.3005
R1965 VAPWR.n918 VAPWR.n174 9.3005
R1966 VAPWR.n920 VAPWR.n919 9.3005
R1967 VAPWR.n921 VAPWR.n173 9.3005
R1968 VAPWR.n923 VAPWR.n922 9.3005
R1969 VAPWR.n924 VAPWR.n169 9.3005
R1970 VAPWR.n926 VAPWR.n925 9.3005
R1971 VAPWR.n927 VAPWR.n168 9.3005
R1972 VAPWR.n929 VAPWR.n928 9.3005
R1973 VAPWR.n931 VAPWR.n930 9.3005
R1974 VAPWR.n932 VAPWR.n165 9.3005
R1975 VAPWR.n934 VAPWR.n933 9.3005
R1976 VAPWR.n935 VAPWR.n161 9.3005
R1977 VAPWR.n937 VAPWR.n936 9.3005
R1978 VAPWR.n938 VAPWR.n160 9.3005
R1979 VAPWR.n940 VAPWR.n939 9.3005
R1980 VAPWR.n941 VAPWR.n156 9.3005
R1981 VAPWR.n943 VAPWR.n942 9.3005
R1982 VAPWR.n944 VAPWR.n155 9.3005
R1983 VAPWR.n946 VAPWR.n945 9.3005
R1984 VAPWR.n947 VAPWR.n151 9.3005
R1985 VAPWR.n949 VAPWR.n948 9.3005
R1986 VAPWR.n908 VAPWR.n183 9.3005
R1987 VAPWR.n907 VAPWR.n906 9.3005
R1988 VAPWR.n185 VAPWR.n184 9.3005
R1989 VAPWR.n878 VAPWR.n877 9.3005
R1990 VAPWR.n876 VAPWR.n190 9.3005
R1991 VAPWR.n875 VAPWR.n874 9.3005
R1992 VAPWR.n192 VAPWR.n191 9.3005
R1993 VAPWR.n868 VAPWR.n867 9.3005
R1994 VAPWR.n866 VAPWR.n197 9.3005
R1995 VAPWR.n865 VAPWR.n864 9.3005
R1996 VAPWR.n199 VAPWR.n198 9.3005
R1997 VAPWR.n858 VAPWR.n857 9.3005
R1998 VAPWR.n856 VAPWR.n204 9.3005
R1999 VAPWR.n855 VAPWR.n854 9.3005
R2000 VAPWR.n206 VAPWR.n205 9.3005
R2001 VAPWR.n848 VAPWR.n847 9.3005
R2002 VAPWR.n846 VAPWR.n209 9.3005
R2003 VAPWR.n845 VAPWR.n844 9.3005
R2004 VAPWR.n211 VAPWR.n210 9.3005
R2005 VAPWR.n836 VAPWR.n835 9.3005
R2006 VAPWR.n834 VAPWR.n216 9.3005
R2007 VAPWR.n833 VAPWR.n832 9.3005
R2008 VAPWR.n218 VAPWR.n217 9.3005
R2009 VAPWR.n826 VAPWR.n825 9.3005
R2010 VAPWR.n824 VAPWR.n223 9.3005
R2011 VAPWR.n823 VAPWR.n822 9.3005
R2012 VAPWR.n225 VAPWR.n224 9.3005
R2013 VAPWR.n816 VAPWR.n815 9.3005
R2014 VAPWR.n814 VAPWR.n230 9.3005
R2015 VAPWR.n813 VAPWR.n812 9.3005
R2016 VAPWR.n232 VAPWR.n231 9.3005
R2017 VAPWR.n805 VAPWR.n804 9.3005
R2018 VAPWR.n803 VAPWR.n236 9.3005
R2019 VAPWR.n802 VAPWR.n801 9.3005
R2020 VAPWR.n238 VAPWR.n237 9.3005
R2021 VAPWR.n794 VAPWR.n793 9.3005
R2022 VAPWR.n792 VAPWR.n241 9.3005
R2023 VAPWR.n791 VAPWR.n790 9.3005
R2024 VAPWR.n243 VAPWR.n242 9.3005
R2025 VAPWR.n782 VAPWR.n781 9.3005
R2026 VAPWR.n780 VAPWR.n246 9.3005
R2027 VAPWR.n779 VAPWR.n778 9.3005
R2028 VAPWR.n248 VAPWR.n247 9.3005
R2029 VAPWR.n770 VAPWR.n769 9.3005
R2030 VAPWR.n768 VAPWR.n251 9.3005
R2031 VAPWR.n767 VAPWR.n766 9.3005
R2032 VAPWR.n253 VAPWR.n252 9.3005
R2033 VAPWR.n759 VAPWR.n758 9.3005
R2034 VAPWR.n757 VAPWR.n257 9.3005
R2035 VAPWR.n756 VAPWR.n755 9.3005
R2036 VAPWR.n259 VAPWR.n258 9.3005
R2037 VAPWR.n748 VAPWR.n747 9.3005
R2038 VAPWR.n746 VAPWR.n263 9.3005
R2039 VAPWR.n745 VAPWR.n744 9.3005
R2040 VAPWR.n265 VAPWR.n264 9.3005
R2041 VAPWR.n724 VAPWR.n723 9.3005
R2042 VAPWR.n725 VAPWR.n308 9.3005
R2043 VAPWR.n727 VAPWR.n726 9.3005
R2044 VAPWR.n722 VAPWR.n307 9.3005
R2045 VAPWR.n721 VAPWR.n720 9.3005
R2046 VAPWR.n310 VAPWR.n309 9.3005
R2047 VAPWR.n705 VAPWR.n704 9.3005
R2048 VAPWR.n703 VAPWR.n319 9.3005
R2049 VAPWR.n702 VAPWR.n701 9.3005
R2050 VAPWR.n321 VAPWR.n320 9.3005
R2051 VAPWR.n686 VAPWR.n334 9.3005
R2052 VAPWR.n688 VAPWR.n687 9.3005
R2053 VAPWR.n685 VAPWR.n333 9.3005
R2054 VAPWR.n684 VAPWR.n683 9.3005
R2055 VAPWR.n336 VAPWR.n335 9.3005
R2056 VAPWR.n670 VAPWR.n669 9.3005
R2057 VAPWR.n668 VAPWR.n347 9.3005
R2058 VAPWR.n667 VAPWR.n666 9.3005
R2059 VAPWR.n349 VAPWR.n348 9.3005
R2060 VAPWR.n654 VAPWR.n653 9.3005
R2061 VAPWR.n652 VAPWR.n359 9.3005
R2062 VAPWR.n651 VAPWR.n650 9.3005
R2063 VAPWR.n361 VAPWR.n360 9.3005
R2064 VAPWR.n635 VAPWR.n634 9.3005
R2065 VAPWR.n633 VAPWR.n369 9.3005
R2066 VAPWR.n632 VAPWR.n631 9.3005
R2067 VAPWR.n371 VAPWR.n370 9.3005
R2068 VAPWR.n616 VAPWR.n615 9.3005
R2069 VAPWR.n614 VAPWR.n380 9.3005
R2070 VAPWR.n613 VAPWR.n612 9.3005
R2071 VAPWR.n382 VAPWR.n381 9.3005
R2072 VAPWR.n600 VAPWR.n599 9.3005
R2073 VAPWR.n598 VAPWR.n394 9.3005
R2074 VAPWR.n597 VAPWR.n596 9.3005
R2075 VAPWR.n396 VAPWR.n395 9.3005
R2076 VAPWR.n583 VAPWR.n582 9.3005
R2077 VAPWR.n581 VAPWR.n407 9.3005
R2078 VAPWR.n580 VAPWR.n579 9.3005
R2079 VAPWR.n409 VAPWR.n408 9.3005
R2080 VAPWR.n567 VAPWR.n566 9.3005
R2081 VAPWR.n565 VAPWR.n420 9.3005
R2082 VAPWR.n564 VAPWR.n563 9.3005
R2083 VAPWR.n422 VAPWR.n421 9.3005
R2084 VAPWR.n549 VAPWR.n548 9.3005
R2085 VAPWR.n458 VAPWR.n457 9.3005
R2086 VAPWR.n487 VAPWR.n486 9.3005
R2087 VAPWR.n485 VAPWR.n484 9.3005
R2088 VAPWR.n494 VAPWR.n493 9.3005
R2089 VAPWR.n495 VAPWR.n483 9.3005
R2090 VAPWR.n497 VAPWR.n496 9.3005
R2091 VAPWR.n481 VAPWR.n480 9.3005
R2092 VAPWR.n504 VAPWR.n503 9.3005
R2093 VAPWR.n505 VAPWR.n479 9.3005
R2094 VAPWR.n507 VAPWR.n506 9.3005
R2095 VAPWR.n477 VAPWR.n476 9.3005
R2096 VAPWR.n514 VAPWR.n513 9.3005
R2097 VAPWR.n515 VAPWR.n475 9.3005
R2098 VAPWR.n517 VAPWR.n516 9.3005
R2099 VAPWR.n473 VAPWR.n472 9.3005
R2100 VAPWR.n524 VAPWR.n523 9.3005
R2101 VAPWR.n525 VAPWR.n471 9.3005
R2102 VAPWR.n527 VAPWR.n526 9.3005
R2103 VAPWR.n469 VAPWR.n468 9.3005
R2104 VAPWR.n534 VAPWR.n533 9.3005
R2105 VAPWR.n535 VAPWR.n467 9.3005
R2106 VAPWR.n538 VAPWR.n537 9.3005
R2107 VAPWR.n536 VAPWR.n465 9.3005
R2108 VAPWR.n464 VAPWR.n463 9.3005
R2109 VAPWR.n546 VAPWR.n545 9.3005
R2110 VAPWR.n547 VAPWR.n462 9.3005
R2111 VAPWR.n555 VAPWR.n554 9.3005
R2112 VAPWR.n557 VAPWR.n425 9.3005
R2113 VAPWR.n559 VAPWR.n558 9.3005
R2114 VAPWR.n416 VAPWR.n415 9.3005
R2115 VAPWR.n571 VAPWR.n570 9.3005
R2116 VAPWR.n572 VAPWR.n413 9.3005
R2117 VAPWR.n575 VAPWR.n574 9.3005
R2118 VAPWR.n403 VAPWR.n402 9.3005
R2119 VAPWR.n588 VAPWR.n587 9.3005
R2120 VAPWR.n589 VAPWR.n400 9.3005
R2121 VAPWR.n592 VAPWR.n591 9.3005
R2122 VAPWR.n390 VAPWR.n389 9.3005
R2123 VAPWR.n605 VAPWR.n604 9.3005
R2124 VAPWR.n606 VAPWR.n387 9.3005
R2125 VAPWR.n608 VAPWR.n607 9.3005
R2126 VAPWR.n377 VAPWR.n376 9.3005
R2127 VAPWR.n622 VAPWR.n621 9.3005
R2128 VAPWR.n623 VAPWR.n375 9.3005
R2129 VAPWR.n627 VAPWR.n626 9.3005
R2130 VAPWR.n366 VAPWR.n365 9.3005
R2131 VAPWR.n641 VAPWR.n640 9.3005
R2132 VAPWR.n642 VAPWR.n364 9.3005
R2133 VAPWR.n646 VAPWR.n645 9.3005
R2134 VAPWR.n355 VAPWR.n354 9.3005
R2135 VAPWR.n658 VAPWR.n657 9.3005
R2136 VAPWR.n659 VAPWR.n353 9.3005
R2137 VAPWR.n662 VAPWR.n661 9.3005
R2138 VAPWR.n660 VAPWR.n343 9.3005
R2139 VAPWR.n675 VAPWR.n674 9.3005
R2140 VAPWR.n676 VAPWR.n340 9.3005
R2141 VAPWR.n679 VAPWR.n678 9.3005
R2142 VAPWR.n677 VAPWR.n328 9.3005
R2143 VAPWR.n693 VAPWR.n692 9.3005
R2144 VAPWR.n694 VAPWR.n325 9.3005
R2145 VAPWR.n696 VAPWR.n695 9.3005
R2146 VAPWR.n316 VAPWR.n315 9.3005
R2147 VAPWR.n711 VAPWR.n710 9.3005
R2148 VAPWR.n713 VAPWR.n313 9.3005
R2149 VAPWR.n715 VAPWR.n714 9.3005
R2150 VAPWR.n303 VAPWR.n302 9.3005
R2151 VAPWR.n733 VAPWR.n732 9.3005
R2152 VAPWR.n735 VAPWR.n270 9.3005
R2153 VAPWR.n737 VAPWR.n736 9.3005
R2154 VAPWR.n2 VAPWR.n0 9.3005
R2155 VAPWR.n1040 VAPWR.n1039 9.3005
R2156 VAPWR.n1038 VAPWR.n1 9.3005
R2157 VAPWR.n1037 VAPWR.n1036 9.3005
R2158 VAPWR.n1034 VAPWR.n6 9.3005
R2159 VAPWR.n1033 VAPWR.n1032 9.3005
R2160 VAPWR.n1031 VAPWR.n8 9.3005
R2161 VAPWR.n1030 VAPWR.n1029 9.3005
R2162 VAPWR.n1027 VAPWR.n12 9.3005
R2163 VAPWR.n1026 VAPWR.n1025 9.3005
R2164 VAPWR.n1024 VAPWR.n14 9.3005
R2165 VAPWR.n1023 VAPWR.n1022 9.3005
R2166 VAPWR.n1021 VAPWR.n18 9.3005
R2167 VAPWR.n1019 VAPWR.n1018 9.3005
R2168 VAPWR.n1017 VAPWR.n20 9.3005
R2169 VAPWR.n1016 VAPWR.n1015 9.3005
R2170 VAPWR.n1014 VAPWR.n24 9.3005
R2171 VAPWR.n1012 VAPWR.n1011 9.3005
R2172 VAPWR.n1010 VAPWR.n26 9.3005
R2173 VAPWR.n1009 VAPWR.n1008 9.3005
R2174 VAPWR.n1007 VAPWR.n30 9.3005
R2175 VAPWR.n1006 VAPWR.n1005 9.3005
R2176 VAPWR.n1004 VAPWR.n32 9.3005
R2177 VAPWR.n1003 VAPWR.n1002 9.3005
R2178 VAPWR.n1001 VAPWR.n36 9.3005
R2179 VAPWR.n1000 VAPWR.n999 9.3005
R2180 VAPWR.n998 VAPWR.n997 9.3005
R2181 VAPWR.n996 VAPWR.n68 9.3005
R2182 VAPWR.n995 VAPWR.n994 9.3005
R2183 VAPWR.n993 VAPWR.n69 9.3005
R2184 VAPWR.n992 VAPWR.n991 9.3005
R2185 VAPWR.n990 VAPWR.n73 9.3005
R2186 VAPWR.n989 VAPWR.n988 9.3005
R2187 VAPWR.n987 VAPWR.n75 9.3005
R2188 VAPWR.n986 VAPWR.n985 9.3005
R2189 VAPWR.n984 VAPWR.n79 9.3005
R2190 VAPWR.n982 VAPWR.n981 9.3005
R2191 VAPWR.n980 VAPWR.n105 9.3005
R2192 VAPWR.n979 VAPWR.n978 9.3005
R2193 VAPWR.n977 VAPWR.n109 9.3005
R2194 VAPWR.n976 VAPWR.n975 9.3005
R2195 VAPWR.n974 VAPWR.n129 9.3005
R2196 VAPWR.n973 VAPWR.n972 9.3005
R2197 VAPWR.n971 VAPWR.n133 9.3005
R2198 VAPWR.n970 VAPWR.n969 9.3005
R2199 VAPWR.n968 VAPWR.n134 9.3005
R2200 VAPWR.n967 VAPWR.n966 9.3005
R2201 VAPWR.n964 VAPWR.n138 9.3005
R2202 VAPWR.n963 VAPWR.n962 9.3005
R2203 VAPWR.n961 VAPWR.n139 9.3005
R2204 VAPWR.n960 VAPWR.n959 9.3005
R2205 VAPWR.n958 VAPWR.n143 9.3005
R2206 VAPWR.n957 VAPWR.n956 9.3005
R2207 VAPWR.n955 VAPWR.n145 9.3005
R2208 VAPWR.n954 VAPWR.n953 9.3005
R2209 VAPWR.n951 VAPWR.n149 9.3005
R2210 VAPWR.n286 VAPWR.n285 6.49676
R2211 VAPWR.n441 VAPWR.n440 6.49676
R2212 VAPWR.n50 VAPWR.n46 6.49675
R2213 VAPWR.n92 VAPWR.n91 6.49672
R2214 VAPWR.n119 VAPWR.n118 6.49621
R2215 VAPWR.n561 VAPWR.t42 6.38705
R2216 VAPWR.n577 VAPWR.t38 6.38705
R2217 VAPWR.n648 VAPWR.t24 6.38705
R2218 VAPWR.n664 VAPWR.t20 6.38705
R2219 VAPWR.n763 VAPWR.t64 6.38705
R2220 VAPWR.t60 VAPWR.n774 6.38705
R2221 VAPWR.t6 VAPWR.n881 6.38705
R2222 VAPWR.n74 VAPWR.t5 4.26389
R2223 VAPWR.n74 VAPWR.t3 4.26389
R2224 VAPWR.n950 VAPWR.n150 4.20883
R2225 VAPWR.n909 VAPWR.n150 4.20883
R2226 VAPWR.n31 VAPWR.t55 3.90909
R2227 VAPWR.n31 VAPWR.t53 3.90909
R2228 VAPWR.n25 VAPWR.t59 3.90909
R2229 VAPWR.n25 VAPWR.t57 3.90909
R2230 VAPWR.n19 VAPWR.t63 3.90909
R2231 VAPWR.n19 VAPWR.t61 3.90909
R2232 VAPWR.n13 VAPWR.t67 3.90909
R2233 VAPWR.n13 VAPWR.t65 3.90909
R2234 VAPWR.n7 VAPWR.t71 3.90909
R2235 VAPWR.n7 VAPWR.t69 3.90909
R2236 VAPWR.n388 VAPWR.t33 3.58175
R2237 VAPWR.n388 VAPWR.t31 3.58175
R2238 VAPWR.n314 VAPWR.t13 3.58175
R2239 VAPWR.n314 VAPWR.t11 3.58175
R2240 VAPWR.n326 VAPWR.t17 3.58175
R2241 VAPWR.n326 VAPWR.t15 3.58175
R2242 VAPWR.n341 VAPWR.t21 3.58175
R2243 VAPWR.n341 VAPWR.t19 3.58175
R2244 VAPWR.n643 VAPWR.t25 3.58175
R2245 VAPWR.n643 VAPWR.t23 3.58175
R2246 VAPWR.n624 VAPWR.t29 3.58175
R2247 VAPWR.n624 VAPWR.t27 3.58175
R2248 VAPWR.n401 VAPWR.t37 3.58175
R2249 VAPWR.n401 VAPWR.t35 3.58175
R2250 VAPWR.n414 VAPWR.t41 3.58175
R2251 VAPWR.n414 VAPWR.t39 3.58175
R2252 VAPWR.t32 VAPWR.n384 3.19378
R2253 VAPWR.n385 VAPWR.t30 3.19378
R2254 VAPWR.t14 VAPWR.n323 3.19378
R2255 VAPWR.n699 VAPWR.t12 3.19378
R2256 VAPWR.n742 VAPWR.t70 3.19378
R2257 VAPWR.n797 VAPWR.t54 3.19378
R2258 VAPWR.n799 VAPWR.t52 3.19378
R2259 VAPWR.n820 VAPWR.t4 3.19378
R2260 VAPWR.t2 VAPWR.n828 3.19378
R2261 VAPWR.n850 VAPWR.t46 3.19378
R2262 VAPWR.n129 VAPWR.n128 1.00328
R2263 VAPWR.n118 VAPWR.n114 0.930838
R2264 VAPWR.n93 VAPWR.n92 0.930321
R2265 VAPWR.n52 VAPWR.n46 0.930287
R2266 VAPWR.n285 VAPWR.n280 0.930277
R2267 VAPWR.n440 VAPWR.n435 0.930277
R2268 VAPWR.n983 VAPWR.n104 0.569944
R2269 VAPWR.n910 VAPWR.n909 0.398938
R2270 VAPWR.n65 VAPWR.n64 0.385222
R2271 VAPWR.n950 VAPWR.n949 0.378625
R2272 VAPWR.n548 VAPWR.n547 0.347375
R2273 VAPWR VAPWR.n1041 0.32388
R2274 VAPWR.n555 VAPWR.n457 0.195708
R2275 VAPWR.n734 VAPWR.n301 0.192167
R2276 VAPWR.n556 VAPWR.n456 0.192167
R2277 VAPWR.n949 VAPWR.n151 0.1805
R2278 VAPWR.n945 VAPWR.n151 0.1805
R2279 VAPWR.n945 VAPWR.n944 0.1805
R2280 VAPWR.n944 VAPWR.n943 0.1805
R2281 VAPWR.n943 VAPWR.n156 0.1805
R2282 VAPWR.n939 VAPWR.n156 0.1805
R2283 VAPWR.n939 VAPWR.n938 0.1805
R2284 VAPWR.n938 VAPWR.n937 0.1805
R2285 VAPWR.n937 VAPWR.n161 0.1805
R2286 VAPWR.n933 VAPWR.n161 0.1805
R2287 VAPWR.n933 VAPWR.n932 0.1805
R2288 VAPWR.n932 VAPWR.n931 0.1805
R2289 VAPWR.n928 VAPWR.n927 0.1805
R2290 VAPWR.n927 VAPWR.n926 0.1805
R2291 VAPWR.n926 VAPWR.n169 0.1805
R2292 VAPWR.n922 VAPWR.n169 0.1805
R2293 VAPWR.n922 VAPWR.n921 0.1805
R2294 VAPWR.n921 VAPWR.n920 0.1805
R2295 VAPWR.n920 VAPWR.n174 0.1805
R2296 VAPWR.n916 VAPWR.n174 0.1805
R2297 VAPWR.n916 VAPWR.n915 0.1805
R2298 VAPWR.n915 VAPWR.n914 0.1805
R2299 VAPWR.n914 VAPWR.n179 0.1805
R2300 VAPWR.n910 VAPWR.n179 0.1805
R2301 VAPWR.n909 VAPWR.n908 0.136437
R2302 VAPWR.n548 VAPWR.n421 0.113
R2303 VAPWR.n564 VAPWR.n421 0.113
R2304 VAPWR.n565 VAPWR.n564 0.113
R2305 VAPWR.n566 VAPWR.n565 0.113
R2306 VAPWR.n566 VAPWR.n408 0.113
R2307 VAPWR.n580 VAPWR.n408 0.113
R2308 VAPWR.n581 VAPWR.n580 0.113
R2309 VAPWR.n582 VAPWR.n581 0.113
R2310 VAPWR.n582 VAPWR.n395 0.113
R2311 VAPWR.n597 VAPWR.n395 0.113
R2312 VAPWR.n598 VAPWR.n597 0.113
R2313 VAPWR.n599 VAPWR.n598 0.113
R2314 VAPWR.n599 VAPWR.n381 0.113
R2315 VAPWR.n613 VAPWR.n381 0.113
R2316 VAPWR.n614 VAPWR.n613 0.113
R2317 VAPWR.n615 VAPWR.n614 0.113
R2318 VAPWR.n615 VAPWR.n370 0.113
R2319 VAPWR.n632 VAPWR.n370 0.113
R2320 VAPWR.n633 VAPWR.n632 0.113
R2321 VAPWR.n634 VAPWR.n633 0.113
R2322 VAPWR.n634 VAPWR.n360 0.113
R2323 VAPWR.n651 VAPWR.n360 0.113
R2324 VAPWR.n652 VAPWR.n651 0.113
R2325 VAPWR.n653 VAPWR.n652 0.113
R2326 VAPWR.n653 VAPWR.n348 0.113
R2327 VAPWR.n667 VAPWR.n348 0.113
R2328 VAPWR.n668 VAPWR.n667 0.113
R2329 VAPWR.n669 VAPWR.n668 0.113
R2330 VAPWR.n669 VAPWR.n335 0.113
R2331 VAPWR.n684 VAPWR.n335 0.113
R2332 VAPWR.n685 VAPWR.n684 0.113
R2333 VAPWR.n687 VAPWR.n685 0.113
R2334 VAPWR.n687 VAPWR.n686 0.113
R2335 VAPWR.n686 VAPWR.n320 0.113
R2336 VAPWR.n702 VAPWR.n320 0.113
R2337 VAPWR.n703 VAPWR.n702 0.113
R2338 VAPWR.n704 VAPWR.n703 0.113
R2339 VAPWR.n704 VAPWR.n309 0.113
R2340 VAPWR.n721 VAPWR.n309 0.113
R2341 VAPWR.n722 VAPWR.n721 0.113
R2342 VAPWR.n726 VAPWR.n722 0.113
R2343 VAPWR.n726 VAPWR.n725 0.113
R2344 VAPWR.n725 VAPWR.n724 0.113
R2345 VAPWR.n724 VAPWR.n264 0.113
R2346 VAPWR.n745 VAPWR.n264 0.113
R2347 VAPWR.n746 VAPWR.n745 0.113
R2348 VAPWR.n747 VAPWR.n746 0.113
R2349 VAPWR.n747 VAPWR.n258 0.113
R2350 VAPWR.n756 VAPWR.n258 0.113
R2351 VAPWR.n757 VAPWR.n756 0.113
R2352 VAPWR.n758 VAPWR.n757 0.113
R2353 VAPWR.n758 VAPWR.n252 0.113
R2354 VAPWR.n767 VAPWR.n252 0.113
R2355 VAPWR.n768 VAPWR.n767 0.113
R2356 VAPWR.n769 VAPWR.n768 0.113
R2357 VAPWR.n769 VAPWR.n247 0.113
R2358 VAPWR.n779 VAPWR.n247 0.113
R2359 VAPWR.n780 VAPWR.n779 0.113
R2360 VAPWR.n781 VAPWR.n780 0.113
R2361 VAPWR.n781 VAPWR.n242 0.113
R2362 VAPWR.n791 VAPWR.n242 0.113
R2363 VAPWR.n792 VAPWR.n791 0.113
R2364 VAPWR.n793 VAPWR.n792 0.113
R2365 VAPWR.n793 VAPWR.n237 0.113
R2366 VAPWR.n802 VAPWR.n237 0.113
R2367 VAPWR.n803 VAPWR.n802 0.113
R2368 VAPWR.n804 VAPWR.n803 0.113
R2369 VAPWR.n804 VAPWR.n231 0.113
R2370 VAPWR.n813 VAPWR.n231 0.113
R2371 VAPWR.n814 VAPWR.n813 0.113
R2372 VAPWR.n815 VAPWR.n814 0.113
R2373 VAPWR.n815 VAPWR.n224 0.113
R2374 VAPWR.n823 VAPWR.n224 0.113
R2375 VAPWR.n824 VAPWR.n823 0.113
R2376 VAPWR.n825 VAPWR.n824 0.113
R2377 VAPWR.n825 VAPWR.n217 0.113
R2378 VAPWR.n833 VAPWR.n217 0.113
R2379 VAPWR.n834 VAPWR.n833 0.113
R2380 VAPWR.n835 VAPWR.n834 0.113
R2381 VAPWR.n835 VAPWR.n210 0.113
R2382 VAPWR.n845 VAPWR.n210 0.113
R2383 VAPWR.n846 VAPWR.n845 0.113
R2384 VAPWR.n847 VAPWR.n846 0.113
R2385 VAPWR.n847 VAPWR.n205 0.113
R2386 VAPWR.n855 VAPWR.n205 0.113
R2387 VAPWR.n856 VAPWR.n855 0.113
R2388 VAPWR.n857 VAPWR.n856 0.113
R2389 VAPWR.n857 VAPWR.n198 0.113
R2390 VAPWR.n865 VAPWR.n198 0.113
R2391 VAPWR.n866 VAPWR.n865 0.113
R2392 VAPWR.n867 VAPWR.n866 0.113
R2393 VAPWR.n867 VAPWR.n191 0.113
R2394 VAPWR.n875 VAPWR.n191 0.113
R2395 VAPWR.n876 VAPWR.n875 0.113
R2396 VAPWR.n877 VAPWR.n876 0.113
R2397 VAPWR.n877 VAPWR.n184 0.113
R2398 VAPWR.n907 VAPWR.n184 0.113
R2399 VAPWR.n908 VAPWR.n907 0.113
R2400 VAPWR.n486 VAPWR.n457 0.113
R2401 VAPWR.n486 VAPWR.n484 0.113
R2402 VAPWR.n494 VAPWR.n484 0.113
R2403 VAPWR.n495 VAPWR.n494 0.113
R2404 VAPWR.n496 VAPWR.n495 0.113
R2405 VAPWR.n496 VAPWR.n480 0.113
R2406 VAPWR.n504 VAPWR.n480 0.113
R2407 VAPWR.n505 VAPWR.n504 0.113
R2408 VAPWR.n506 VAPWR.n505 0.113
R2409 VAPWR.n506 VAPWR.n476 0.113
R2410 VAPWR.n514 VAPWR.n476 0.113
R2411 VAPWR.n515 VAPWR.n514 0.113
R2412 VAPWR.n516 VAPWR.n515 0.113
R2413 VAPWR.n516 VAPWR.n472 0.113
R2414 VAPWR.n524 VAPWR.n472 0.113
R2415 VAPWR.n525 VAPWR.n524 0.113
R2416 VAPWR.n526 VAPWR.n525 0.113
R2417 VAPWR.n526 VAPWR.n468 0.113
R2418 VAPWR.n534 VAPWR.n468 0.113
R2419 VAPWR.n535 VAPWR.n534 0.113
R2420 VAPWR.n537 VAPWR.n535 0.113
R2421 VAPWR.n537 VAPWR.n536 0.113
R2422 VAPWR.n536 VAPWR.n463 0.113
R2423 VAPWR.n546 VAPWR.n463 0.113
R2424 VAPWR.n547 VAPWR.n546 0.113
R2425 VAPWR.n128 VAPWR.n110 0.1005
R2426 VAPWR.n124 VAPWR.n110 0.1005
R2427 VAPWR.n124 VAPWR.n123 0.1005
R2428 VAPWR.n123 VAPWR.n122 0.1005
R2429 VAPWR.n122 VAPWR.n114 0.1005
R2430 VAPWR.n104 VAPWR.n80 0.1005
R2431 VAPWR.n100 VAPWR.n80 0.1005
R2432 VAPWR.n100 VAPWR.n99 0.1005
R2433 VAPWR.n99 VAPWR.n98 0.1005
R2434 VAPWR.n98 VAPWR.n84 0.1005
R2435 VAPWR.n94 VAPWR.n84 0.1005
R2436 VAPWR.n94 VAPWR.n93 0.1005
R2437 VAPWR.n64 VAPWR.n37 0.1005
R2438 VAPWR.n60 VAPWR.n37 0.1005
R2439 VAPWR.n60 VAPWR.n59 0.1005
R2440 VAPWR.n59 VAPWR.n58 0.1005
R2441 VAPWR.n58 VAPWR.n41 0.1005
R2442 VAPWR.n54 VAPWR.n41 0.1005
R2443 VAPWR.n54 VAPWR.n53 0.1005
R2444 VAPWR.n53 VAPWR.n52 0.1005
R2445 VAPWR.n301 VAPWR.n271 0.1005
R2446 VAPWR.n297 VAPWR.n271 0.1005
R2447 VAPWR.n297 VAPWR.n296 0.1005
R2448 VAPWR.n296 VAPWR.n295 0.1005
R2449 VAPWR.n295 VAPWR.n275 0.1005
R2450 VAPWR.n291 VAPWR.n275 0.1005
R2451 VAPWR.n291 VAPWR.n290 0.1005
R2452 VAPWR.n290 VAPWR.n289 0.1005
R2453 VAPWR.n289 VAPWR.n280 0.1005
R2454 VAPWR.n456 VAPWR.n426 0.1005
R2455 VAPWR.n452 VAPWR.n426 0.1005
R2456 VAPWR.n452 VAPWR.n451 0.1005
R2457 VAPWR.n451 VAPWR.n450 0.1005
R2458 VAPWR.n450 VAPWR.n430 0.1005
R2459 VAPWR.n446 VAPWR.n430 0.1005
R2460 VAPWR.n446 VAPWR.n445 0.1005
R2461 VAPWR.n445 VAPWR.n444 0.1005
R2462 VAPWR.n444 VAPWR.n435 0.1005
R2463 VAPWR.n931 VAPWR.n150 0.0905
R2464 VAPWR.n928 VAPWR.n150 0.0905
R2465 VAPWR.n951 VAPWR.n950 0.018625
R2466 VAPWR.n558 VAPWR.n557 0.0155
R2467 VAPWR.n558 VAPWR.n415 0.0155
R2468 VAPWR.n571 VAPWR.n415 0.0155
R2469 VAPWR.n572 VAPWR.n571 0.0155
R2470 VAPWR.n574 VAPWR.n402 0.0155
R2471 VAPWR.n588 VAPWR.n402 0.0155
R2472 VAPWR.n589 VAPWR.n588 0.0155
R2473 VAPWR.n591 VAPWR.n389 0.0155
R2474 VAPWR.n605 VAPWR.n389 0.0155
R2475 VAPWR.n606 VAPWR.n605 0.0155
R2476 VAPWR.n607 VAPWR.n606 0.0155
R2477 VAPWR.n607 VAPWR.n376 0.0155
R2478 VAPWR.n622 VAPWR.n376 0.0155
R2479 VAPWR.n623 VAPWR.n622 0.0155
R2480 VAPWR.n626 VAPWR.n623 0.0155
R2481 VAPWR.n641 VAPWR.n365 0.0155
R2482 VAPWR.n642 VAPWR.n641 0.0155
R2483 VAPWR.n645 VAPWR.n642 0.0155
R2484 VAPWR.n658 VAPWR.n354 0.0155
R2485 VAPWR.n659 VAPWR.n658 0.0155
R2486 VAPWR.n661 VAPWR.n659 0.0155
R2487 VAPWR.n661 VAPWR.n660 0.0155
R2488 VAPWR.n676 VAPWR.n675 0.0155
R2489 VAPWR.n678 VAPWR.n676 0.0155
R2490 VAPWR.n678 VAPWR.n677 0.0155
R2491 VAPWR.n694 VAPWR.n693 0.0155
R2492 VAPWR.n695 VAPWR.n694 0.0155
R2493 VAPWR.n695 VAPWR.n315 0.0155
R2494 VAPWR.n711 VAPWR.n315 0.0155
R2495 VAPWR.n714 VAPWR.n713 0.0155
R2496 VAPWR.n714 VAPWR.n302 0.0155
R2497 VAPWR.n733 VAPWR.n302 0.0155
R2498 VAPWR.n736 VAPWR.n735 0.0155
R2499 VAPWR.n736 VAPWR.n0 0.0155
R2500 VAPWR.n1040 VAPWR.n1 0.0155
R2501 VAPWR.n1036 VAPWR.n1 0.0155
R2502 VAPWR.n1034 VAPWR.n1033 0.0155
R2503 VAPWR.n1033 VAPWR.n8 0.0155
R2504 VAPWR.n1029 VAPWR.n8 0.0155
R2505 VAPWR.n1027 VAPWR.n1026 0.0155
R2506 VAPWR.n1026 VAPWR.n14 0.0155
R2507 VAPWR.n1022 VAPWR.n14 0.0155
R2508 VAPWR.n1022 VAPWR.n1021 0.0155
R2509 VAPWR.n1019 VAPWR.n20 0.0155
R2510 VAPWR.n1015 VAPWR.n20 0.0155
R2511 VAPWR.n1015 VAPWR.n1014 0.0155
R2512 VAPWR.n1012 VAPWR.n26 0.0155
R2513 VAPWR.n1008 VAPWR.n26 0.0155
R2514 VAPWR.n1008 VAPWR.n1007 0.0155
R2515 VAPWR.n1007 VAPWR.n1006 0.0155
R2516 VAPWR.n1006 VAPWR.n32 0.0155
R2517 VAPWR.n1002 VAPWR.n32 0.0155
R2518 VAPWR.n1002 VAPWR.n1001 0.0155
R2519 VAPWR.n1001 VAPWR.n1000 0.0155
R2520 VAPWR.n997 VAPWR.n996 0.0155
R2521 VAPWR.n996 VAPWR.n995 0.0155
R2522 VAPWR.n995 VAPWR.n69 0.0155
R2523 VAPWR.n991 VAPWR.n69 0.0155
R2524 VAPWR.n991 VAPWR.n990 0.0155
R2525 VAPWR.n990 VAPWR.n989 0.0155
R2526 VAPWR.n989 VAPWR.n75 0.0155
R2527 VAPWR.n985 VAPWR.n75 0.0155
R2528 VAPWR.n985 VAPWR.n984 0.0155
R2529 VAPWR.n982 VAPWR.n105 0.0155
R2530 VAPWR.n978 VAPWR.n105 0.0155
R2531 VAPWR.n978 VAPWR.n977 0.0155
R2532 VAPWR.n977 VAPWR.n976 0.0155
R2533 VAPWR.n976 VAPWR.n129 0.0155
R2534 VAPWR.n972 VAPWR.n129 0.0155
R2535 VAPWR.n972 VAPWR.n971 0.0155
R2536 VAPWR.n971 VAPWR.n970 0.0155
R2537 VAPWR.n970 VAPWR.n134 0.0155
R2538 VAPWR.n966 VAPWR.n134 0.0155
R2539 VAPWR.n964 VAPWR.n963 0.0155
R2540 VAPWR.n963 VAPWR.n139 0.0155
R2541 VAPWR.n959 VAPWR.n958 0.0155
R2542 VAPWR.n958 VAPWR.n957 0.0155
R2543 VAPWR.n957 VAPWR.n145 0.0155
R2544 VAPWR.n953 VAPWR.n145 0.0155
R2545 VAPWR.n574 VAPWR.n573 0.0138333
R2546 VAPWR.n645 VAPWR.n644 0.0138333
R2547 VAPWR.n1020 VAPWR.n1019 0.0138333
R2548 VAPWR.n144 VAPWR.n139 0.0138333
R2549 VAPWR.n677 VAPWR.n327 0.0121667
R2550 VAPWR.n713 VAPWR.n712 0.0121667
R2551 VAPWR.n1035 VAPWR.n1034 0.0121667
R2552 VAPWR.n556 VAPWR.n555 0.0105
R2553 VAPWR.n675 VAPWR.n342 0.0105
R2554 VAPWR.n734 VAPWR.n733 0.0105
R2555 VAPWR.n1029 VAPWR.n1028 0.0105
R2556 VAPWR.n952 VAPWR.n951 0.0105
R2557 VAPWR.n1041 VAPWR.n0 0.0102917
R2558 VAPWR.n590 VAPWR.n589 0.00883333
R2559 VAPWR.n625 VAPWR.n365 0.00883333
R2560 VAPWR.n1014 VAPWR.n1013 0.00883333
R2561 VAPWR.n997 VAPWR.n65 0.00883333
R2562 VAPWR.n983 VAPWR.n982 0.00883333
R2563 VAPWR.n966 VAPWR.n965 0.00883333
R2564 VAPWR.n591 VAPWR.n590 0.00716667
R2565 VAPWR.n626 VAPWR.n625 0.00716667
R2566 VAPWR.n1013 VAPWR.n1012 0.00716667
R2567 VAPWR.n1000 VAPWR.n65 0.00716667
R2568 VAPWR.n984 VAPWR.n983 0.00716667
R2569 VAPWR.n965 VAPWR.n964 0.00716667
R2570 VAPWR.n1041 VAPWR.n1040 0.00570833
R2571 VAPWR.n557 VAPWR.n556 0.0055
R2572 VAPWR.n660 VAPWR.n342 0.0055
R2573 VAPWR.n735 VAPWR.n734 0.0055
R2574 VAPWR.n1028 VAPWR.n1027 0.0055
R2575 VAPWR.n953 VAPWR.n952 0.0055
R2576 VAPWR.n693 VAPWR.n327 0.00383333
R2577 VAPWR.n712 VAPWR.n711 0.00383333
R2578 VAPWR.n1036 VAPWR.n1035 0.00383333
R2579 VAPWR.n573 VAPWR.n572 0.00216667
R2580 VAPWR.n644 VAPWR.n354 0.00216667
R2581 VAPWR.n1021 VAPWR.n1020 0.00216667
R2582 VAPWR.n959 VAPWR.n144 0.00216667
R2583 VSS.n408 VSS.n407 585
R2584 VSS.n409 VSS.n408 585
R2585 VSS.n342 VSS.n341 585
R2586 VSS.n349 VSS.n342 585
R2587 VSS.n421 VSS.n420 585
R2588 VSS.n420 VSS.n419 585
R2589 VSS.n339 VSS.n338 585
R2590 VSS.n338 VSS.n337 585
R2591 VSS.n426 VSS.n425 585
R2592 VSS.t23 VSS.n426 585
R2593 VSS.n330 VSS.n329 585
R2594 VSS.n331 VSS.n330 585
R2595 VSS.n437 VSS.n436 585
R2596 VSS.n436 VSS.n435 585
R2597 VSS.n327 VSS.n326 585
R2598 VSS.n326 VSS.n325 585
R2599 VSS.n442 VSS.n441 585
R2600 VSS.n443 VSS.n442 585
R2601 VSS.n317 VSS.n316 585
R2602 VSS.n318 VSS.n317 585
R2603 VSS.n454 VSS.n453 585
R2604 VSS.n453 VSS.n452 585
R2605 VSS.n314 VSS.n313 585
R2606 VSS.n313 VSS.n312 585
R2607 VSS.n459 VSS.n458 585
R2608 VSS.n460 VSS.n459 585
R2609 VSS.n304 VSS.n303 585
R2610 VSS.n305 VSS.n304 585
R2611 VSS.n471 VSS.n470 585
R2612 VSS.n470 VSS.n469 585
R2613 VSS.n301 VSS.n300 585
R2614 VSS.n468 VSS.n300 585
R2615 VSS.n476 VSS.n475 585
R2616 VSS.n477 VSS.n476 585
R2617 VSS.n292 VSS.n291 585
R2618 VSS.n299 VSS.n292 585
R2619 VSS.n489 VSS.n488 585
R2620 VSS.n488 VSS.n487 585
R2621 VSS.n289 VSS.n288 585
R2622 VSS.n486 VSS.n288 585
R2623 VSS.n494 VSS.n493 585
R2624 VSS.n495 VSS.n494 585
R2625 VSS.n280 VSS.n279 585
R2626 VSS.n287 VSS.n280 585
R2627 VSS.n506 VSS.n505 585
R2628 VSS.n505 VSS.n504 585
R2629 VSS.n277 VSS.n276 585
R2630 VSS.n276 VSS.n275 585
R2631 VSS.n511 VSS.n510 585
R2632 VSS.t5 VSS.n511 585
R2633 VSS.n252 VSS.n251 585
R2634 VSS.n253 VSS.n252 585
R2635 VSS.n522 VSS.n521 585
R2636 VSS.n521 VSS.n520 585
R2637 VSS.n249 VSS.n248 585
R2638 VSS.n248 VSS.n247 585
R2639 VSS.n527 VSS.n526 585
R2640 VSS.n528 VSS.n527 585
R2641 VSS.n240 VSS.n239 585
R2642 VSS.n241 VSS.n240 585
R2643 VSS.n538 VSS.n537 585
R2644 VSS.n537 VSS.n536 585
R2645 VSS.n237 VSS.n236 585
R2646 VSS.n236 VSS.n235 585
R2647 VSS.n543 VSS.n542 585
R2648 VSS.n544 VSS.n543 585
R2649 VSS.n228 VSS.n227 585
R2650 VSS.n229 VSS.n228 585
R2651 VSS.n554 VSS.n553 585
R2652 VSS.n553 VSS.n552 585
R2653 VSS.n225 VSS.n224 585
R2654 VSS.n224 VSS.n223 585
R2655 VSS.n559 VSS.n558 585
R2656 VSS.n560 VSS.n559 585
R2657 VSS.n216 VSS.n215 585
R2658 VSS.n217 VSS.n216 585
R2659 VSS.n570 VSS.n569 585
R2660 VSS.n569 VSS.n568 585
R2661 VSS.n212 VSS.n210 585
R2662 VSS.n210 VSS.n208 585
R2663 VSS.n579 VSS.n578 585
R2664 VSS.n580 VSS.n579 585
R2665 VSS.n213 VSS.n211 585
R2666 VSS.n211 VSS.n209 585
R2667 VSS.n574 VSS.n573 585
R2668 VSS.n573 VSS.n202 585
R2669 VSS.n201 VSS.n200 585
R2670 VSS.n589 VSS.n201 585
R2671 VSS.n592 VSS.n591 585
R2672 VSS.n591 VSS.n590 585
R2673 VSS.n198 VSS.n197 585
R2674 VSS.n197 VSS.n196 585
R2675 VSS.n597 VSS.n596 585
R2676 VSS.n598 VSS.n597 585
R2677 VSS.n195 VSS.n194 585
R2678 VSS.n600 VSS.n195 585
R2679 VSS.n603 VSS.n602 585
R2680 VSS.n602 VSS.n601 585
R2681 VSS.n192 VSS.n191 585
R2682 VSS.n191 VSS.n190 585
R2683 VSS.n608 VSS.n607 585
R2684 VSS.n609 VSS.n608 585
R2685 VSS.n189 VSS.n188 585
R2686 VSS.n611 VSS.n189 585
R2687 VSS.n614 VSS.n613 585
R2688 VSS.n613 VSS.n612 585
R2689 VSS.n186 VSS.n185 585
R2690 VSS.n185 VSS.n184 585
R2691 VSS.n619 VSS.n618 585
R2692 VSS.n620 VSS.n619 585
R2693 VSS.n183 VSS.n182 585
R2694 VSS.n622 VSS.n183 585
R2695 VSS.n625 VSS.n624 585
R2696 VSS.n624 VSS.n623 585
R2697 VSS.n180 VSS.n179 585
R2698 VSS.n179 VSS.n178 585
R2699 VSS.n630 VSS.n629 585
R2700 VSS.n631 VSS.n630 585
R2701 VSS.n177 VSS.n176 585
R2702 VSS.n633 VSS.n177 585
R2703 VSS.n636 VSS.n635 585
R2704 VSS.n635 VSS.n634 585
R2705 VSS.n174 VSS.n173 585
R2706 VSS.n173 VSS.n172 585
R2707 VSS.n641 VSS.n640 585
R2708 VSS.n642 VSS.n641 585
R2709 VSS.n171 VSS.n170 585
R2710 VSS.n644 VSS.n171 585
R2711 VSS.n648 VSS.n647 585
R2712 VSS.n647 VSS.n646 585
R2713 VSS.n168 VSS.n167 585
R2714 VSS.n645 VSS.n167 585
R2715 VSS.n653 VSS.n652 585
R2716 VSS.n654 VSS.n653 585
R2717 VSS.n166 VSS.n165 585
R2718 VSS.n656 VSS.n166 585
R2719 VSS.n659 VSS.n658 585
R2720 VSS.n658 VSS.n657 585
R2721 VSS.n163 VSS.n162 585
R2722 VSS.n162 VSS.n160 585
R2723 VSS.n664 VSS.n663 585
R2724 VSS.n665 VSS.n664 585
R2725 VSS.n159 VSS.n158 585
R2726 VSS.n666 VSS.n159 585
R2727 VSS.n669 VSS.n668 585
R2728 VSS.n668 VSS.n667 585
R2729 VSS.n156 VSS.n155 585
R2730 VSS.n155 VSS.n153 585
R2731 VSS.n674 VSS.n673 585
R2732 VSS.n675 VSS.n674 585
R2733 VSS.n152 VSS.n151 585
R2734 VSS.n676 VSS.n152 585
R2735 VSS.n680 VSS.n679 585
R2736 VSS.n679 VSS.n678 585
R2737 VSS.n149 VSS.n148 585
R2738 VSS.n677 VSS.n148 585
R2739 VSS.n685 VSS.n684 585
R2740 VSS.n686 VSS.n685 585
R2741 VSS.n146 VSS.n145 585
R2742 VSS.n687 VSS.n146 585
R2743 VSS.n690 VSS.n689 585
R2744 VSS.n689 VSS.n688 585
R2745 VSS.n143 VSS.n142 585
R2746 VSS.n142 VSS.n140 585
R2747 VSS.n695 VSS.n694 585
R2748 VSS.n696 VSS.n695 585
R2749 VSS.n139 VSS.n138 585
R2750 VSS.n697 VSS.n139 585
R2751 VSS.n700 VSS.n699 585
R2752 VSS.n699 VSS.n698 585
R2753 VSS.n136 VSS.n135 585
R2754 VSS.n135 VSS.n133 585
R2755 VSS.n705 VSS.n704 585
R2756 VSS.n706 VSS.n705 585
R2757 VSS.n132 VSS.n131 585
R2758 VSS.n707 VSS.n132 585
R2759 VSS.n710 VSS.n709 585
R2760 VSS.n709 VSS.n708 585
R2761 VSS.n129 VSS.n128 585
R2762 VSS.n128 VSS.n126 585
R2763 VSS.n715 VSS.n714 585
R2764 VSS.n716 VSS.n715 585
R2765 VSS.n125 VSS.n124 585
R2766 VSS.n717 VSS.n125 585
R2767 VSS.n720 VSS.n719 585
R2768 VSS.n719 VSS.n718 585
R2769 VSS.n122 VSS.n121 585
R2770 VSS.n121 VSS.n119 585
R2771 VSS.n725 VSS.n724 585
R2772 VSS.t31 VSS.n725 585
R2773 VSS.n118 VSS.n117 585
R2774 VSS.n726 VSS.n118 585
R2775 VSS.n729 VSS.n728 585
R2776 VSS.n728 VSS.n727 585
R2777 VSS.n114 VSS.n112 585
R2778 VSS.n112 VSS.n110 585
R2779 VSS.n785 VSS.n784 585
R2780 VSS.n786 VSS.n785 585
R2781 VSS.n789 VSS.n788 585
R2782 VSS.n757 VSS.n108 585
R2783 VSS.n759 VSS.n758 585
R2784 VSS.n762 VSS.n755 585
R2785 VSS.n763 VSS.n754 585
R2786 VSS.n764 VSS.n752 585
R2787 VSS.n751 VSS.n748 585
R2788 VSS.n768 VSS.n747 585
R2789 VSS.n769 VSS.n746 585
R2790 VSS.n771 VSS.n744 585
R2791 VSS.n772 VSS.n743 585
R2792 VSS.n773 VSS.n741 585
R2793 VSS.n740 VSS.n737 585
R2794 VSS.n777 VSS.n736 585
R2795 VSS.n778 VSS.n735 585
R2796 VSS.n779 VSS.n733 585
R2797 VSS.n115 VSS.n113 585
R2798 VSS.n113 VSS.n111 585
R2799 VSS.n787 VSS.n105 585
R2800 VSS.n787 VSS.n786 585
R2801 VSS.n794 VSS.n104 585
R2802 VSS.n110 VSS.n104 585
R2803 VSS.n795 VSS.n103 585
R2804 VSS.n727 VSS.n103 585
R2805 VSS.n796 VSS.n102 585
R2806 VSS.n726 VSS.n102 585
R2807 VSS.n120 VSS.n99 585
R2808 VSS.t31 VSS.n120 585
R2809 VSS.n800 VSS.n98 585
R2810 VSS.n119 VSS.n98 585
R2811 VSS.n801 VSS.n97 585
R2812 VSS.n718 VSS.n97 585
R2813 VSS.n802 VSS.n96 585
R2814 VSS.n717 VSS.n96 585
R2815 VSS.n127 VSS.n94 585
R2816 VSS.n716 VSS.n127 585
R2817 VSS.n807 VSS.n93 585
R2818 VSS.n126 VSS.n93 585
R2819 VSS.n808 VSS.n92 585
R2820 VSS.n708 VSS.n92 585
R2821 VSS.n809 VSS.n91 585
R2822 VSS.n707 VSS.n91 585
R2823 VSS.n134 VSS.n89 585
R2824 VSS.n706 VSS.n134 585
R2825 VSS.n813 VSS.n88 585
R2826 VSS.n133 VSS.n88 585
R2827 VSS.n814 VSS.n87 585
R2828 VSS.n698 VSS.n87 585
R2829 VSS.n815 VSS.n86 585
R2830 VSS.n697 VSS.n86 585
R2831 VSS.n141 VSS.n84 585
R2832 VSS.n696 VSS.n141 585
R2833 VSS.n819 VSS.n83 585
R2834 VSS.n140 VSS.n83 585
R2835 VSS.n820 VSS.n82 585
R2836 VSS.n688 VSS.n82 585
R2837 VSS.n821 VSS.n81 585
R2838 VSS.n687 VSS.n81 585
R2839 VSS.n147 VSS.n79 585
R2840 VSS.n686 VSS.n147 585
R2841 VSS.n826 VSS.n78 585
R2842 VSS.n677 VSS.n78 585
R2843 VSS.n827 VSS.n77 585
R2844 VSS.n678 VSS.n77 585
R2845 VSS.n828 VSS.n76 585
R2846 VSS.n676 VSS.n76 585
R2847 VSS.n154 VSS.n74 585
R2848 VSS.n675 VSS.n154 585
R2849 VSS.n832 VSS.n73 585
R2850 VSS.n153 VSS.n73 585
R2851 VSS.n833 VSS.n72 585
R2852 VSS.n667 VSS.n72 585
R2853 VSS.n834 VSS.n71 585
R2854 VSS.n666 VSS.n71 585
R2855 VSS.n161 VSS.n69 585
R2856 VSS.n665 VSS.n161 585
R2857 VSS.n838 VSS.n68 585
R2858 VSS.n160 VSS.n68 585
R2859 VSS.n839 VSS.n67 585
R2860 VSS.n657 VSS.n67 585
R2861 VSS.n655 VSS.n49 585
R2862 VSS.n656 VSS.n655 585
R2863 VSS.n843 VSS.n48 585
R2864 VSS.n654 VSS.n48 585
R2865 VSS.n844 VSS.n47 585
R2866 VSS.n645 VSS.n47 585
R2867 VSS.n845 VSS.n46 585
R2868 VSS.n646 VSS.n46 585
R2869 VSS.n643 VSS.n43 585
R2870 VSS.n644 VSS.n643 585
R2871 VSS.n849 VSS.n42 585
R2872 VSS.n642 VSS.n42 585
R2873 VSS.n850 VSS.n41 585
R2874 VSS.n172 VSS.n41 585
R2875 VSS.n851 VSS.n40 585
R2876 VSS.n634 VSS.n40 585
R2877 VSS.n632 VSS.n37 585
R2878 VSS.n633 VSS.n632 585
R2879 VSS.n856 VSS.n36 585
R2880 VSS.n631 VSS.n36 585
R2881 VSS.n857 VSS.n35 585
R2882 VSS.n178 VSS.n35 585
R2883 VSS.n858 VSS.n34 585
R2884 VSS.n623 VSS.n34 585
R2885 VSS.n621 VSS.n16 585
R2886 VSS.n622 VSS.n621 585
R2887 VSS.n863 VSS.n15 585
R2888 VSS.n620 VSS.n15 585
R2889 VSS.n864 VSS.n14 585
R2890 VSS.n184 VSS.n14 585
R2891 VSS.n865 VSS.n13 585
R2892 VSS.n612 VSS.n13 585
R2893 VSS.n610 VSS.n11 585
R2894 VSS.n611 VSS.n610 585
R2895 VSS.n869 VSS.n10 585
R2896 VSS.n609 VSS.n10 585
R2897 VSS.n870 VSS.n9 585
R2898 VSS.n190 VSS.n9 585
R2899 VSS.n871 VSS.n8 585
R2900 VSS.n601 VSS.n8 585
R2901 VSS.n599 VSS.n6 585
R2902 VSS.n600 VSS.n599 585
R2903 VSS.n875 VSS.n5 585
R2904 VSS.n598 VSS.n5 585
R2905 VSS.n876 VSS.n4 585
R2906 VSS.n196 VSS.n4 585
R2907 VSS.n877 VSS.n3 585
R2908 VSS.n590 VSS.n3 585
R2909 VSS.n588 VSS.n2 585
R2910 VSS.n589 VSS.n588 585
R2911 VSS.n587 VSS.n586 585
R2912 VSS.n587 VSS.n202 585
R2913 VSS.n204 VSS.n203 585
R2914 VSS.n209 VSS.n203 585
R2915 VSS.n582 VSS.n581 585
R2916 VSS.n581 VSS.n580 585
R2917 VSS.n207 VSS.n206 585
R2918 VSS.n208 VSS.n207 585
R2919 VSS.n567 VSS.n566 585
R2920 VSS.n568 VSS.n567 585
R2921 VSS.n219 VSS.n218 585
R2922 VSS.n218 VSS.n217 585
R2923 VSS.n562 VSS.n561 585
R2924 VSS.n561 VSS.n560 585
R2925 VSS.n222 VSS.n221 585
R2926 VSS.n223 VSS.n222 585
R2927 VSS.n551 VSS.n550 585
R2928 VSS.n552 VSS.n551 585
R2929 VSS.n231 VSS.n230 585
R2930 VSS.n230 VSS.n229 585
R2931 VSS.n546 VSS.n545 585
R2932 VSS.n545 VSS.n544 585
R2933 VSS.n234 VSS.n233 585
R2934 VSS.n235 VSS.n234 585
R2935 VSS.n535 VSS.n534 585
R2936 VSS.n536 VSS.n535 585
R2937 VSS.n243 VSS.n242 585
R2938 VSS.n242 VSS.n241 585
R2939 VSS.n530 VSS.n529 585
R2940 VSS.n529 VSS.n528 585
R2941 VSS.n246 VSS.n245 585
R2942 VSS.n247 VSS.n246 585
R2943 VSS.n519 VSS.n518 585
R2944 VSS.n520 VSS.n519 585
R2945 VSS.n255 VSS.n254 585
R2946 VSS.n254 VSS.n253 585
R2947 VSS.n513 VSS.n512 585
R2948 VSS.n512 VSS.t5 585
R2949 VSS.n274 VSS.n273 585
R2950 VSS.n275 VSS.n274 585
R2951 VSS.n503 VSS.n502 585
R2952 VSS.n504 VSS.n503 585
R2953 VSS.n282 VSS.n281 585
R2954 VSS.n287 VSS.n281 585
R2955 VSS.n497 VSS.n496 585
R2956 VSS.n496 VSS.n495 585
R2957 VSS.n286 VSS.n285 585
R2958 VSS.n486 VSS.n286 585
R2959 VSS.n485 VSS.n484 585
R2960 VSS.n487 VSS.n485 585
R2961 VSS.n294 VSS.n293 585
R2962 VSS.n299 VSS.n293 585
R2963 VSS.n479 VSS.n478 585
R2964 VSS.n478 VSS.n477 585
R2965 VSS.n298 VSS.n297 585
R2966 VSS.n468 VSS.n298 585
R2967 VSS.n467 VSS.n466 585
R2968 VSS.n469 VSS.n467 585
R2969 VSS.n307 VSS.n306 585
R2970 VSS.n306 VSS.n305 585
R2971 VSS.n462 VSS.n461 585
R2972 VSS.n461 VSS.n460 585
R2973 VSS.n311 VSS.n310 585
R2974 VSS.n312 VSS.n311 585
R2975 VSS.n451 VSS.n450 585
R2976 VSS.n452 VSS.n451 585
R2977 VSS.n320 VSS.n319 585
R2978 VSS.n319 VSS.n318 585
R2979 VSS.n445 VSS.n444 585
R2980 VSS.n444 VSS.n443 585
R2981 VSS.n324 VSS.n323 585
R2982 VSS.n325 VSS.n324 585
R2983 VSS.n434 VSS.n433 585
R2984 VSS.n435 VSS.n434 585
R2985 VSS.n333 VSS.n332 585
R2986 VSS.n332 VSS.n331 585
R2987 VSS.n428 VSS.n427 585
R2988 VSS.n427 VSS.t23 585
R2989 VSS.n336 VSS.n335 585
R2990 VSS.n337 VSS.n336 585
R2991 VSS.n418 VSS.n417 585
R2992 VSS.n419 VSS.n418 585
R2993 VSS.n344 VSS.n343 585
R2994 VSS.n349 VSS.n343 585
R2995 VSS.n411 VSS.n410 585
R2996 VSS.n410 VSS.n409 585
R2997 VSS.n351 VSS.n350 585
R2998 VSS.n403 VSS.n354 585
R2999 VSS.n402 VSS.n355 585
R3000 VSS.n355 VSS.n348 585
R3001 VSS.n401 VSS.n356 585
R3002 VSS.n360 VSS.n357 585
R3003 VSS.n397 VSS.n361 585
R3004 VSS.n396 VSS.n363 585
R3005 VSS.n395 VSS.n364 585
R3006 VSS.n368 VSS.n365 585
R3007 VSS.n391 VSS.n369 585
R3008 VSS.n390 VSS.n371 585
R3009 VSS.n389 VSS.n372 585
R3010 VSS.n376 VSS.n373 585
R3011 VSS.n385 VSS.n377 585
R3012 VSS.n384 VSS.n379 585
R3013 VSS.n383 VSS.n381 585
R3014 VSS.n347 VSS.n346 585
R3015 VSS.n785 VSS.n113 463.175
R3016 VSS.n788 VSS.n787 463.175
R3017 VSS.n410 VSS.n347 463.175
R3018 VSS.n408 VSS.n350 463.175
R3019 VSS.n111 VSS.n109 255.031
R3020 VSS.n756 VSS.n111 255.031
R3021 VSS.n753 VSS.n111 255.031
R3022 VSS.n750 VSS.n111 255.031
R3023 VSS.n745 VSS.n111 255.031
R3024 VSS.n742 VSS.n111 255.031
R3025 VSS.n739 VSS.n111 255.031
R3026 VSS.n734 VSS.n111 255.031
R3027 VSS.n353 VSS.n348 255.031
R3028 VSS.n359 VSS.n348 255.031
R3029 VSS.n362 VSS.n348 255.031
R3030 VSS.n367 VSS.n348 255.031
R3031 VSS.n370 VSS.n348 255.031
R3032 VSS.n375 VSS.n348 255.031
R3033 VSS.n378 VSS.n348 255.031
R3034 VSS.n380 VSS.n348 255.031
R3035 VSS.n270 VSS.n269 248.305
R3036 VSS.n31 VSS.n30 248.305
R3037 VSS.n64 VSS.n63 248.305
R3038 VSS.n805 VSS.t28 236.332
R3039 VSS.n262 VSS.n261 185
R3040 VSS.n264 VSS.n263 185
R3041 VSS.n259 VSS.n258 185
R3042 VSS.n269 VSS.n268 185
R3043 VSS.n23 VSS.n22 185
R3044 VSS.n25 VSS.n24 185
R3045 VSS.n20 VSS.n19 185
R3046 VSS.n30 VSS.n29 185
R3047 VSS.n56 VSS.n55 185
R3048 VSS.n58 VSS.n57 185
R3049 VSS.n53 VSS.n52 185
R3050 VSS.n63 VSS.n62 185
R3051 VSS.n409 VSS.n348 181.444
R3052 VSS.n786 VSS.n111 181.444
R3053 VSS.t6 VSS.n260 177.089
R3054 VSS.t44 VSS.n21 175.19
R3055 VSS.t34 VSS.n54 175.19
R3056 VSS.n733 VSS.n113 171.9
R3057 VSS.n736 VSS.n735 171.9
R3058 VSS.n741 VSS.n740 171.9
R3059 VSS.n744 VSS.n743 171.9
R3060 VSS.n747 VSS.n746 171.9
R3061 VSS.n752 VSS.n751 171.9
R3062 VSS.n755 VSS.n754 171.9
R3063 VSS.n758 VSS.n757 171.9
R3064 VSS.n410 VSS.n343 171.9
R3065 VSS.n418 VSS.n343 171.9
R3066 VSS.n418 VSS.n336 171.9
R3067 VSS.n427 VSS.n336 171.9
R3068 VSS.n427 VSS.n332 171.9
R3069 VSS.n434 VSS.n332 171.9
R3070 VSS.n434 VSS.n324 171.9
R3071 VSS.n444 VSS.n324 171.9
R3072 VSS.n444 VSS.n319 171.9
R3073 VSS.n451 VSS.n319 171.9
R3074 VSS.n451 VSS.n311 171.9
R3075 VSS.n461 VSS.n311 171.9
R3076 VSS.n461 VSS.n306 171.9
R3077 VSS.n467 VSS.n306 171.9
R3078 VSS.n467 VSS.n298 171.9
R3079 VSS.n478 VSS.n298 171.9
R3080 VSS.n478 VSS.n293 171.9
R3081 VSS.n485 VSS.n293 171.9
R3082 VSS.n485 VSS.n286 171.9
R3083 VSS.n496 VSS.n286 171.9
R3084 VSS.n496 VSS.n281 171.9
R3085 VSS.n503 VSS.n281 171.9
R3086 VSS.n503 VSS.n274 171.9
R3087 VSS.n512 VSS.n274 171.9
R3088 VSS.n512 VSS.n254 171.9
R3089 VSS.n519 VSS.n254 171.9
R3090 VSS.n519 VSS.n246 171.9
R3091 VSS.n529 VSS.n246 171.9
R3092 VSS.n529 VSS.n242 171.9
R3093 VSS.n535 VSS.n242 171.9
R3094 VSS.n535 VSS.n234 171.9
R3095 VSS.n545 VSS.n234 171.9
R3096 VSS.n545 VSS.n230 171.9
R3097 VSS.n551 VSS.n230 171.9
R3098 VSS.n551 VSS.n222 171.9
R3099 VSS.n561 VSS.n222 171.9
R3100 VSS.n561 VSS.n218 171.9
R3101 VSS.n567 VSS.n218 171.9
R3102 VSS.n567 VSS.n207 171.9
R3103 VSS.n581 VSS.n207 171.9
R3104 VSS.n581 VSS.n203 171.9
R3105 VSS.n587 VSS.n203 171.9
R3106 VSS.n588 VSS.n587 171.9
R3107 VSS.n588 VSS.n3 171.9
R3108 VSS.n4 VSS.n3 171.9
R3109 VSS.n5 VSS.n4 171.9
R3110 VSS.n599 VSS.n5 171.9
R3111 VSS.n599 VSS.n8 171.9
R3112 VSS.n9 VSS.n8 171.9
R3113 VSS.n10 VSS.n9 171.9
R3114 VSS.n610 VSS.n10 171.9
R3115 VSS.n610 VSS.n13 171.9
R3116 VSS.n14 VSS.n13 171.9
R3117 VSS.n15 VSS.n14 171.9
R3118 VSS.n621 VSS.n15 171.9
R3119 VSS.n621 VSS.n34 171.9
R3120 VSS.n35 VSS.n34 171.9
R3121 VSS.n36 VSS.n35 171.9
R3122 VSS.n632 VSS.n36 171.9
R3123 VSS.n632 VSS.n40 171.9
R3124 VSS.n41 VSS.n40 171.9
R3125 VSS.n42 VSS.n41 171.9
R3126 VSS.n643 VSS.n42 171.9
R3127 VSS.n643 VSS.n46 171.9
R3128 VSS.n47 VSS.n46 171.9
R3129 VSS.n48 VSS.n47 171.9
R3130 VSS.n655 VSS.n48 171.9
R3131 VSS.n655 VSS.n67 171.9
R3132 VSS.n68 VSS.n67 171.9
R3133 VSS.n161 VSS.n68 171.9
R3134 VSS.n161 VSS.n71 171.9
R3135 VSS.n72 VSS.n71 171.9
R3136 VSS.n73 VSS.n72 171.9
R3137 VSS.n154 VSS.n73 171.9
R3138 VSS.n154 VSS.n76 171.9
R3139 VSS.n77 VSS.n76 171.9
R3140 VSS.n78 VSS.n77 171.9
R3141 VSS.n147 VSS.n78 171.9
R3142 VSS.n147 VSS.n81 171.9
R3143 VSS.n82 VSS.n81 171.9
R3144 VSS.n83 VSS.n82 171.9
R3145 VSS.n141 VSS.n83 171.9
R3146 VSS.n141 VSS.n86 171.9
R3147 VSS.n87 VSS.n86 171.9
R3148 VSS.n88 VSS.n87 171.9
R3149 VSS.n134 VSS.n88 171.9
R3150 VSS.n134 VSS.n91 171.9
R3151 VSS.n92 VSS.n91 171.9
R3152 VSS.n93 VSS.n92 171.9
R3153 VSS.n127 VSS.n93 171.9
R3154 VSS.n127 VSS.n96 171.9
R3155 VSS.n97 VSS.n96 171.9
R3156 VSS.n98 VSS.n97 171.9
R3157 VSS.n120 VSS.n98 171.9
R3158 VSS.n120 VSS.n102 171.9
R3159 VSS.n103 VSS.n102 171.9
R3160 VSS.n104 VSS.n103 171.9
R3161 VSS.n787 VSS.n104 171.9
R3162 VSS.n355 VSS.n354 171.9
R3163 VSS.n356 VSS.n355 171.9
R3164 VSS.n361 VSS.n360 171.9
R3165 VSS.n364 VSS.n363 171.9
R3166 VSS.n369 VSS.n368 171.9
R3167 VSS.n372 VSS.n371 171.9
R3168 VSS.n377 VSS.n376 171.9
R3169 VSS.n381 VSS.n379 171.9
R3170 VSS.n408 VSS.n342 171.9
R3171 VSS.n420 VSS.n342 171.9
R3172 VSS.n420 VSS.n338 171.9
R3173 VSS.n426 VSS.n338 171.9
R3174 VSS.n426 VSS.n330 171.9
R3175 VSS.n436 VSS.n330 171.9
R3176 VSS.n436 VSS.n326 171.9
R3177 VSS.n442 VSS.n326 171.9
R3178 VSS.n442 VSS.n317 171.9
R3179 VSS.n453 VSS.n317 171.9
R3180 VSS.n453 VSS.n313 171.9
R3181 VSS.n459 VSS.n313 171.9
R3182 VSS.n459 VSS.n304 171.9
R3183 VSS.n470 VSS.n304 171.9
R3184 VSS.n470 VSS.n300 171.9
R3185 VSS.n476 VSS.n300 171.9
R3186 VSS.n476 VSS.n292 171.9
R3187 VSS.n488 VSS.n292 171.9
R3188 VSS.n488 VSS.n288 171.9
R3189 VSS.n494 VSS.n288 171.9
R3190 VSS.n494 VSS.n280 171.9
R3191 VSS.n505 VSS.n280 171.9
R3192 VSS.n505 VSS.n276 171.9
R3193 VSS.n511 VSS.n276 171.9
R3194 VSS.n511 VSS.n252 171.9
R3195 VSS.n521 VSS.n252 171.9
R3196 VSS.n521 VSS.n248 171.9
R3197 VSS.n527 VSS.n248 171.9
R3198 VSS.n527 VSS.n240 171.9
R3199 VSS.n537 VSS.n240 171.9
R3200 VSS.n537 VSS.n236 171.9
R3201 VSS.n543 VSS.n236 171.9
R3202 VSS.n543 VSS.n228 171.9
R3203 VSS.n553 VSS.n228 171.9
R3204 VSS.n553 VSS.n224 171.9
R3205 VSS.n559 VSS.n224 171.9
R3206 VSS.n559 VSS.n216 171.9
R3207 VSS.n569 VSS.n216 171.9
R3208 VSS.n569 VSS.n210 171.9
R3209 VSS.n579 VSS.n210 171.9
R3210 VSS.n579 VSS.n211 171.9
R3211 VSS.n573 VSS.n211 171.9
R3212 VSS.n573 VSS.n201 171.9
R3213 VSS.n591 VSS.n201 171.9
R3214 VSS.n591 VSS.n197 171.9
R3215 VSS.n597 VSS.n197 171.9
R3216 VSS.n597 VSS.n195 171.9
R3217 VSS.n602 VSS.n195 171.9
R3218 VSS.n602 VSS.n191 171.9
R3219 VSS.n608 VSS.n191 171.9
R3220 VSS.n608 VSS.n189 171.9
R3221 VSS.n613 VSS.n189 171.9
R3222 VSS.n613 VSS.n185 171.9
R3223 VSS.n619 VSS.n185 171.9
R3224 VSS.n619 VSS.n183 171.9
R3225 VSS.n624 VSS.n183 171.9
R3226 VSS.n624 VSS.n179 171.9
R3227 VSS.n630 VSS.n179 171.9
R3228 VSS.n630 VSS.n177 171.9
R3229 VSS.n635 VSS.n177 171.9
R3230 VSS.n635 VSS.n173 171.9
R3231 VSS.n641 VSS.n173 171.9
R3232 VSS.n641 VSS.n171 171.9
R3233 VSS.n647 VSS.n171 171.9
R3234 VSS.n647 VSS.n167 171.9
R3235 VSS.n653 VSS.n167 171.9
R3236 VSS.n653 VSS.n166 171.9
R3237 VSS.n658 VSS.n166 171.9
R3238 VSS.n658 VSS.n162 171.9
R3239 VSS.n664 VSS.n162 171.9
R3240 VSS.n664 VSS.n159 171.9
R3241 VSS.n668 VSS.n159 171.9
R3242 VSS.n668 VSS.n155 171.9
R3243 VSS.n674 VSS.n155 171.9
R3244 VSS.n674 VSS.n152 171.9
R3245 VSS.n679 VSS.n152 171.9
R3246 VSS.n679 VSS.n148 171.9
R3247 VSS.n685 VSS.n148 171.9
R3248 VSS.n685 VSS.n146 171.9
R3249 VSS.n689 VSS.n146 171.9
R3250 VSS.n689 VSS.n142 171.9
R3251 VSS.n695 VSS.n142 171.9
R3252 VSS.n695 VSS.n139 171.9
R3253 VSS.n699 VSS.n139 171.9
R3254 VSS.n699 VSS.n135 171.9
R3255 VSS.n705 VSS.n135 171.9
R3256 VSS.n705 VSS.n132 171.9
R3257 VSS.n709 VSS.n132 171.9
R3258 VSS.n709 VSS.n128 171.9
R3259 VSS.n715 VSS.n128 171.9
R3260 VSS.n715 VSS.n125 171.9
R3261 VSS.n719 VSS.n125 171.9
R3262 VSS.n719 VSS.n121 171.9
R3263 VSS.n725 VSS.n121 171.9
R3264 VSS.n725 VSS.n118 171.9
R3265 VSS.n728 VSS.n118 171.9
R3266 VSS.n728 VSS.n112 171.9
R3267 VSS.n785 VSS.n112 171.9
R3268 VSS.n263 VSS.n262 136.8
R3269 VSS.n263 VSS.n258 136.8
R3270 VSS.n269 VSS.n258 136.8
R3271 VSS.n24 VSS.n23 136.8
R3272 VSS.n24 VSS.n19 136.8
R3273 VSS.n30 VSS.n19 136.8
R3274 VSS.n57 VSS.n56 136.8
R3275 VSS.n57 VSS.n52 136.8
R3276 VSS.n63 VSS.n52 136.8
R3277 VSS.n100 VSS.t32 132.585
R3278 VSS.n409 VSS.n349 116.642
R3279 VSS.n419 VSS.n337 116.642
R3280 VSS.t23 VSS.n337 116.642
R3281 VSS.t23 VSS.n331 116.642
R3282 VSS.n435 VSS.n331 116.642
R3283 VSS.n443 VSS.n325 116.642
R3284 VSS.n452 VSS.n318 116.642
R3285 VSS.n460 VSS.n312 116.642
R3286 VSS.n469 VSS.n305 116.642
R3287 VSS.n469 VSS.n468 116.642
R3288 VSS.n477 VSS.n299 116.642
R3289 VSS.n487 VSS.n486 116.642
R3290 VSS.n495 VSS.n287 116.642
R3291 VSS.n504 VSS.n275 116.642
R3292 VSS.t5 VSS.n275 116.642
R3293 VSS.t5 VSS.n253 116.642
R3294 VSS.n520 VSS.n253 116.642
R3295 VSS.n520 VSS.n247 116.642
R3296 VSS.n528 VSS.n247 116.642
R3297 VSS.n528 VSS.n241 116.642
R3298 VSS.n536 VSS.n241 116.642
R3299 VSS.n536 VSS.n235 116.642
R3300 VSS.n544 VSS.n235 116.642
R3301 VSS.n544 VSS.n229 116.642
R3302 VSS.n552 VSS.n229 116.642
R3303 VSS.n552 VSS.n223 116.642
R3304 VSS.n560 VSS.n223 116.642
R3305 VSS.n560 VSS.n217 116.642
R3306 VSS.n568 VSS.n217 116.642
R3307 VSS.n568 VSS.n208 116.642
R3308 VSS.n580 VSS.n208 116.642
R3309 VSS.n580 VSS.n209 116.642
R3310 VSS.n209 VSS.n202 116.642
R3311 VSS.n589 VSS.n202 116.642
R3312 VSS.n590 VSS.n589 116.642
R3313 VSS.n590 VSS.n196 116.642
R3314 VSS.n598 VSS.n196 116.642
R3315 VSS.n600 VSS.n598 116.642
R3316 VSS.n601 VSS.n600 116.642
R3317 VSS.n601 VSS.n190 116.642
R3318 VSS.n609 VSS.n190 116.642
R3319 VSS.n611 VSS.n609 116.642
R3320 VSS.n612 VSS.n611 116.642
R3321 VSS.n612 VSS.n184 116.642
R3322 VSS.n620 VSS.n184 116.642
R3323 VSS.n622 VSS.n620 116.642
R3324 VSS.n623 VSS.n622 116.642
R3325 VSS.n631 VSS.n178 116.642
R3326 VSS.n634 VSS.n633 116.642
R3327 VSS.n642 VSS.n172 116.642
R3328 VSS.n646 VSS.n644 116.642
R3329 VSS.n646 VSS.n645 116.642
R3330 VSS.n656 VSS.n654 116.642
R3331 VSS.n657 VSS.n160 116.642
R3332 VSS.n665 VSS.n160 116.642
R3333 VSS.n666 VSS.n665 116.642
R3334 VSS.n667 VSS.n666 116.642
R3335 VSS.n667 VSS.n153 116.642
R3336 VSS.n675 VSS.n153 116.642
R3337 VSS.n676 VSS.n675 116.642
R3338 VSS.n678 VSS.n677 116.642
R3339 VSS.n687 VSS.n686 116.642
R3340 VSS.n688 VSS.n687 116.642
R3341 VSS.n688 VSS.n140 116.642
R3342 VSS.n696 VSS.n140 116.642
R3343 VSS.n698 VSS.n697 116.642
R3344 VSS.n698 VSS.n133 116.642
R3345 VSS.n706 VSS.n133 116.642
R3346 VSS.n707 VSS.n706 116.642
R3347 VSS.n708 VSS.n707 116.642
R3348 VSS.n716 VSS.n126 116.642
R3349 VSS.n717 VSS.n716 116.642
R3350 VSS.n718 VSS.n717 116.642
R3351 VSS.n718 VSS.n119 116.642
R3352 VSS.t31 VSS.n119 116.642
R3353 VSS.n726 VSS.t31 116.642
R3354 VSS.n727 VSS.n726 116.642
R3355 VSS.n786 VSS.n110 116.642
R3356 VSS.n460 VSS.t15 103.683
R3357 VSS.n477 VSS.t13 103.683
R3358 VSS.t37 VSS.n642 103.683
R3359 VSS.n654 VSS.t35 103.683
R3360 VSS.n678 VSS.t2 103.683
R3361 VSS.t29 VSS.n696 103.683
R3362 VSS.n85 VSS.t30 96.4441
R3363 VSS.n349 VSS.t25 90.7221
R3364 VSS.t21 VSS.n325 90.7221
R3365 VSS.n287 VSS.t7 90.7221
R3366 VSS.t43 VSS.n178 90.7221
R3367 VSS.t4 VSS.n110 90.7221
R3368 VSS.n452 VSS.t17 77.7619
R3369 VSS.n487 VSS.t11 77.7619
R3370 VSS.n634 VSS.t39 77.7619
R3371 VSS.n657 VSS.t33 77.7619
R3372 VSS.n686 VSS.t0 77.7619
R3373 VSS.n735 VSS.n734 74.9406
R3374 VSS.n740 VSS.n739 74.9406
R3375 VSS.n743 VSS.n742 74.9406
R3376 VSS.n746 VSS.n745 74.9406
R3377 VSS.n751 VSS.n750 74.9406
R3378 VSS.n754 VSS.n753 74.9406
R3379 VSS.n758 VSS.n756 74.9406
R3380 VSS.n788 VSS.n109 74.9406
R3381 VSS.n353 VSS.n350 74.9406
R3382 VSS.n359 VSS.n356 74.9406
R3383 VSS.n362 VSS.n361 74.9406
R3384 VSS.n367 VSS.n364 74.9406
R3385 VSS.n370 VSS.n369 74.9406
R3386 VSS.n375 VSS.n372 74.9406
R3387 VSS.n378 VSS.n377 74.9406
R3388 VSS.n381 VSS.n380 74.9406
R3389 VSS.n757 VSS.n109 74.9406
R3390 VSS.n756 VSS.n755 74.9406
R3391 VSS.n753 VSS.n752 74.9406
R3392 VSS.n750 VSS.n747 74.9406
R3393 VSS.n745 VSS.n744 74.9406
R3394 VSS.n742 VSS.n741 74.9406
R3395 VSS.n739 VSS.n736 74.9406
R3396 VSS.n734 VSS.n733 74.9406
R3397 VSS.n354 VSS.n353 74.9406
R3398 VSS.n360 VSS.n359 74.9406
R3399 VSS.n363 VSS.n362 74.9406
R3400 VSS.n368 VSS.n367 74.9406
R3401 VSS.n371 VSS.n370 74.9406
R3402 VSS.n376 VSS.n375 74.9406
R3403 VSS.n379 VSS.n378 74.9406
R3404 VSS.n380 VSS.n347 74.9406
R3405 VSS.n23 VSS.t44 68.4005
R3406 VSS.n56 VSS.t34 68.4005
R3407 VSS.n262 VSS.t6 66.5005
R3408 VSS.t19 VSS.n318 64.8017
R3409 VSS.n486 VSS.t9 64.8017
R3410 VSS.n633 VSS.t41 64.8017
R3411 VSS.t27 VSS.n126 64.8017
R3412 VSS.n443 VSS.t19 51.8414
R3413 VSS.n495 VSS.t9 51.8414
R3414 VSS.t41 VSS.n631 51.8414
R3415 VSS.n708 VSS.t27 51.8414
R3416 VSS.t17 VSS.n312 38.8812
R3417 VSS.n299 VSS.t11 38.8812
R3418 VSS.t39 VSS.n172 38.8812
R3419 VSS.t33 VSS.n656 38.8812
R3420 VSS.n677 VSS.t0 38.8812
R3421 VSS.n407 VSS.n351 31.0405
R3422 VSS.n784 VSS.n115 31.0405
R3423 VSS.n789 VSS.n105 31.0405
R3424 VSS.n411 VSS.n346 31.0405
R3425 VSS.n830 VSS.t3 27.4425
R3426 VSS.n823 VSS.t1 27.4425
R3427 VSS.n264 VSS.n261 27.1064
R3428 VSS.n264 VSS.n259 27.1064
R3429 VSS.n268 VSS.n259 27.1064
R3430 VSS.n268 VSS.n257 27.1064
R3431 VSS.n25 VSS.n22 27.1064
R3432 VSS.n25 VSS.n20 27.1064
R3433 VSS.n29 VSS.n20 27.1064
R3434 VSS.n29 VSS.n18 27.1064
R3435 VSS.n58 VSS.n55 27.1064
R3436 VSS.n58 VSS.n53 27.1064
R3437 VSS.n62 VSS.n53 27.1064
R3438 VSS.n62 VSS.n51 27.1064
R3439 VSS.n419 VSS.t25 25.921
R3440 VSS.n435 VSS.t21 25.921
R3441 VSS.n504 VSS.t7 25.921
R3442 VSS.n623 VSS.t43 25.921
R3443 VSS.n727 VSS.t4 25.921
R3444 VSS.n271 VSS.n270 25.6385
R3445 VSS.n32 VSS.n31 25.6385
R3446 VSS.n65 VSS.n64 25.6385
R3447 VSS.n415 VSS.n414 16.7666
R3448 VSS.n322 VSS.n321 16.7666
R3449 VSS.n309 VSS.n308 16.7666
R3450 VSS.n481 VSS.n295 16.7666
R3451 VSS.n499 VSS.n283 16.7666
R3452 VSS.n846 VSS.n44 16.7499
R3453 VSS.n853 VSS.n38 16.7499
R3454 VSS.t15 VSS.n305 12.9607
R3455 VSS.n468 VSS.t13 12.9607
R3456 VSS.n644 VSS.t37 12.9607
R3457 VSS.n645 VSS.t35 12.9607
R3458 VSS.t2 VSS.n676 12.9607
R3459 VSS.n697 VSS.t29 12.9607
R3460 VSS.n407 VSS.n341 11.5205
R3461 VSS.n421 VSS.n341 11.5205
R3462 VSS.n421 VSS.n339 11.5205
R3463 VSS.n425 VSS.n339 11.5205
R3464 VSS.n425 VSS.n329 11.5205
R3465 VSS.n437 VSS.n329 11.5205
R3466 VSS.n437 VSS.n327 11.5205
R3467 VSS.n441 VSS.n327 11.5205
R3468 VSS.n441 VSS.n316 11.5205
R3469 VSS.n454 VSS.n316 11.5205
R3470 VSS.n454 VSS.n314 11.5205
R3471 VSS.n458 VSS.n314 11.5205
R3472 VSS.n458 VSS.n303 11.5205
R3473 VSS.n471 VSS.n303 11.5205
R3474 VSS.n471 VSS.n301 11.5205
R3475 VSS.n475 VSS.n301 11.5205
R3476 VSS.n475 VSS.n291 11.5205
R3477 VSS.n489 VSS.n291 11.5205
R3478 VSS.n489 VSS.n289 11.5205
R3479 VSS.n493 VSS.n289 11.5205
R3480 VSS.n493 VSS.n279 11.5205
R3481 VSS.n506 VSS.n279 11.5205
R3482 VSS.n506 VSS.n277 11.5205
R3483 VSS.n510 VSS.n277 11.5205
R3484 VSS.n510 VSS.n251 11.5205
R3485 VSS.n522 VSS.n251 11.5205
R3486 VSS.n522 VSS.n249 11.5205
R3487 VSS.n526 VSS.n249 11.5205
R3488 VSS.n526 VSS.n239 11.5205
R3489 VSS.n538 VSS.n239 11.5205
R3490 VSS.n538 VSS.n237 11.5205
R3491 VSS.n542 VSS.n237 11.5205
R3492 VSS.n542 VSS.n227 11.5205
R3493 VSS.n554 VSS.n227 11.5205
R3494 VSS.n554 VSS.n225 11.5205
R3495 VSS.n558 VSS.n225 11.5205
R3496 VSS.n558 VSS.n215 11.5205
R3497 VSS.n570 VSS.n215 11.5205
R3498 VSS.n570 VSS.n212 11.5205
R3499 VSS.n578 VSS.n212 11.5205
R3500 VSS.n578 VSS.n213 11.5205
R3501 VSS.n574 VSS.n213 11.5205
R3502 VSS.n574 VSS.n200 11.5205
R3503 VSS.n592 VSS.n200 11.5205
R3504 VSS.n592 VSS.n198 11.5205
R3505 VSS.n596 VSS.n198 11.5205
R3506 VSS.n596 VSS.n194 11.5205
R3507 VSS.n603 VSS.n194 11.5205
R3508 VSS.n603 VSS.n192 11.5205
R3509 VSS.n607 VSS.n192 11.5205
R3510 VSS.n607 VSS.n188 11.5205
R3511 VSS.n614 VSS.n188 11.5205
R3512 VSS.n614 VSS.n186 11.5205
R3513 VSS.n618 VSS.n186 11.5205
R3514 VSS.n618 VSS.n182 11.5205
R3515 VSS.n625 VSS.n182 11.5205
R3516 VSS.n625 VSS.n180 11.5205
R3517 VSS.n629 VSS.n180 11.5205
R3518 VSS.n629 VSS.n176 11.5205
R3519 VSS.n636 VSS.n176 11.5205
R3520 VSS.n636 VSS.n174 11.5205
R3521 VSS.n640 VSS.n174 11.5205
R3522 VSS.n640 VSS.n170 11.5205
R3523 VSS.n648 VSS.n170 11.5205
R3524 VSS.n648 VSS.n168 11.5205
R3525 VSS.n652 VSS.n168 11.5205
R3526 VSS.n652 VSS.n165 11.5205
R3527 VSS.n659 VSS.n165 11.5205
R3528 VSS.n659 VSS.n163 11.5205
R3529 VSS.n663 VSS.n163 11.5205
R3530 VSS.n663 VSS.n158 11.5205
R3531 VSS.n669 VSS.n158 11.5205
R3532 VSS.n669 VSS.n156 11.5205
R3533 VSS.n673 VSS.n156 11.5205
R3534 VSS.n673 VSS.n151 11.5205
R3535 VSS.n680 VSS.n151 11.5205
R3536 VSS.n680 VSS.n149 11.5205
R3537 VSS.n684 VSS.n149 11.5205
R3538 VSS.n684 VSS.n145 11.5205
R3539 VSS.n690 VSS.n145 11.5205
R3540 VSS.n690 VSS.n143 11.5205
R3541 VSS.n694 VSS.n143 11.5205
R3542 VSS.n694 VSS.n138 11.5205
R3543 VSS.n700 VSS.n138 11.5205
R3544 VSS.n700 VSS.n136 11.5205
R3545 VSS.n704 VSS.n136 11.5205
R3546 VSS.n704 VSS.n131 11.5205
R3547 VSS.n710 VSS.n131 11.5205
R3548 VSS.n710 VSS.n129 11.5205
R3549 VSS.n714 VSS.n129 11.5205
R3550 VSS.n714 VSS.n124 11.5205
R3551 VSS.n720 VSS.n124 11.5205
R3552 VSS.n720 VSS.n122 11.5205
R3553 VSS.n724 VSS.n122 11.5205
R3554 VSS.n724 VSS.n117 11.5205
R3555 VSS.n729 VSS.n117 11.5205
R3556 VSS.n729 VSS.n114 11.5205
R3557 VSS.n784 VSS.n114 11.5205
R3558 VSS.n779 VSS.n115 11.5205
R3559 VSS.n779 VSS.n778 11.5205
R3560 VSS.n778 VSS.n777 11.5205
R3561 VSS.n777 VSS.n737 11.5205
R3562 VSS.n773 VSS.n737 11.5205
R3563 VSS.n773 VSS.n772 11.5205
R3564 VSS.n772 VSS.n771 11.5205
R3565 VSS.n771 VSS.n769 11.5205
R3566 VSS.n769 VSS.n768 11.5205
R3567 VSS.n768 VSS.n748 11.5205
R3568 VSS.n764 VSS.n748 11.5205
R3569 VSS.n764 VSS.n763 11.5205
R3570 VSS.n763 VSS.n762 11.5205
R3571 VSS.n762 VSS.n759 11.5205
R3572 VSS.n759 VSS.n108 11.5205
R3573 VSS.n789 VSS.n108 11.5205
R3574 VSS.n411 VSS.n344 11.5205
R3575 VSS.n417 VSS.n344 11.5205
R3576 VSS.n417 VSS.n335 11.5205
R3577 VSS.n428 VSS.n335 11.5205
R3578 VSS.n428 VSS.n333 11.5205
R3579 VSS.n433 VSS.n333 11.5205
R3580 VSS.n433 VSS.n323 11.5205
R3581 VSS.n445 VSS.n323 11.5205
R3582 VSS.n445 VSS.n320 11.5205
R3583 VSS.n450 VSS.n320 11.5205
R3584 VSS.n450 VSS.n310 11.5205
R3585 VSS.n462 VSS.n310 11.5205
R3586 VSS.n462 VSS.n307 11.5205
R3587 VSS.n466 VSS.n307 11.5205
R3588 VSS.n466 VSS.n297 11.5205
R3589 VSS.n479 VSS.n297 11.5205
R3590 VSS.n479 VSS.n294 11.5205
R3591 VSS.n484 VSS.n294 11.5205
R3592 VSS.n484 VSS.n285 11.5205
R3593 VSS.n497 VSS.n285 11.5205
R3594 VSS.n497 VSS.n282 11.5205
R3595 VSS.n502 VSS.n282 11.5205
R3596 VSS.n502 VSS.n273 11.5205
R3597 VSS.n513 VSS.n273 11.5205
R3598 VSS.n513 VSS.n255 11.5205
R3599 VSS.n518 VSS.n255 11.5205
R3600 VSS.n518 VSS.n245 11.5205
R3601 VSS.n530 VSS.n245 11.5205
R3602 VSS.n530 VSS.n243 11.5205
R3603 VSS.n534 VSS.n243 11.5205
R3604 VSS.n534 VSS.n233 11.5205
R3605 VSS.n546 VSS.n233 11.5205
R3606 VSS.n546 VSS.n231 11.5205
R3607 VSS.n550 VSS.n231 11.5205
R3608 VSS.n550 VSS.n221 11.5205
R3609 VSS.n562 VSS.n221 11.5205
R3610 VSS.n562 VSS.n219 11.5205
R3611 VSS.n566 VSS.n219 11.5205
R3612 VSS.n566 VSS.n206 11.5205
R3613 VSS.n582 VSS.n206 11.5205
R3614 VSS.n582 VSS.n204 11.5205
R3615 VSS.n586 VSS.n204 11.5205
R3616 VSS.n586 VSS.n2 11.5205
R3617 VSS.n877 VSS.n2 11.5205
R3618 VSS.n877 VSS.n876 11.5205
R3619 VSS.n876 VSS.n875 11.5205
R3620 VSS.n875 VSS.n6 11.5205
R3621 VSS.n871 VSS.n6 11.5205
R3622 VSS.n871 VSS.n870 11.5205
R3623 VSS.n870 VSS.n869 11.5205
R3624 VSS.n869 VSS.n11 11.5205
R3625 VSS.n865 VSS.n11 11.5205
R3626 VSS.n865 VSS.n864 11.5205
R3627 VSS.n864 VSS.n863 11.5205
R3628 VSS.n863 VSS.n16 11.5205
R3629 VSS.n858 VSS.n16 11.5205
R3630 VSS.n858 VSS.n857 11.5205
R3631 VSS.n857 VSS.n856 11.5205
R3632 VSS.n856 VSS.n37 11.5205
R3633 VSS.n851 VSS.n37 11.5205
R3634 VSS.n851 VSS.n850 11.5205
R3635 VSS.n850 VSS.n849 11.5205
R3636 VSS.n849 VSS.n43 11.5205
R3637 VSS.n845 VSS.n43 11.5205
R3638 VSS.n845 VSS.n844 11.5205
R3639 VSS.n844 VSS.n843 11.5205
R3640 VSS.n843 VSS.n49 11.5205
R3641 VSS.n839 VSS.n49 11.5205
R3642 VSS.n839 VSS.n838 11.5205
R3643 VSS.n838 VSS.n69 11.5205
R3644 VSS.n834 VSS.n69 11.5205
R3645 VSS.n834 VSS.n833 11.5205
R3646 VSS.n833 VSS.n832 11.5205
R3647 VSS.n832 VSS.n74 11.5205
R3648 VSS.n828 VSS.n74 11.5205
R3649 VSS.n828 VSS.n827 11.5205
R3650 VSS.n827 VSS.n826 11.5205
R3651 VSS.n826 VSS.n79 11.5205
R3652 VSS.n821 VSS.n79 11.5205
R3653 VSS.n821 VSS.n820 11.5205
R3654 VSS.n820 VSS.n819 11.5205
R3655 VSS.n819 VSS.n84 11.5205
R3656 VSS.n815 VSS.n84 11.5205
R3657 VSS.n815 VSS.n814 11.5205
R3658 VSS.n814 VSS.n813 11.5205
R3659 VSS.n813 VSS.n89 11.5205
R3660 VSS.n809 VSS.n89 11.5205
R3661 VSS.n809 VSS.n808 11.5205
R3662 VSS.n808 VSS.n807 11.5205
R3663 VSS.n807 VSS.n94 11.5205
R3664 VSS.n802 VSS.n94 11.5205
R3665 VSS.n802 VSS.n801 11.5205
R3666 VSS.n801 VSS.n800 11.5205
R3667 VSS.n800 VSS.n99 11.5205
R3668 VSS.n796 VSS.n99 11.5205
R3669 VSS.n796 VSS.n795 11.5205
R3670 VSS.n795 VSS.n794 11.5205
R3671 VSS.n794 VSS.n105 11.5205
R3672 VSS.n403 VSS.n351 11.5205
R3673 VSS.n403 VSS.n402 11.5205
R3674 VSS.n402 VSS.n401 11.5205
R3675 VSS.n401 VSS.n357 11.5205
R3676 VSS.n397 VSS.n357 11.5205
R3677 VSS.n397 VSS.n396 11.5205
R3678 VSS.n396 VSS.n395 11.5205
R3679 VSS.n395 VSS.n365 11.5205
R3680 VSS.n391 VSS.n365 11.5205
R3681 VSS.n391 VSS.n390 11.5205
R3682 VSS.n390 VSS.n389 11.5205
R3683 VSS.n389 VSS.n373 11.5205
R3684 VSS.n385 VSS.n373 11.5205
R3685 VSS.n385 VSS.n384 11.5205
R3686 VSS.n384 VSS.n383 11.5205
R3687 VSS.n383 VSS.n346 11.5205
R3688 VSS.n270 VSS.n257 9.39327
R3689 VSS.n31 VSS.n18 9.39327
R3690 VSS.n64 VSS.n51 9.39327
R3691 VSS.n265 VSS.n264 9.3005
R3692 VSS.n266 VSS.n259 9.3005
R3693 VSS.n268 VSS.n267 9.3005
R3694 VSS.n257 VSS.n256 9.3005
R3695 VSS.n26 VSS.n25 9.3005
R3696 VSS.n27 VSS.n20 9.3005
R3697 VSS.n29 VSS.n28 9.3005
R3698 VSS.n18 VSS.n17 9.3005
R3699 VSS.n59 VSS.n58 9.3005
R3700 VSS.n60 VSS.n53 9.3005
R3701 VSS.n62 VSS.n61 9.3005
R3702 VSS.n51 VSS.n50 9.3005
R3703 VSS.n790 VSS.n789 9.3005
R3704 VSS.n108 VSS.n107 9.3005
R3705 VSS.n760 VSS.n759 9.3005
R3706 VSS.n762 VSS.n761 9.3005
R3707 VSS.n763 VSS.n749 9.3005
R3708 VSS.n765 VSS.n764 9.3005
R3709 VSS.n766 VSS.n748 9.3005
R3710 VSS.n768 VSS.n767 9.3005
R3711 VSS.n769 VSS.n106 9.3005
R3712 VSS.n771 VSS.n770 9.3005
R3713 VSS.n772 VSS.n738 9.3005
R3714 VSS.n774 VSS.n773 9.3005
R3715 VSS.n775 VSS.n737 9.3005
R3716 VSS.n777 VSS.n776 9.3005
R3717 VSS.n778 VSS.n732 9.3005
R3718 VSS.n780 VSS.n779 9.3005
R3719 VSS.n781 VSS.n115 9.3005
R3720 VSS.n405 VSS.n351 9.3005
R3721 VSS.n404 VSS.n403 9.3005
R3722 VSS.n402 VSS.n352 9.3005
R3723 VSS.n401 VSS.n400 9.3005
R3724 VSS.n399 VSS.n357 9.3005
R3725 VSS.n398 VSS.n397 9.3005
R3726 VSS.n396 VSS.n358 9.3005
R3727 VSS.n395 VSS.n394 9.3005
R3728 VSS.n393 VSS.n365 9.3005
R3729 VSS.n392 VSS.n391 9.3005
R3730 VSS.n390 VSS.n366 9.3005
R3731 VSS.n389 VSS.n388 9.3005
R3732 VSS.n387 VSS.n373 9.3005
R3733 VSS.n386 VSS.n385 9.3005
R3734 VSS.n384 VSS.n374 9.3005
R3735 VSS.n383 VSS.n382 9.3005
R3736 VSS.n346 VSS.n345 9.3005
R3737 VSS.n407 VSS.n406 9.3005
R3738 VSS.n341 VSS.n340 9.3005
R3739 VSS.n422 VSS.n421 9.3005
R3740 VSS.n423 VSS.n339 9.3005
R3741 VSS.n425 VSS.n424 9.3005
R3742 VSS.n329 VSS.n328 9.3005
R3743 VSS.n438 VSS.n437 9.3005
R3744 VSS.n439 VSS.n327 9.3005
R3745 VSS.n441 VSS.n440 9.3005
R3746 VSS.n316 VSS.n315 9.3005
R3747 VSS.n455 VSS.n454 9.3005
R3748 VSS.n456 VSS.n314 9.3005
R3749 VSS.n458 VSS.n457 9.3005
R3750 VSS.n303 VSS.n302 9.3005
R3751 VSS.n472 VSS.n471 9.3005
R3752 VSS.n473 VSS.n301 9.3005
R3753 VSS.n475 VSS.n474 9.3005
R3754 VSS.n291 VSS.n290 9.3005
R3755 VSS.n490 VSS.n489 9.3005
R3756 VSS.n491 VSS.n289 9.3005
R3757 VSS.n493 VSS.n492 9.3005
R3758 VSS.n279 VSS.n278 9.3005
R3759 VSS.n507 VSS.n506 9.3005
R3760 VSS.n508 VSS.n277 9.3005
R3761 VSS.n510 VSS.n509 9.3005
R3762 VSS.n251 VSS.n250 9.3005
R3763 VSS.n523 VSS.n522 9.3005
R3764 VSS.n524 VSS.n249 9.3005
R3765 VSS.n526 VSS.n525 9.3005
R3766 VSS.n239 VSS.n238 9.3005
R3767 VSS.n539 VSS.n538 9.3005
R3768 VSS.n540 VSS.n237 9.3005
R3769 VSS.n542 VSS.n541 9.3005
R3770 VSS.n227 VSS.n226 9.3005
R3771 VSS.n555 VSS.n554 9.3005
R3772 VSS.n556 VSS.n225 9.3005
R3773 VSS.n558 VSS.n557 9.3005
R3774 VSS.n215 VSS.n214 9.3005
R3775 VSS.n571 VSS.n570 9.3005
R3776 VSS.n572 VSS.n212 9.3005
R3777 VSS.n578 VSS.n577 9.3005
R3778 VSS.n576 VSS.n213 9.3005
R3779 VSS.n575 VSS.n574 9.3005
R3780 VSS.n200 VSS.n199 9.3005
R3781 VSS.n593 VSS.n592 9.3005
R3782 VSS.n594 VSS.n198 9.3005
R3783 VSS.n596 VSS.n595 9.3005
R3784 VSS.n194 VSS.n193 9.3005
R3785 VSS.n604 VSS.n603 9.3005
R3786 VSS.n605 VSS.n192 9.3005
R3787 VSS.n607 VSS.n606 9.3005
R3788 VSS.n188 VSS.n187 9.3005
R3789 VSS.n615 VSS.n614 9.3005
R3790 VSS.n616 VSS.n186 9.3005
R3791 VSS.n618 VSS.n617 9.3005
R3792 VSS.n182 VSS.n181 9.3005
R3793 VSS.n626 VSS.n625 9.3005
R3794 VSS.n627 VSS.n180 9.3005
R3795 VSS.n629 VSS.n628 9.3005
R3796 VSS.n176 VSS.n175 9.3005
R3797 VSS.n637 VSS.n636 9.3005
R3798 VSS.n638 VSS.n174 9.3005
R3799 VSS.n640 VSS.n639 9.3005
R3800 VSS.n170 VSS.n169 9.3005
R3801 VSS.n649 VSS.n648 9.3005
R3802 VSS.n650 VSS.n168 9.3005
R3803 VSS.n652 VSS.n651 9.3005
R3804 VSS.n165 VSS.n164 9.3005
R3805 VSS.n660 VSS.n659 9.3005
R3806 VSS.n661 VSS.n163 9.3005
R3807 VSS.n663 VSS.n662 9.3005
R3808 VSS.n158 VSS.n157 9.3005
R3809 VSS.n670 VSS.n669 9.3005
R3810 VSS.n671 VSS.n156 9.3005
R3811 VSS.n673 VSS.n672 9.3005
R3812 VSS.n151 VSS.n150 9.3005
R3813 VSS.n681 VSS.n680 9.3005
R3814 VSS.n682 VSS.n149 9.3005
R3815 VSS.n684 VSS.n683 9.3005
R3816 VSS.n145 VSS.n144 9.3005
R3817 VSS.n691 VSS.n690 9.3005
R3818 VSS.n692 VSS.n143 9.3005
R3819 VSS.n694 VSS.n693 9.3005
R3820 VSS.n138 VSS.n137 9.3005
R3821 VSS.n701 VSS.n700 9.3005
R3822 VSS.n702 VSS.n136 9.3005
R3823 VSS.n704 VSS.n703 9.3005
R3824 VSS.n131 VSS.n130 9.3005
R3825 VSS.n711 VSS.n710 9.3005
R3826 VSS.n712 VSS.n129 9.3005
R3827 VSS.n714 VSS.n713 9.3005
R3828 VSS.n124 VSS.n123 9.3005
R3829 VSS.n721 VSS.n720 9.3005
R3830 VSS.n722 VSS.n122 9.3005
R3831 VSS.n724 VSS.n723 9.3005
R3832 VSS.n117 VSS.n116 9.3005
R3833 VSS.n730 VSS.n729 9.3005
R3834 VSS.n731 VSS.n114 9.3005
R3835 VSS.n784 VSS.n783 9.3005
R3836 VSS.n792 VSS.n105 9.3005
R3837 VSS.n794 VSS.n793 9.3005
R3838 VSS.n795 VSS.n101 9.3005
R3839 VSS.n797 VSS.n796 9.3005
R3840 VSS.n798 VSS.n99 9.3005
R3841 VSS.n800 VSS.n799 9.3005
R3842 VSS.n801 VSS.n95 9.3005
R3843 VSS.n803 VSS.n802 9.3005
R3844 VSS.n804 VSS.n94 9.3005
R3845 VSS.n807 VSS.n806 9.3005
R3846 VSS.n808 VSS.n90 9.3005
R3847 VSS.n810 VSS.n809 9.3005
R3848 VSS.n811 VSS.n89 9.3005
R3849 VSS.n813 VSS.n812 9.3005
R3850 VSS.n814 VSS.n85 9.3005
R3851 VSS.n816 VSS.n815 9.3005
R3852 VSS.n817 VSS.n84 9.3005
R3853 VSS.n819 VSS.n818 9.3005
R3854 VSS.n820 VSS.n80 9.3005
R3855 VSS.n822 VSS.n821 9.3005
R3856 VSS.n824 VSS.n79 9.3005
R3857 VSS.n826 VSS.n825 9.3005
R3858 VSS.n827 VSS.n75 9.3005
R3859 VSS.n829 VSS.n828 9.3005
R3860 VSS.n830 VSS.n74 9.3005
R3861 VSS.n832 VSS.n831 9.3005
R3862 VSS.n833 VSS.n70 9.3005
R3863 VSS.n835 VSS.n834 9.3005
R3864 VSS.n836 VSS.n69 9.3005
R3865 VSS.n838 VSS.n837 9.3005
R3866 VSS.n840 VSS.n839 9.3005
R3867 VSS.n841 VSS.n49 9.3005
R3868 VSS.n843 VSS.n842 9.3005
R3869 VSS.n844 VSS.n45 9.3005
R3870 VSS.n846 VSS.n845 9.3005
R3871 VSS.n847 VSS.n43 9.3005
R3872 VSS.n849 VSS.n848 9.3005
R3873 VSS.n850 VSS.n39 9.3005
R3874 VSS.n852 VSS.n851 9.3005
R3875 VSS.n854 VSS.n37 9.3005
R3876 VSS.n856 VSS.n855 9.3005
R3877 VSS.n857 VSS.n33 9.3005
R3878 VSS.n859 VSS.n858 9.3005
R3879 VSS.n861 VSS.n16 9.3005
R3880 VSS.n863 VSS.n862 9.3005
R3881 VSS.n864 VSS.n12 9.3005
R3882 VSS.n866 VSS.n865 9.3005
R3883 VSS.n867 VSS.n11 9.3005
R3884 VSS.n869 VSS.n868 9.3005
R3885 VSS.n870 VSS.n7 9.3005
R3886 VSS.n872 VSS.n871 9.3005
R3887 VSS.n873 VSS.n6 9.3005
R3888 VSS.n875 VSS.n874 9.3005
R3889 VSS.n876 VSS.n1 9.3005
R3890 VSS.n878 VSS.n877 9.3005
R3891 VSS.n2 VSS.n0 9.3005
R3892 VSS.n586 VSS.n585 9.3005
R3893 VSS.n584 VSS.n204 9.3005
R3894 VSS.n583 VSS.n582 9.3005
R3895 VSS.n206 VSS.n205 9.3005
R3896 VSS.n566 VSS.n565 9.3005
R3897 VSS.n564 VSS.n219 9.3005
R3898 VSS.n563 VSS.n562 9.3005
R3899 VSS.n221 VSS.n220 9.3005
R3900 VSS.n550 VSS.n549 9.3005
R3901 VSS.n548 VSS.n231 9.3005
R3902 VSS.n547 VSS.n546 9.3005
R3903 VSS.n233 VSS.n232 9.3005
R3904 VSS.n534 VSS.n533 9.3005
R3905 VSS.n532 VSS.n243 9.3005
R3906 VSS.n531 VSS.n530 9.3005
R3907 VSS.n245 VSS.n244 9.3005
R3908 VSS.n518 VSS.n517 9.3005
R3909 VSS.n515 VSS.n255 9.3005
R3910 VSS.n514 VSS.n513 9.3005
R3911 VSS.n273 VSS.n272 9.3005
R3912 VSS.n502 VSS.n501 9.3005
R3913 VSS.n500 VSS.n282 9.3005
R3914 VSS.n498 VSS.n497 9.3005
R3915 VSS.n285 VSS.n284 9.3005
R3916 VSS.n484 VSS.n483 9.3005
R3917 VSS.n482 VSS.n294 9.3005
R3918 VSS.n480 VSS.n479 9.3005
R3919 VSS.n297 VSS.n296 9.3005
R3920 VSS.n466 VSS.n465 9.3005
R3921 VSS.n464 VSS.n307 9.3005
R3922 VSS.n463 VSS.n462 9.3005
R3923 VSS.n448 VSS.n310 9.3005
R3924 VSS.n450 VSS.n449 9.3005
R3925 VSS.n447 VSS.n320 9.3005
R3926 VSS.n446 VSS.n445 9.3005
R3927 VSS.n431 VSS.n323 9.3005
R3928 VSS.n433 VSS.n432 9.3005
R3929 VSS.n430 VSS.n333 9.3005
R3930 VSS.n429 VSS.n428 9.3005
R3931 VSS.n335 VSS.n334 9.3005
R3932 VSS.n417 VSS.n416 9.3005
R3933 VSS.n413 VSS.n344 9.3005
R3934 VSS.n412 VSS.n411 9.3005
R3935 VSS.n261 VSS.n260 6.33755
R3936 VSS.n22 VSS.n21 6.33755
R3937 VSS.n55 VSS.n54 6.33755
R3938 VSS.n414 VSS.t26 3.91803
R3939 VSS.n414 VSS.t24 3.91803
R3940 VSS.n321 VSS.t22 3.91803
R3941 VSS.n321 VSS.t20 3.91803
R3942 VSS.n308 VSS.t18 3.91803
R3943 VSS.n308 VSS.t16 3.91803
R3944 VSS.n295 VSS.t14 3.91803
R3945 VSS.n295 VSS.t12 3.91803
R3946 VSS.n283 VSS.t10 3.91803
R3947 VSS.n283 VSS.t8 3.91803
R3948 VSS.n44 VSS.t38 3.81746
R3949 VSS.n44 VSS.t36 3.81746
R3950 VSS.n38 VSS.t42 3.81746
R3951 VSS.n38 VSS.t40 3.81746
R3952 VSS.n782 VSS.n106 2.74217
R3953 VSS.n791 VSS.n106 2.74217
R3954 VSS.n265 VSS.n260 1.08701
R3955 VSS.n26 VSS.n21 1.08701
R3956 VSS.n59 VSS.n54 1.08701
R3957 VSS.n782 VSS.n781 0.328938
R3958 VSS VSS.n879 0.32388
R3959 VSS.n791 VSS.n790 0.308625
R3960 VSS.n406 VSS.n405 0.303625
R3961 VSS.n516 VSS.n271 0.219944
R3962 VSS.n860 VSS.n32 0.203278
R3963 VSS.n66 VSS.n65 0.203278
R3964 VSS.n781 VSS.n780 0.1805
R3965 VSS.n780 VSS.n732 0.1805
R3966 VSS.n776 VSS.n732 0.1805
R3967 VSS.n776 VSS.n775 0.1805
R3968 VSS.n775 VSS.n774 0.1805
R3969 VSS.n774 VSS.n738 0.1805
R3970 VSS.n770 VSS.n738 0.1805
R3971 VSS.n770 VSS.n106 0.1805
R3972 VSS.n767 VSS.n106 0.1805
R3973 VSS.n767 VSS.n766 0.1805
R3974 VSS.n766 VSS.n765 0.1805
R3975 VSS.n765 VSS.n749 0.1805
R3976 VSS.n761 VSS.n749 0.1805
R3977 VSS.n761 VSS.n760 0.1805
R3978 VSS.n760 VSS.n107 0.1805
R3979 VSS.n790 VSS.n107 0.1805
R3980 VSS.n412 VSS.n345 0.151958
R3981 VSS.n783 VSS.n782 0.136437
R3982 VSS.n405 VSS.n404 0.113
R3983 VSS.n404 VSS.n352 0.113
R3984 VSS.n400 VSS.n352 0.113
R3985 VSS.n400 VSS.n399 0.113
R3986 VSS.n399 VSS.n398 0.113
R3987 VSS.n398 VSS.n358 0.113
R3988 VSS.n394 VSS.n358 0.113
R3989 VSS.n394 VSS.n393 0.113
R3990 VSS.n393 VSS.n392 0.113
R3991 VSS.n392 VSS.n366 0.113
R3992 VSS.n388 VSS.n366 0.113
R3993 VSS.n388 VSS.n387 0.113
R3994 VSS.n387 VSS.n386 0.113
R3995 VSS.n386 VSS.n374 0.113
R3996 VSS.n382 VSS.n374 0.113
R3997 VSS.n382 VSS.n345 0.113
R3998 VSS.n406 VSS.n340 0.113
R3999 VSS.n422 VSS.n340 0.113
R4000 VSS.n423 VSS.n422 0.113
R4001 VSS.n424 VSS.n423 0.113
R4002 VSS.n424 VSS.n328 0.113
R4003 VSS.n438 VSS.n328 0.113
R4004 VSS.n439 VSS.n438 0.113
R4005 VSS.n440 VSS.n439 0.113
R4006 VSS.n440 VSS.n315 0.113
R4007 VSS.n455 VSS.n315 0.113
R4008 VSS.n456 VSS.n455 0.113
R4009 VSS.n457 VSS.n456 0.113
R4010 VSS.n457 VSS.n302 0.113
R4011 VSS.n472 VSS.n302 0.113
R4012 VSS.n473 VSS.n472 0.113
R4013 VSS.n474 VSS.n473 0.113
R4014 VSS.n474 VSS.n290 0.113
R4015 VSS.n490 VSS.n290 0.113
R4016 VSS.n491 VSS.n490 0.113
R4017 VSS.n492 VSS.n491 0.113
R4018 VSS.n492 VSS.n278 0.113
R4019 VSS.n507 VSS.n278 0.113
R4020 VSS.n508 VSS.n507 0.113
R4021 VSS.n509 VSS.n508 0.113
R4022 VSS.n509 VSS.n250 0.113
R4023 VSS.n523 VSS.n250 0.113
R4024 VSS.n524 VSS.n523 0.113
R4025 VSS.n525 VSS.n524 0.113
R4026 VSS.n525 VSS.n238 0.113
R4027 VSS.n539 VSS.n238 0.113
R4028 VSS.n540 VSS.n539 0.113
R4029 VSS.n541 VSS.n540 0.113
R4030 VSS.n541 VSS.n226 0.113
R4031 VSS.n555 VSS.n226 0.113
R4032 VSS.n556 VSS.n555 0.113
R4033 VSS.n557 VSS.n556 0.113
R4034 VSS.n557 VSS.n214 0.113
R4035 VSS.n571 VSS.n214 0.113
R4036 VSS.n572 VSS.n571 0.113
R4037 VSS.n577 VSS.n572 0.113
R4038 VSS.n577 VSS.n576 0.113
R4039 VSS.n576 VSS.n575 0.113
R4040 VSS.n575 VSS.n199 0.113
R4041 VSS.n593 VSS.n199 0.113
R4042 VSS.n594 VSS.n593 0.113
R4043 VSS.n595 VSS.n594 0.113
R4044 VSS.n595 VSS.n193 0.113
R4045 VSS.n604 VSS.n193 0.113
R4046 VSS.n605 VSS.n604 0.113
R4047 VSS.n606 VSS.n605 0.113
R4048 VSS.n606 VSS.n187 0.113
R4049 VSS.n615 VSS.n187 0.113
R4050 VSS.n616 VSS.n615 0.113
R4051 VSS.n617 VSS.n616 0.113
R4052 VSS.n617 VSS.n181 0.113
R4053 VSS.n626 VSS.n181 0.113
R4054 VSS.n627 VSS.n626 0.113
R4055 VSS.n628 VSS.n627 0.113
R4056 VSS.n628 VSS.n175 0.113
R4057 VSS.n637 VSS.n175 0.113
R4058 VSS.n638 VSS.n637 0.113
R4059 VSS.n639 VSS.n638 0.113
R4060 VSS.n639 VSS.n169 0.113
R4061 VSS.n649 VSS.n169 0.113
R4062 VSS.n650 VSS.n649 0.113
R4063 VSS.n651 VSS.n650 0.113
R4064 VSS.n651 VSS.n164 0.113
R4065 VSS.n660 VSS.n164 0.113
R4066 VSS.n661 VSS.n660 0.113
R4067 VSS.n662 VSS.n661 0.113
R4068 VSS.n662 VSS.n157 0.113
R4069 VSS.n670 VSS.n157 0.113
R4070 VSS.n671 VSS.n670 0.113
R4071 VSS.n672 VSS.n671 0.113
R4072 VSS.n672 VSS.n150 0.113
R4073 VSS.n681 VSS.n150 0.113
R4074 VSS.n682 VSS.n681 0.113
R4075 VSS.n683 VSS.n682 0.113
R4076 VSS.n683 VSS.n144 0.113
R4077 VSS.n691 VSS.n144 0.113
R4078 VSS.n692 VSS.n691 0.113
R4079 VSS.n693 VSS.n692 0.113
R4080 VSS.n693 VSS.n137 0.113
R4081 VSS.n701 VSS.n137 0.113
R4082 VSS.n702 VSS.n701 0.113
R4083 VSS.n703 VSS.n702 0.113
R4084 VSS.n703 VSS.n130 0.113
R4085 VSS.n711 VSS.n130 0.113
R4086 VSS.n712 VSS.n711 0.113
R4087 VSS.n713 VSS.n712 0.113
R4088 VSS.n713 VSS.n123 0.113
R4089 VSS.n721 VSS.n123 0.113
R4090 VSS.n722 VSS.n721 0.113
R4091 VSS.n723 VSS.n722 0.113
R4092 VSS.n723 VSS.n116 0.113
R4093 VSS.n730 VSS.n116 0.113
R4094 VSS.n731 VSS.n730 0.113
R4095 VSS.n783 VSS.n731 0.113
R4096 VSS.n266 VSS.n265 0.1005
R4097 VSS.n267 VSS.n266 0.1005
R4098 VSS.n267 VSS.n256 0.1005
R4099 VSS.n271 VSS.n256 0.1005
R4100 VSS.n27 VSS.n26 0.1005
R4101 VSS.n28 VSS.n27 0.1005
R4102 VSS.n28 VSS.n17 0.1005
R4103 VSS.n32 VSS.n17 0.1005
R4104 VSS.n60 VSS.n59 0.1005
R4105 VSS.n61 VSS.n60 0.1005
R4106 VSS.n61 VSS.n50 0.1005
R4107 VSS.n65 VSS.n50 0.1005
R4108 VSS.n792 VSS.n791 0.018625
R4109 VSS.n413 VSS.n412 0.0155
R4110 VSS.n416 VSS.n413 0.0155
R4111 VSS.n429 VSS.n334 0.0155
R4112 VSS.n430 VSS.n429 0.0155
R4113 VSS.n432 VSS.n430 0.0155
R4114 VSS.n432 VSS.n431 0.0155
R4115 VSS.n447 VSS.n446 0.0155
R4116 VSS.n449 VSS.n447 0.0155
R4117 VSS.n449 VSS.n448 0.0155
R4118 VSS.n464 VSS.n463 0.0155
R4119 VSS.n465 VSS.n464 0.0155
R4120 VSS.n465 VSS.n296 0.0155
R4121 VSS.n480 VSS.n296 0.0155
R4122 VSS.n483 VSS.n482 0.0155
R4123 VSS.n483 VSS.n284 0.0155
R4124 VSS.n498 VSS.n284 0.0155
R4125 VSS.n501 VSS.n500 0.0155
R4126 VSS.n501 VSS.n272 0.0155
R4127 VSS.n514 VSS.n272 0.0155
R4128 VSS.n515 VSS.n514 0.0155
R4129 VSS.n517 VSS.n244 0.0155
R4130 VSS.n531 VSS.n244 0.0155
R4131 VSS.n532 VSS.n531 0.0155
R4132 VSS.n533 VSS.n532 0.0155
R4133 VSS.n533 VSS.n232 0.0155
R4134 VSS.n547 VSS.n232 0.0155
R4135 VSS.n548 VSS.n547 0.0155
R4136 VSS.n549 VSS.n548 0.0155
R4137 VSS.n549 VSS.n220 0.0155
R4138 VSS.n563 VSS.n220 0.0155
R4139 VSS.n564 VSS.n563 0.0155
R4140 VSS.n565 VSS.n564 0.0155
R4141 VSS.n565 VSS.n205 0.0155
R4142 VSS.n583 VSS.n205 0.0155
R4143 VSS.n584 VSS.n583 0.0155
R4144 VSS.n585 VSS.n584 0.0155
R4145 VSS.n585 VSS.n0 0.0155
R4146 VSS.n878 VSS.n1 0.0155
R4147 VSS.n874 VSS.n1 0.0155
R4148 VSS.n874 VSS.n873 0.0155
R4149 VSS.n873 VSS.n872 0.0155
R4150 VSS.n872 VSS.n7 0.0155
R4151 VSS.n868 VSS.n7 0.0155
R4152 VSS.n868 VSS.n867 0.0155
R4153 VSS.n867 VSS.n866 0.0155
R4154 VSS.n866 VSS.n12 0.0155
R4155 VSS.n862 VSS.n12 0.0155
R4156 VSS.n862 VSS.n861 0.0155
R4157 VSS.n859 VSS.n33 0.0155
R4158 VSS.n855 VSS.n33 0.0155
R4159 VSS.n855 VSS.n854 0.0155
R4160 VSS.n852 VSS.n39 0.0155
R4161 VSS.n848 VSS.n39 0.0155
R4162 VSS.n848 VSS.n847 0.0155
R4163 VSS.n847 VSS.n846 0.0155
R4164 VSS.n846 VSS.n45 0.0155
R4165 VSS.n842 VSS.n45 0.0155
R4166 VSS.n842 VSS.n841 0.0155
R4167 VSS.n841 VSS.n840 0.0155
R4168 VSS.n837 VSS.n836 0.0155
R4169 VSS.n836 VSS.n835 0.0155
R4170 VSS.n835 VSS.n70 0.0155
R4171 VSS.n831 VSS.n70 0.0155
R4172 VSS.n831 VSS.n830 0.0155
R4173 VSS.n830 VSS.n829 0.0155
R4174 VSS.n829 VSS.n75 0.0155
R4175 VSS.n825 VSS.n75 0.0155
R4176 VSS.n825 VSS.n824 0.0155
R4177 VSS.n822 VSS.n80 0.0155
R4178 VSS.n818 VSS.n80 0.0155
R4179 VSS.n818 VSS.n817 0.0155
R4180 VSS.n817 VSS.n816 0.0155
R4181 VSS.n816 VSS.n85 0.0155
R4182 VSS.n812 VSS.n85 0.0155
R4183 VSS.n812 VSS.n811 0.0155
R4184 VSS.n811 VSS.n810 0.0155
R4185 VSS.n810 VSS.n90 0.0155
R4186 VSS.n806 VSS.n90 0.0155
R4187 VSS.n804 VSS.n803 0.0155
R4188 VSS.n803 VSS.n95 0.0155
R4189 VSS.n799 VSS.n798 0.0155
R4190 VSS.n798 VSS.n797 0.0155
R4191 VSS.n797 VSS.n101 0.0155
R4192 VSS.n793 VSS.n101 0.0155
R4193 VSS.n793 VSS.n792 0.0155
R4194 VSS.n416 VSS.n415 0.0138333
R4195 VSS.n517 VSS.n516 0.0138333
R4196 VSS.n860 VSS.n859 0.0138333
R4197 VSS.n100 VSS.n95 0.0138333
R4198 VSS.n448 VSS.n309 0.0121667
R4199 VSS.n482 VSS.n481 0.0121667
R4200 VSS.n446 VSS.n322 0.0105
R4201 VSS.n499 VSS.n498 0.0105
R4202 VSS.n879 VSS.n0 0.0102917
R4203 VSS.n854 VSS.n853 0.00883333
R4204 VSS.n837 VSS.n66 0.00883333
R4205 VSS.n823 VSS.n822 0.00883333
R4206 VSS.n806 VSS.n805 0.00883333
R4207 VSS.n853 VSS.n852 0.00716667
R4208 VSS.n840 VSS.n66 0.00716667
R4209 VSS.n824 VSS.n823 0.00716667
R4210 VSS.n805 VSS.n804 0.00716667
R4211 VSS.n879 VSS.n878 0.00570833
R4212 VSS.n431 VSS.n322 0.0055
R4213 VSS.n500 VSS.n499 0.0055
R4214 VSS.n463 VSS.n309 0.00383333
R4215 VSS.n481 VSS.n480 0.00383333
R4216 VSS.n415 VSS.n334 0.00216667
R4217 VSS.n516 VSS.n515 0.00216667
R4218 VSS.n861 VSS.n860 0.00216667
R4219 VSS.n799 VSS.n100 0.00216667
C0 a_1240_n1152# a_840_n900# 1.23544f
C1 a_1640_n1488# en 0.00735f
C2 a_1640_n1488# VAPWR 10.2978f
C3 a_1240_n1152# a_120_n984# 0.00851f
C4 a_1640_n1488# out 0.0239f
C5 a_2360_n1712# VAPWR 24.5951f
C6 a_840_n900# a_280_n984# 0
C7 a_1640_n1488# in 0
C8 a_2360_n1712# out 10.4532f
C9 a_120_n984# a_280_n984# 0.08707f
C10 a_840_n900# a_120_n984# 1.04675f
C11 a_1640_n1488# a_1240_n1152# 2.21812f
C12 VAPWR en 0.51705f
C13 a_2360_n1712# a_1240_n1152# 0.00613f
C14 in en 0.42565f
C15 VAPWR out 22.984f
C16 VAPWR in 0.45665f
C17 a_1640_n1488# a_840_n900# 0.00587f
C18 a_2360_n1712# a_840_n900# 0
C19 a_1640_n1488# a_120_n984# 0.00242f
C20 a_1240_n1152# en 0.01145f
C21 a_1240_n1152# VAPWR 3.1748f
C22 a_2360_n1712# a_120_n984# 0
C23 a_1240_n1152# in 0.00787f
C24 a_280_n984# en 0.0267f
C25 a_840_n900# en 0.00791f
C26 a_840_n900# VAPWR 0.97382f
C27 a_120_n984# en 1.05015f
C28 a_280_n984# in 0.02627f
C29 a_2360_n1712# a_1640_n1488# 5.69218f
C30 a_840_n900# in 0.00213f
C31 a_120_n984# VAPWR 0.86996f
C32 a_120_n984# in 1.17447f
C33 a_1240_n1152# a_280_n984# 0
C34 out VSS 1.34498f
C35 en VSS 1.1505f
C36 in VSS 0.85334f
C37 VAPWR VSS 62.23479f
C38 a_280_n984# VSS 0.12305f
C39 a_120_n984# VSS 1.25229f
C40 a_840_n900# VSS 0.94175f
C41 a_1240_n1152# VSS 1.76802f
C42 a_1640_n1488# VSS 5.0212f
C43 a_2360_n1712# VSS 12.3695f
C44 VAPWR.n0 VSS 0.05377f
C45 VAPWR.n1 VSS 0.06506f
C46 VAPWR.n2 VSS 0.00867f
C47 VAPWR.n3 VSS 0.00867f
C48 VAPWR.n4 VSS 0.00867f
C49 VAPWR.n5 VSS 0.00867f
C50 VAPWR.n6 VSS 0.00867f
C51 VAPWR.t71 VSS 0.03312f
C52 VAPWR.t69 VSS 0.03312f
C53 VAPWR.n7 VSS 0.07621f
C54 VAPWR.n8 VSS 0.06506f
C55 VAPWR.n9 VSS 0.00867f
C56 VAPWR.n10 VSS 0.00867f
C57 VAPWR.n11 VSS 0.00867f
C58 VAPWR.n12 VSS 0.00867f
C59 VAPWR.t67 VSS 0.03312f
C60 VAPWR.t65 VSS 0.03312f
C61 VAPWR.n13 VSS 0.07621f
C62 VAPWR.n14 VSS 0.06506f
C63 VAPWR.n15 VSS 0.00867f
C64 VAPWR.n16 VSS 0.00867f
C65 VAPWR.n17 VSS 0.00867f
C66 VAPWR.n18 VSS 0.00867f
C67 VAPWR.t63 VSS 0.03312f
C68 VAPWR.t61 VSS 0.03312f
C69 VAPWR.n19 VSS 0.07621f
C70 VAPWR.n20 VSS 0.06506f
C71 VAPWR.n21 VSS 0.00867f
C72 VAPWR.n22 VSS 0.00867f
C73 VAPWR.n23 VSS 0.00867f
C74 VAPWR.n24 VSS 0.00867f
C75 VAPWR.t59 VSS 0.03312f
C76 VAPWR.t57 VSS 0.03312f
C77 VAPWR.n25 VSS 0.07621f
C78 VAPWR.n26 VSS 0.06506f
C79 VAPWR.n27 VSS 0.00867f
C80 VAPWR.n28 VSS 0.00867f
C81 VAPWR.n29 VSS 0.00867f
C82 VAPWR.n30 VSS 0.00867f
C83 VAPWR.t55 VSS 0.03312f
C84 VAPWR.t53 VSS 0.03312f
C85 VAPWR.n31 VSS 0.07621f
C86 VAPWR.n32 VSS 0.06506f
C87 VAPWR.n33 VSS 0.00867f
C88 VAPWR.n34 VSS 0.00867f
C89 VAPWR.n35 VSS 0.00867f
C90 VAPWR.n36 VSS 0.00867f
C91 VAPWR.n37 VSS 0.00976f
C92 VAPWR.n38 VSS 0.00369f
C93 VAPWR.n39 VSS 0.00651f
C94 VAPWR.n40 VSS 0.00369f
C95 VAPWR.n41 VSS 0.00976f
C96 VAPWR.n42 VSS 0.00651f
C97 VAPWR.n43 VSS 0.00651f
C98 VAPWR.n44 VSS 0.00651f
C99 VAPWR.n45 VSS 0.00369f
C100 VAPWR.n46 VSS 0.03546f
C101 VAPWR.n47 VSS 0.00651f
C102 VAPWR.n48 VSS 0.00651f
C103 VAPWR.t51 VSS 0.01226f
C104 VAPWR.n49 VSS 0.00488f
C105 VAPWR.n50 VSS 0.00416f
C106 VAPWR.n51 VSS 0.00369f
C107 VAPWR.n52 VSS 0.17255f
C108 VAPWR.n53 VSS 0.00976f
C109 VAPWR.n54 VSS 0.00976f
C110 VAPWR.n55 VSS 0.00369f
C111 VAPWR.n56 VSS 0.00369f
C112 VAPWR.n57 VSS 0.00369f
C113 VAPWR.n58 VSS 0.00976f
C114 VAPWR.n59 VSS 0.00976f
C115 VAPWR.n60 VSS 0.00976f
C116 VAPWR.n61 VSS 0.00369f
C117 VAPWR.n62 VSS 0.01364f
C118 VAPWR.n63 VSS 0.00703f
C119 VAPWR.n64 VSS 0.02721f
C120 VAPWR.n65 VSS 0.0513f
C121 VAPWR.n66 VSS 0.00867f
C122 VAPWR.n67 VSS 0.00867f
C123 VAPWR.n68 VSS 0.00867f
C124 VAPWR.n69 VSS 0.06506f
C125 VAPWR.n70 VSS 0.00867f
C126 VAPWR.n71 VSS 0.00867f
C127 VAPWR.n72 VSS 0.00867f
C128 VAPWR.n73 VSS 0.00867f
C129 VAPWR.t5 VSS 0.03036f
C130 VAPWR.t3 VSS 0.03036f
C131 VAPWR.n74 VSS 0.06998f
C132 VAPWR.n75 VSS 0.06506f
C133 VAPWR.n76 VSS 0.00867f
C134 VAPWR.n77 VSS 0.00867f
C135 VAPWR.n78 VSS 0.00867f
C136 VAPWR.n79 VSS 0.00867f
C137 VAPWR.n80 VSS 0.00976f
C138 VAPWR.n81 VSS 0.00369f
C139 VAPWR.n82 VSS 0.00651f
C140 VAPWR.n83 VSS 0.00369f
C141 VAPWR.n84 VSS 0.00976f
C142 VAPWR.n85 VSS 0.00651f
C143 VAPWR.n86 VSS 0.00651f
C144 VAPWR.n87 VSS 0.00651f
C145 VAPWR.n88 VSS 0.00369f
C146 VAPWR.t1 VSS 0.01226f
C147 VAPWR.n89 VSS 0.00651f
C148 VAPWR.n90 VSS 0.00488f
C149 VAPWR.n91 VSS 0.00416f
C150 VAPWR.n92 VSS 0.03288f
C151 VAPWR.n93 VSS 0.15617f
C152 VAPWR.n94 VSS 0.00976f
C153 VAPWR.n95 VSS 0.00369f
C154 VAPWR.n96 VSS 0.00369f
C155 VAPWR.n97 VSS 0.00369f
C156 VAPWR.n98 VSS 0.00976f
C157 VAPWR.n99 VSS 0.00976f
C158 VAPWR.n100 VSS 0.00976f
C159 VAPWR.n101 VSS 0.00369f
C160 VAPWR.n102 VSS 0.01406f
C161 VAPWR.n103 VSS 0.00743f
C162 VAPWR.n104 VSS 0.0364f
C163 VAPWR.n105 VSS 0.06506f
C164 VAPWR.n106 VSS 0.00867f
C165 VAPWR.n107 VSS 0.00867f
C166 VAPWR.n108 VSS 0.00867f
C167 VAPWR.n109 VSS 0.00867f
C168 VAPWR.n110 VSS 0.00976f
C169 VAPWR.n111 VSS 0.00369f
C170 VAPWR.n112 VSS 0.00651f
C171 VAPWR.n113 VSS 0.00369f
C172 VAPWR.n114 VSS 0.1199f
C173 VAPWR.n115 VSS 0.00651f
C174 VAPWR.n116 VSS 0.00651f
C175 VAPWR.n117 VSS 0.00488f
C176 VAPWR.t47 VSS 0.01222f
C177 VAPWR.n118 VSS 0.02712f
C178 VAPWR.n119 VSS 0.00416f
C179 VAPWR.n120 VSS 0.00369f
C180 VAPWR.n121 VSS 0.00369f
C181 VAPWR.n122 VSS 0.00976f
C182 VAPWR.n123 VSS 0.00976f
C183 VAPWR.n124 VSS 0.00976f
C184 VAPWR.n125 VSS 0.00369f
C185 VAPWR.n126 VSS 0.01314f
C186 VAPWR.n127 VSS 0.00656f
C187 VAPWR.n128 VSS 0.05716f
C188 VAPWR.n129 VSS 0.11399f
C189 VAPWR.n130 VSS 0.00867f
C190 VAPWR.n131 VSS 0.00867f
C191 VAPWR.n132 VSS 0.00867f
C192 VAPWR.n133 VSS 0.00867f
C193 VAPWR.n134 VSS 0.06506f
C194 VAPWR.n135 VSS 0.00867f
C195 VAPWR.n136 VSS 0.00867f
C196 VAPWR.n137 VSS 0.00867f
C197 VAPWR.n138 VSS 0.00867f
C198 VAPWR.t45 VSS 0.02245f
C199 VAPWR.n139 VSS 0.06145f
C200 VAPWR.n140 VSS 0.00867f
C201 VAPWR.n141 VSS 0.00867f
C202 VAPWR.n142 VSS 0.00867f
C203 VAPWR.n143 VSS 0.00867f
C204 VAPWR.t49 VSS 0.02245f
C205 VAPWR.n144 VSS 0.26983f
C206 VAPWR.n145 VSS 0.06506f
C207 VAPWR.n146 VSS 0.00867f
C208 VAPWR.n147 VSS 0.00867f
C209 VAPWR.n148 VSS 0.00867f
C210 VAPWR.n149 VSS 0.0201f
C211 VAPWR.t7 VSS 0.02245f
C212 VAPWR.n150 VSS 0.04834f
C213 VAPWR.n151 VSS 0.00542f
C214 VAPWR.n152 VSS 0.02014f
C215 VAPWR.n153 VSS 0.00867f
C216 VAPWR.n154 VSS 0.00867f
C217 VAPWR.n155 VSS 0.00867f
C218 VAPWR.n156 VSS 0.00542f
C219 VAPWR.n157 VSS 0.00867f
C220 VAPWR.n158 VSS 0.00867f
C221 VAPWR.n159 VSS 0.00867f
C222 VAPWR.n160 VSS 0.00867f
C223 VAPWR.n161 VSS 0.00542f
C224 VAPWR.n162 VSS 0.00867f
C225 VAPWR.n163 VSS 0.00867f
C226 VAPWR.n164 VSS 0.00867f
C227 VAPWR.n165 VSS 0.00867f
C228 VAPWR.n166 VSS 0.00867f
C229 VAPWR.n167 VSS 0.00867f
C230 VAPWR.n168 VSS 0.00867f
C231 VAPWR.n169 VSS 0.00542f
C232 VAPWR.n170 VSS 0.00867f
C233 VAPWR.n171 VSS 0.00867f
C234 VAPWR.n172 VSS 0.00867f
C235 VAPWR.n173 VSS 0.00867f
C236 VAPWR.n174 VSS 0.00542f
C237 VAPWR.n175 VSS 0.00867f
C238 VAPWR.n176 VSS 0.00867f
C239 VAPWR.n177 VSS 0.00867f
C240 VAPWR.n178 VSS 0.00867f
C241 VAPWR.n179 VSS 0.00542f
C242 VAPWR.n180 VSS 0.00867f
C243 VAPWR.n181 VSS 0.00867f
C244 VAPWR.n182 VSS 0.02014f
C245 VAPWR.n183 VSS 0.0201f
C246 VAPWR.n184 VSS 0.00867f
C247 VAPWR.n185 VSS 0.00867f
C248 VAPWR.n186 VSS 0.00867f
C249 VAPWR.n187 VSS 0.0201f
C250 VAPWR.n188 VSS 0.00867f
C251 VAPWR.t48 VSS 0.25808f
C252 VAPWR.n189 VSS 0.00867f
C253 VAPWR.n190 VSS 0.00867f
C254 VAPWR.n191 VSS 0.00867f
C255 VAPWR.n192 VSS 0.00867f
C256 VAPWR.n193 VSS 0.00867f
C257 VAPWR.n194 VSS 0.00867f
C258 VAPWR.n195 VSS 0.25808f
C259 VAPWR.n196 VSS 0.00867f
C260 VAPWR.n197 VSS 0.00867f
C261 VAPWR.n198 VSS 0.00867f
C262 VAPWR.n199 VSS 0.00867f
C263 VAPWR.n200 VSS 0.00867f
C264 VAPWR.n201 VSS 0.00867f
C265 VAPWR.n202 VSS 0.25808f
C266 VAPWR.n203 VSS 0.00867f
C267 VAPWR.n204 VSS 0.00867f
C268 VAPWR.n205 VSS 0.00867f
C269 VAPWR.n206 VSS 0.00867f
C270 VAPWR.n207 VSS 0.00867f
C271 VAPWR.t46 VSS 0.12904f
C272 VAPWR.n208 VSS 0.00867f
C273 VAPWR.n209 VSS 0.00867f
C274 VAPWR.n210 VSS 0.00867f
C275 VAPWR.n211 VSS 0.00867f
C276 VAPWR.n212 VSS 0.00867f
C277 VAPWR.n213 VSS 0.00867f
C278 VAPWR.n214 VSS 0.21506f
C279 VAPWR.n215 VSS 0.00867f
C280 VAPWR.n216 VSS 0.00867f
C281 VAPWR.n217 VSS 0.00867f
C282 VAPWR.n218 VSS 0.00867f
C283 VAPWR.n219 VSS 0.00867f
C284 VAPWR.n220 VSS 0.00867f
C285 VAPWR.n221 VSS 0.25808f
C286 VAPWR.n222 VSS 0.00867f
C287 VAPWR.n223 VSS 0.00867f
C288 VAPWR.n224 VSS 0.00867f
C289 VAPWR.n225 VSS 0.00867f
C290 VAPWR.n226 VSS 0.00867f
C291 VAPWR.n227 VSS 0.00867f
C292 VAPWR.n228 VSS 0.25808f
C293 VAPWR.n229 VSS 0.00867f
C294 VAPWR.n230 VSS 0.00867f
C295 VAPWR.n231 VSS 0.00867f
C296 VAPWR.n232 VSS 0.00867f
C297 VAPWR.n233 VSS 0.00867f
C298 VAPWR.n234 VSS 0.24374f
C299 VAPWR.n235 VSS 0.00867f
C300 VAPWR.n236 VSS 0.00867f
C301 VAPWR.n237 VSS 0.00867f
C302 VAPWR.n238 VSS 0.00867f
C303 VAPWR.n239 VSS 0.00867f
C304 VAPWR.t54 VSS 0.12904f
C305 VAPWR.n240 VSS 0.00867f
C306 VAPWR.n241 VSS 0.00867f
C307 VAPWR.n242 VSS 0.00867f
C308 VAPWR.n243 VSS 0.00867f
C309 VAPWR.n244 VSS 0.00867f
C310 VAPWR.t58 VSS 0.12904f
C311 VAPWR.n245 VSS 0.00867f
C312 VAPWR.n246 VSS 0.00867f
C313 VAPWR.n247 VSS 0.00867f
C314 VAPWR.n248 VSS 0.00867f
C315 VAPWR.n249 VSS 0.00867f
C316 VAPWR.t62 VSS 0.25808f
C317 VAPWR.n250 VSS 0.00867f
C318 VAPWR.n251 VSS 0.00867f
C319 VAPWR.n252 VSS 0.00867f
C320 VAPWR.n253 VSS 0.00867f
C321 VAPWR.n254 VSS 0.00867f
C322 VAPWR.n255 VSS 0.18639f
C323 VAPWR.n256 VSS 0.00867f
C324 VAPWR.n257 VSS 0.00867f
C325 VAPWR.n258 VSS 0.00867f
C326 VAPWR.n259 VSS 0.00867f
C327 VAPWR.n260 VSS 0.00867f
C328 VAPWR.n261 VSS 0.24374f
C329 VAPWR.n262 VSS 0.00867f
C330 VAPWR.n263 VSS 0.00867f
C331 VAPWR.n264 VSS 0.00867f
C332 VAPWR.n265 VSS 0.00867f
C333 VAPWR.n266 VSS 0.00867f
C334 VAPWR.n267 VSS 0.25808f
C335 VAPWR.n268 VSS 0.00867f
C336 VAPWR.n269 VSS 0.00867f
C337 VAPWR.n270 VSS 0.00867f
C338 VAPWR.n271 VSS 0.00976f
C339 VAPWR.n272 VSS 0.00369f
C340 VAPWR.n273 VSS 0.00651f
C341 VAPWR.n274 VSS 0.00369f
C342 VAPWR.n275 VSS 0.00976f
C343 VAPWR.n276 VSS 0.00651f
C344 VAPWR.n277 VSS 0.00651f
C345 VAPWR.n278 VSS 0.00651f
C346 VAPWR.n279 VSS 0.00369f
C347 VAPWR.n280 VSS 0.18938f
C348 VAPWR.n281 VSS 0.00651f
C349 VAPWR.n282 VSS 0.00651f
C350 VAPWR.n283 VSS 0.00651f
C351 VAPWR.n284 VSS 0.00488f
C352 VAPWR.t9 VSS 0.01227f
C353 VAPWR.n285 VSS 0.03812f
C354 VAPWR.n286 VSS 0.00416f
C355 VAPWR.n287 VSS 0.00369f
C356 VAPWR.n288 VSS 0.00369f
C357 VAPWR.n289 VSS 0.00976f
C358 VAPWR.n290 VSS 0.00976f
C359 VAPWR.n291 VSS 0.00976f
C360 VAPWR.n292 VSS 0.00369f
C361 VAPWR.n293 VSS 0.00369f
C362 VAPWR.n294 VSS 0.00369f
C363 VAPWR.n295 VSS 0.00976f
C364 VAPWR.n296 VSS 0.00976f
C365 VAPWR.n297 VSS 0.00976f
C366 VAPWR.n298 VSS 0.00369f
C367 VAPWR.n299 VSS 0.01344f
C368 VAPWR.n300 VSS 0.00685f
C369 VAPWR.n301 VSS 0.01771f
C370 VAPWR.n302 VSS 0.06506f
C371 VAPWR.n303 VSS 0.00867f
C372 VAPWR.n304 VSS 0.00867f
C373 VAPWR.t8 VSS 0.12904f
C374 VAPWR.n305 VSS 0.00867f
C375 VAPWR.n306 VSS 0.00867f
C376 VAPWR.n307 VSS 0.00867f
C377 VAPWR.n308 VSS 0.00867f
C378 VAPWR.n309 VSS 0.00867f
C379 VAPWR.n310 VSS 0.00867f
C380 VAPWR.n311 VSS 0.00867f
C381 VAPWR.t10 VSS 0.12904f
C382 VAPWR.n312 VSS 0.00867f
C383 VAPWR.n313 VSS 0.00867f
C384 VAPWR.t13 VSS 0.03615f
C385 VAPWR.t11 VSS 0.03615f
C386 VAPWR.n314 VSS 0.08273f
C387 VAPWR.n315 VSS 0.06506f
C388 VAPWR.n316 VSS 0.00867f
C389 VAPWR.n317 VSS 0.00867f
C390 VAPWR.t12 VSS 0.12904f
C391 VAPWR.n318 VSS 0.00867f
C392 VAPWR.n319 VSS 0.00867f
C393 VAPWR.n320 VSS 0.00867f
C394 VAPWR.n321 VSS 0.00867f
C395 VAPWR.n322 VSS 0.00867f
C396 VAPWR.n323 VSS 0.14338f
C397 VAPWR.n324 VSS 0.00867f
C398 VAPWR.n325 VSS 0.00867f
C399 VAPWR.t17 VSS 0.03615f
C400 VAPWR.t15 VSS 0.03615f
C401 VAPWR.n326 VSS 0.08273f
C402 VAPWR.n327 VSS 0.33047f
C403 VAPWR.n328 VSS 0.00867f
C404 VAPWR.n329 VSS 0.00867f
C405 VAPWR.n330 VSS 0.17205f
C406 VAPWR.n331 VSS 0.00867f
C407 VAPWR.n332 VSS 0.00867f
C408 VAPWR.n333 VSS 0.00867f
C409 VAPWR.n334 VSS 0.00867f
C410 VAPWR.n335 VSS 0.00867f
C411 VAPWR.n336 VSS 0.00867f
C412 VAPWR.n337 VSS 0.00867f
C413 VAPWR.n338 VSS 0.20073f
C414 VAPWR.t16 VSS 0.12904f
C415 VAPWR.n339 VSS 0.00867f
C416 VAPWR.n340 VSS 0.00867f
C417 VAPWR.t21 VSS 0.03615f
C418 VAPWR.t19 VSS 0.03615f
C419 VAPWR.n341 VSS 0.08273f
C420 VAPWR.n342 VSS 0.33047f
C421 VAPWR.n343 VSS 0.00867f
C422 VAPWR.n344 VSS 0.00867f
C423 VAPWR.n345 VSS 0.2294f
C424 VAPWR.n346 VSS 0.00867f
C425 VAPWR.n347 VSS 0.00867f
C426 VAPWR.n348 VSS 0.00867f
C427 VAPWR.n349 VSS 0.00867f
C428 VAPWR.n350 VSS 0.00867f
C429 VAPWR.n351 VSS 0.25808f
C430 VAPWR.t20 VSS 0.12904f
C431 VAPWR.n352 VSS 0.00867f
C432 VAPWR.n353 VSS 0.00867f
C433 VAPWR.n354 VSS 0.03615f
C434 VAPWR.n355 VSS 0.00867f
C435 VAPWR.n356 VSS 0.00867f
C436 VAPWR.n357 VSS 0.25808f
C437 VAPWR.n358 VSS 0.00867f
C438 VAPWR.n359 VSS 0.00867f
C439 VAPWR.n360 VSS 0.00867f
C440 VAPWR.n361 VSS 0.00867f
C441 VAPWR.n362 VSS 0.00867f
C442 VAPWR.t24 VSS 0.12904f
C443 VAPWR.n363 VSS 0.00867f
C444 VAPWR.n364 VSS 0.00867f
C445 VAPWR.n365 VSS 0.0506f
C446 VAPWR.n366 VSS 0.00867f
C447 VAPWR.n367 VSS 0.00867f
C448 VAPWR.t26 VSS 0.12904f
C449 VAPWR.n368 VSS 0.00867f
C450 VAPWR.n369 VSS 0.00867f
C451 VAPWR.n370 VSS 0.00867f
C452 VAPWR.n371 VSS 0.00867f
C453 VAPWR.n372 VSS 0.00867f
C454 VAPWR.t28 VSS 0.12904f
C455 VAPWR.n373 VSS 0.20073f
C456 VAPWR.n374 VSS 0.00867f
C457 VAPWR.n375 VSS 0.00867f
C458 VAPWR.n376 VSS 0.06506f
C459 VAPWR.n377 VSS 0.00867f
C460 VAPWR.n378 VSS 0.00867f
C461 VAPWR.t30 VSS 0.12904f
C462 VAPWR.n379 VSS 0.00867f
C463 VAPWR.n380 VSS 0.00867f
C464 VAPWR.n381 VSS 0.00867f
C465 VAPWR.n382 VSS 0.00867f
C466 VAPWR.n383 VSS 0.00867f
C467 VAPWR.n384 VSS 0.14338f
C468 VAPWR.n385 VSS 0.14338f
C469 VAPWR.n386 VSS 0.00867f
C470 VAPWR.n387 VSS 0.00867f
C471 VAPWR.t33 VSS 0.03615f
C472 VAPWR.t31 VSS 0.03615f
C473 VAPWR.n388 VSS 0.08273f
C474 VAPWR.n389 VSS 0.06506f
C475 VAPWR.n390 VSS 0.00867f
C476 VAPWR.n391 VSS 0.00867f
C477 VAPWR.n392 VSS 0.17205f
C478 VAPWR.n393 VSS 0.00867f
C479 VAPWR.n394 VSS 0.00867f
C480 VAPWR.n395 VSS 0.00867f
C481 VAPWR.n396 VSS 0.00867f
C482 VAPWR.n397 VSS 0.00867f
C483 VAPWR.n398 VSS 0.20073f
C484 VAPWR.t34 VSS 0.12904f
C485 VAPWR.n399 VSS 0.00867f
C486 VAPWR.n400 VSS 0.00867f
C487 VAPWR.t37 VSS 0.03615f
C488 VAPWR.t35 VSS 0.03615f
C489 VAPWR.n401 VSS 0.08273f
C490 VAPWR.n402 VSS 0.06506f
C491 VAPWR.n403 VSS 0.00867f
C492 VAPWR.n404 VSS 0.00867f
C493 VAPWR.n405 VSS 0.2294f
C494 VAPWR.n406 VSS 0.00867f
C495 VAPWR.n407 VSS 0.00867f
C496 VAPWR.n408 VSS 0.00867f
C497 VAPWR.n409 VSS 0.00867f
C498 VAPWR.n410 VSS 0.00867f
C499 VAPWR.n411 VSS 0.25808f
C500 VAPWR.t38 VSS 0.12904f
C501 VAPWR.n412 VSS 0.00867f
C502 VAPWR.n413 VSS 0.00867f
C503 VAPWR.t41 VSS 0.03615f
C504 VAPWR.t39 VSS 0.03615f
C505 VAPWR.n414 VSS 0.08273f
C506 VAPWR.n415 VSS 0.06506f
C507 VAPWR.n416 VSS 0.00867f
C508 VAPWR.n417 VSS 0.00867f
C509 VAPWR.n418 VSS 0.25808f
C510 VAPWR.n419 VSS 0.00867f
C511 VAPWR.n420 VSS 0.00867f
C512 VAPWR.n421 VSS 0.00867f
C513 VAPWR.n422 VSS 0.00867f
C514 VAPWR.n423 VSS 0.00867f
C515 VAPWR.t42 VSS 0.12904f
C516 VAPWR.n424 VSS 0.00867f
C517 VAPWR.n425 VSS 0.00867f
C518 VAPWR.n426 VSS 0.00976f
C519 VAPWR.n427 VSS 0.00369f
C520 VAPWR.n428 VSS 0.00651f
C521 VAPWR.n429 VSS 0.00369f
C522 VAPWR.n430 VSS 0.00976f
C523 VAPWR.n431 VSS 0.00651f
C524 VAPWR.n432 VSS 0.00651f
C525 VAPWR.n433 VSS 0.00651f
C526 VAPWR.n434 VSS 0.00369f
C527 VAPWR.n435 VSS 0.18938f
C528 VAPWR.n436 VSS 0.00651f
C529 VAPWR.n437 VSS 0.00651f
C530 VAPWR.n438 VSS 0.00651f
C531 VAPWR.n439 VSS 0.00488f
C532 VAPWR.t43 VSS 0.01227f
C533 VAPWR.n440 VSS 0.03812f
C534 VAPWR.n441 VSS 0.00416f
C535 VAPWR.n442 VSS 0.00369f
C536 VAPWR.n443 VSS 0.00369f
C537 VAPWR.n444 VSS 0.00976f
C538 VAPWR.n445 VSS 0.00976f
C539 VAPWR.n446 VSS 0.00976f
C540 VAPWR.n447 VSS 0.00369f
C541 VAPWR.n448 VSS 0.00369f
C542 VAPWR.n449 VSS 0.00369f
C543 VAPWR.n450 VSS 0.00976f
C544 VAPWR.n451 VSS 0.00976f
C545 VAPWR.n452 VSS 0.00976f
C546 VAPWR.n453 VSS 0.00369f
C547 VAPWR.n454 VSS 0.01344f
C548 VAPWR.n455 VSS 0.00685f
C549 VAPWR.n456 VSS 0.01771f
C550 VAPWR.n457 VSS 0.09989f
C551 VAPWR.n458 VSS 0.02014f
C552 VAPWR.n459 VSS 0.02014f
C553 VAPWR.n460 VSS 0.70254f
C554 VAPWR.n461 VSS 0.02014f
C555 VAPWR.n462 VSS 0.02014f
C556 VAPWR.n463 VSS 0.00867f
C557 VAPWR.n464 VSS 0.00867f
C558 VAPWR.n465 VSS 0.00867f
C559 VAPWR.n466 VSS 0.00867f
C560 VAPWR.n467 VSS 0.00867f
C561 VAPWR.n468 VSS 0.00867f
C562 VAPWR.n469 VSS 0.00867f
C563 VAPWR.n470 VSS 0.00867f
C564 VAPWR.n471 VSS 0.00867f
C565 VAPWR.n472 VSS 0.00867f
C566 VAPWR.n473 VSS 0.00867f
C567 VAPWR.n474 VSS 0.00867f
C568 VAPWR.n475 VSS 0.00867f
C569 VAPWR.n476 VSS 0.00867f
C570 VAPWR.n477 VSS 0.00867f
C571 VAPWR.n478 VSS 0.00867f
C572 VAPWR.n479 VSS 0.00867f
C573 VAPWR.n480 VSS 0.00867f
C574 VAPWR.n481 VSS 0.00867f
C575 VAPWR.n482 VSS 0.00867f
C576 VAPWR.n483 VSS 0.00867f
C577 VAPWR.n484 VSS 0.00867f
C578 VAPWR.n485 VSS 0.00867f
C579 VAPWR.n486 VSS 0.00867f
C580 VAPWR.n487 VSS 0.00867f
C581 VAPWR.n489 VSS 0.00867f
C582 VAPWR.n490 VSS 0.00867f
C583 VAPWR.n492 VSS 0.00867f
C584 VAPWR.n493 VSS 0.00867f
C585 VAPWR.n494 VSS 0.00867f
C586 VAPWR.n495 VSS 0.00867f
C587 VAPWR.n496 VSS 0.00867f
C588 VAPWR.n497 VSS 0.00867f
C589 VAPWR.n498 VSS 0.00867f
C590 VAPWR.n500 VSS 0.00867f
C591 VAPWR.n502 VSS 0.00867f
C592 VAPWR.n503 VSS 0.00867f
C593 VAPWR.n504 VSS 0.00867f
C594 VAPWR.n505 VSS 0.00867f
C595 VAPWR.n506 VSS 0.00867f
C596 VAPWR.n507 VSS 0.00867f
C597 VAPWR.n508 VSS 0.00867f
C598 VAPWR.n510 VSS 0.00867f
C599 VAPWR.n512 VSS 0.00867f
C600 VAPWR.n513 VSS 0.00867f
C601 VAPWR.n514 VSS 0.00867f
C602 VAPWR.n515 VSS 0.00867f
C603 VAPWR.n516 VSS 0.00867f
C604 VAPWR.n517 VSS 0.00867f
C605 VAPWR.n518 VSS 0.00867f
C606 VAPWR.n520 VSS 0.00867f
C607 VAPWR.n522 VSS 0.00867f
C608 VAPWR.n523 VSS 0.00867f
C609 VAPWR.n524 VSS 0.00867f
C610 VAPWR.n525 VSS 0.00867f
C611 VAPWR.n526 VSS 0.00867f
C612 VAPWR.n527 VSS 0.00867f
C613 VAPWR.n528 VSS 0.00867f
C614 VAPWR.n530 VSS 0.00867f
C615 VAPWR.n532 VSS 0.00867f
C616 VAPWR.n533 VSS 0.00867f
C617 VAPWR.n534 VSS 0.00867f
C618 VAPWR.n535 VSS 0.00867f
C619 VAPWR.n536 VSS 0.00867f
C620 VAPWR.n537 VSS 0.00867f
C621 VAPWR.n538 VSS 0.00867f
C622 VAPWR.n539 VSS 0.00867f
C623 VAPWR.n541 VSS 0.00867f
C624 VAPWR.n542 VSS 0.00867f
C625 VAPWR.n544 VSS 0.00867f
C626 VAPWR.n545 VSS 0.00867f
C627 VAPWR.n546 VSS 0.00867f
C628 VAPWR.n547 VSS 0.02014f
C629 VAPWR.n548 VSS 0.0201f
C630 VAPWR.n549 VSS 0.0201f
C631 VAPWR.n550 VSS 0.0201f
C632 VAPWR.n551 VSS 0.2294f
C633 VAPWR.n552 VSS 0.32977f
C634 VAPWR.n553 VSS 0.0201f
C635 VAPWR.n554 VSS 0.0201f
C636 VAPWR.n555 VSS 0.72735f
C637 VAPWR.n556 VSS 0.04188f
C638 VAPWR.n557 VSS 0.04337f
C639 VAPWR.n558 VSS 0.06506f
C640 VAPWR.n559 VSS 0.00867f
C641 VAPWR.n560 VSS 0.00867f
C642 VAPWR.n561 VSS 0.15771f
C643 VAPWR.n562 VSS 0.00867f
C644 VAPWR.n563 VSS 0.00867f
C645 VAPWR.n564 VSS 0.00867f
C646 VAPWR.n565 VSS 0.00867f
C647 VAPWR.n566 VSS 0.00867f
C648 VAPWR.n567 VSS 0.00867f
C649 VAPWR.n568 VSS 0.00867f
C650 VAPWR.t40 VSS 0.25808f
C651 VAPWR.n569 VSS 0.00867f
C652 VAPWR.n570 VSS 0.00867f
C653 VAPWR.n571 VSS 0.06506f
C654 VAPWR.n572 VSS 0.03615f
C655 VAPWR.n573 VSS 0.33047f
C656 VAPWR.n574 VSS 0.06145f
C657 VAPWR.n575 VSS 0.00867f
C658 VAPWR.n576 VSS 0.00867f
C659 VAPWR.n577 VSS 0.15771f
C660 VAPWR.n578 VSS 0.00867f
C661 VAPWR.n579 VSS 0.00867f
C662 VAPWR.n580 VSS 0.00867f
C663 VAPWR.n581 VSS 0.00867f
C664 VAPWR.n582 VSS 0.00867f
C665 VAPWR.n583 VSS 0.00867f
C666 VAPWR.n584 VSS 0.00867f
C667 VAPWR.t36 VSS 0.12904f
C668 VAPWR.n585 VSS 0.18639f
C669 VAPWR.n586 VSS 0.00867f
C670 VAPWR.n587 VSS 0.00867f
C671 VAPWR.n588 VSS 0.06506f
C672 VAPWR.n589 VSS 0.0506f
C673 VAPWR.n590 VSS 0.33047f
C674 VAPWR.n591 VSS 0.04699f
C675 VAPWR.n592 VSS 0.00867f
C676 VAPWR.n593 VSS 0.00867f
C677 VAPWR.n594 VSS 0.21506f
C678 VAPWR.n595 VSS 0.00867f
C679 VAPWR.n596 VSS 0.00867f
C680 VAPWR.n597 VSS 0.00867f
C681 VAPWR.n598 VSS 0.00867f
C682 VAPWR.n599 VSS 0.00867f
C683 VAPWR.n600 VSS 0.00867f
C684 VAPWR.n601 VSS 0.00867f
C685 VAPWR.t32 VSS 0.12904f
C686 VAPWR.n602 VSS 0.24374f
C687 VAPWR.n603 VSS 0.00867f
C688 VAPWR.n604 VSS 0.00867f
C689 VAPWR.n605 VSS 0.06506f
C690 VAPWR.n606 VSS 0.06506f
C691 VAPWR.n607 VSS 0.363f
C692 VAPWR.n608 VSS 0.00867f
C693 VAPWR.n609 VSS 0.00867f
C694 VAPWR.n610 VSS 0.25808f
C695 VAPWR.n611 VSS 0.00867f
C696 VAPWR.n612 VSS 0.00867f
C697 VAPWR.n613 VSS 0.00867f
C698 VAPWR.n614 VSS 0.00867f
C699 VAPWR.n615 VSS 0.00867f
C700 VAPWR.n616 VSS 0.00867f
C701 VAPWR.n617 VSS 0.00867f
C702 VAPWR.n618 VSS 0.17205f
C703 VAPWR.n619 VSS 0.24374f
C704 VAPWR.n620 VSS 0.00867f
C705 VAPWR.n621 VSS 0.00867f
C706 VAPWR.n622 VSS 0.06506f
C707 VAPWR.n623 VSS 0.06506f
C708 VAPWR.t29 VSS 0.03615f
C709 VAPWR.t27 VSS 0.03615f
C710 VAPWR.n624 VSS 0.08273f
C711 VAPWR.n625 VSS 0.33047f
C712 VAPWR.n626 VSS 0.04699f
C713 VAPWR.n627 VSS 0.00867f
C714 VAPWR.n628 VSS 0.00867f
C715 VAPWR.n629 VSS 0.21506f
C716 VAPWR.n630 VSS 0.00867f
C717 VAPWR.n631 VSS 0.00867f
C718 VAPWR.n632 VSS 0.00867f
C719 VAPWR.n633 VSS 0.00867f
C720 VAPWR.n634 VSS 0.00867f
C721 VAPWR.n635 VSS 0.00867f
C722 VAPWR.n636 VSS 0.00867f
C723 VAPWR.n637 VSS 0.2294f
C724 VAPWR.n638 VSS 0.18639f
C725 VAPWR.n639 VSS 0.00867f
C726 VAPWR.n640 VSS 0.00867f
C727 VAPWR.n641 VSS 0.06506f
C728 VAPWR.n642 VSS 0.06506f
C729 VAPWR.t25 VSS 0.03615f
C730 VAPWR.t23 VSS 0.03615f
C731 VAPWR.n643 VSS 0.08273f
C732 VAPWR.n644 VSS 0.33047f
C733 VAPWR.n645 VSS 0.06145f
C734 VAPWR.n646 VSS 0.00867f
C735 VAPWR.n647 VSS 0.00867f
C736 VAPWR.n648 VSS 0.15771f
C737 VAPWR.n649 VSS 0.00867f
C738 VAPWR.n650 VSS 0.00867f
C739 VAPWR.n651 VSS 0.00867f
C740 VAPWR.n652 VSS 0.00867f
C741 VAPWR.n653 VSS 0.00867f
C742 VAPWR.n654 VSS 0.00867f
C743 VAPWR.n655 VSS 0.00867f
C744 VAPWR.t22 VSS 0.25808f
C745 VAPWR.n656 VSS 0.00867f
C746 VAPWR.n657 VSS 0.00867f
C747 VAPWR.n658 VSS 0.06506f
C748 VAPWR.n659 VSS 0.06506f
C749 VAPWR.n660 VSS 0.04337f
C750 VAPWR.n661 VSS 0.06506f
C751 VAPWR.n662 VSS 0.00867f
C752 VAPWR.n663 VSS 0.00867f
C753 VAPWR.n664 VSS 0.15771f
C754 VAPWR.n665 VSS 0.00867f
C755 VAPWR.n666 VSS 0.00867f
C756 VAPWR.n667 VSS 0.00867f
C757 VAPWR.n668 VSS 0.00867f
C758 VAPWR.n669 VSS 0.00867f
C759 VAPWR.n670 VSS 0.00867f
C760 VAPWR.n671 VSS 0.00867f
C761 VAPWR.t18 VSS 0.12904f
C762 VAPWR.n672 VSS 0.18639f
C763 VAPWR.n673 VSS 0.00867f
C764 VAPWR.n674 VSS 0.00867f
C765 VAPWR.n675 VSS 0.05422f
C766 VAPWR.n676 VSS 0.06506f
C767 VAPWR.n677 VSS 0.05783f
C768 VAPWR.n678 VSS 0.06506f
C769 VAPWR.n679 VSS 0.00867f
C770 VAPWR.n680 VSS 0.00867f
C771 VAPWR.n681 VSS 0.21506f
C772 VAPWR.n682 VSS 0.00867f
C773 VAPWR.n683 VSS 0.00867f
C774 VAPWR.n684 VSS 0.00867f
C775 VAPWR.n685 VSS 0.00867f
C776 VAPWR.n686 VSS 0.00867f
C777 VAPWR.n687 VSS 0.00867f
C778 VAPWR.n688 VSS 0.00867f
C779 VAPWR.n689 VSS 0.00867f
C780 VAPWR.t14 VSS 0.12904f
C781 VAPWR.n690 VSS 0.24374f
C782 VAPWR.n691 VSS 0.00867f
C783 VAPWR.n692 VSS 0.00867f
C784 VAPWR.n693 VSS 0.03976f
C785 VAPWR.n694 VSS 0.06506f
C786 VAPWR.n695 VSS 0.06506f
C787 VAPWR.n696 VSS 0.00867f
C788 VAPWR.n697 VSS 0.00867f
C789 VAPWR.n698 VSS 0.25808f
C790 VAPWR.n699 VSS 0.14338f
C791 VAPWR.n700 VSS 0.00867f
C792 VAPWR.n701 VSS 0.00867f
C793 VAPWR.n702 VSS 0.00867f
C794 VAPWR.n703 VSS 0.00867f
C795 VAPWR.n704 VSS 0.00867f
C796 VAPWR.n705 VSS 0.00867f
C797 VAPWR.n706 VSS 0.00867f
C798 VAPWR.n707 VSS 0.17205f
C799 VAPWR.n708 VSS 0.24374f
C800 VAPWR.n709 VSS 0.00867f
C801 VAPWR.n710 VSS 0.00867f
C802 VAPWR.n711 VSS 0.03976f
C803 VAPWR.n712 VSS 0.33047f
C804 VAPWR.n713 VSS 0.05783f
C805 VAPWR.n714 VSS 0.06506f
C806 VAPWR.n715 VSS 0.00867f
C807 VAPWR.n716 VSS 0.00867f
C808 VAPWR.n717 VSS 0.21506f
C809 VAPWR.n718 VSS 0.20073f
C810 VAPWR.n719 VSS 0.00867f
C811 VAPWR.n720 VSS 0.00867f
C812 VAPWR.n721 VSS 0.00867f
C813 VAPWR.n722 VSS 0.00867f
C814 VAPWR.n723 VSS 0.00867f
C815 VAPWR.n724 VSS 0.00867f
C816 VAPWR.n725 VSS 0.00867f
C817 VAPWR.n726 VSS 0.00867f
C818 VAPWR.n727 VSS 0.00867f
C819 VAPWR.n728 VSS 0.00867f
C820 VAPWR.n729 VSS 0.25808f
C821 VAPWR.n730 VSS 0.18639f
C822 VAPWR.n731 VSS 0.00867f
C823 VAPWR.n732 VSS 0.00867f
C824 VAPWR.n733 VSS 0.05422f
C825 VAPWR.n734 VSS 0.04188f
C826 VAPWR.n735 VSS 0.04337f
C827 VAPWR.n736 VSS 0.06506f
C828 VAPWR.n737 VSS 0.00867f
C829 VAPWR.n738 VSS 0.00867f
C830 VAPWR.n739 VSS 0.00867f
C831 VAPWR.n740 VSS 0.25808f
C832 VAPWR.n741 VSS 0.25808f
C833 VAPWR.t70 VSS 0.12904f
C834 VAPWR.n742 VSS 0.14338f
C835 VAPWR.n743 VSS 0.00867f
C836 VAPWR.n744 VSS 0.00867f
C837 VAPWR.n745 VSS 0.00867f
C838 VAPWR.n746 VSS 0.00867f
C839 VAPWR.n747 VSS 0.00867f
C840 VAPWR.n748 VSS 0.00867f
C841 VAPWR.n749 VSS 0.00867f
C842 VAPWR.n750 VSS 0.00867f
C843 VAPWR.n751 VSS 0.17205f
C844 VAPWR.t68 VSS 0.12904f
C845 VAPWR.n752 VSS 0.21506f
C846 VAPWR.t66 VSS 0.12904f
C847 VAPWR.n753 VSS 0.20073f
C848 VAPWR.n754 VSS 0.00867f
C849 VAPWR.n755 VSS 0.00867f
C850 VAPWR.n756 VSS 0.00867f
C851 VAPWR.n757 VSS 0.00867f
C852 VAPWR.n758 VSS 0.00867f
C853 VAPWR.n759 VSS 0.00867f
C854 VAPWR.n760 VSS 0.00867f
C855 VAPWR.n761 VSS 0.00867f
C856 VAPWR.n762 VSS 0.2294f
C857 VAPWR.t64 VSS 0.12904f
C858 VAPWR.n763 VSS 0.15771f
C859 VAPWR.n764 VSS 0.25808f
C860 VAPWR.n765 VSS 0.00867f
C861 VAPWR.n766 VSS 0.00867f
C862 VAPWR.n767 VSS 0.00867f
C863 VAPWR.n768 VSS 0.00867f
C864 VAPWR.n769 VSS 0.00867f
C865 VAPWR.n770 VSS 0.00867f
C866 VAPWR.n771 VSS 0.00867f
C867 VAPWR.n772 VSS 0.00867f
C868 VAPWR.n773 VSS 0.25808f
C869 VAPWR.n774 VSS 0.15771f
C870 VAPWR.t60 VSS 0.12904f
C871 VAPWR.n775 VSS 0.18639f
C872 VAPWR.n776 VSS 0.2294f
C873 VAPWR.n777 VSS 0.00867f
C874 VAPWR.n778 VSS 0.00867f
C875 VAPWR.n779 VSS 0.00867f
C876 VAPWR.n780 VSS 0.00867f
C877 VAPWR.n781 VSS 0.00867f
C878 VAPWR.n782 VSS 0.00867f
C879 VAPWR.n783 VSS 0.00867f
C880 VAPWR.n784 VSS 0.00867f
C881 VAPWR.n785 VSS 0.20073f
C882 VAPWR.n786 VSS 0.21506f
C883 VAPWR.t56 VSS 0.12904f
C884 VAPWR.n787 VSS 0.24374f
C885 VAPWR.n788 VSS 0.17205f
C886 VAPWR.n789 VSS 0.00867f
C887 VAPWR.n790 VSS 0.00867f
C888 VAPWR.n791 VSS 0.00867f
C889 VAPWR.n792 VSS 0.00867f
C890 VAPWR.n793 VSS 0.00867f
C891 VAPWR.n794 VSS 0.00867f
C892 VAPWR.n795 VSS 0.00867f
C893 VAPWR.n796 VSS 0.00867f
C894 VAPWR.n797 VSS 0.14338f
C895 VAPWR.n798 VSS 0.25808f
C896 VAPWR.t52 VSS 0.12904f
C897 VAPWR.n799 VSS 0.14338f
C898 VAPWR.n800 VSS 0.00867f
C899 VAPWR.n801 VSS 0.00867f
C900 VAPWR.n802 VSS 0.00867f
C901 VAPWR.n803 VSS 0.00867f
C902 VAPWR.n804 VSS 0.00867f
C903 VAPWR.n805 VSS 0.00867f
C904 VAPWR.n806 VSS 0.00867f
C905 VAPWR.n807 VSS 0.00867f
C906 VAPWR.n808 VSS 0.17205f
C907 VAPWR.t50 VSS 0.12904f
C908 VAPWR.n809 VSS 0.21506f
C909 VAPWR.n810 VSS 0.25808f
C910 VAPWR.n811 VSS 0.00867f
C911 VAPWR.n812 VSS 0.00867f
C912 VAPWR.n813 VSS 0.00867f
C913 VAPWR.n814 VSS 0.00867f
C914 VAPWR.n815 VSS 0.00867f
C915 VAPWR.n816 VSS 0.00867f
C916 VAPWR.n817 VSS 0.00867f
C917 VAPWR.n818 VSS 0.25808f
C918 VAPWR.n819 VSS 0.24374f
C919 VAPWR.t4 VSS 0.12904f
C920 VAPWR.n820 VSS 0.14338f
C921 VAPWR.n821 VSS 0.00867f
C922 VAPWR.n822 VSS 0.00867f
C923 VAPWR.n823 VSS 0.00867f
C924 VAPWR.n824 VSS 0.00867f
C925 VAPWR.n825 VSS 0.00867f
C926 VAPWR.n826 VSS 0.00867f
C927 VAPWR.n827 VSS 0.00867f
C928 VAPWR.n828 VSS 0.14338f
C929 VAPWR.t2 VSS 0.12904f
C930 VAPWR.n829 VSS 0.24374f
C931 VAPWR.t0 VSS 0.12904f
C932 VAPWR.n830 VSS 0.17205f
C933 VAPWR.n831 VSS 0.00867f
C934 VAPWR.n832 VSS 0.00867f
C935 VAPWR.n833 VSS 0.00867f
C936 VAPWR.n834 VSS 0.00867f
C937 VAPWR.n835 VSS 0.00867f
C938 VAPWR.n836 VSS 0.00867f
C939 VAPWR.n837 VSS 0.00867f
C940 VAPWR.n838 VSS 0.25808f
C941 VAPWR.n839 VSS 0.25808f
C942 VAPWR.n840 VSS 0.00867f
C943 VAPWR.n841 VSS 0.24374f
C944 VAPWR.n842 VSS 0.25808f
C945 VAPWR.n843 VSS 0.00867f
C946 VAPWR.n844 VSS 0.00867f
C947 VAPWR.n845 VSS 0.00867f
C948 VAPWR.n846 VSS 0.00867f
C949 VAPWR.n847 VSS 0.00867f
C950 VAPWR.n848 VSS 0.00867f
C951 VAPWR.n849 VSS 0.00867f
C952 VAPWR.n850 VSS 0.14338f
C953 VAPWR.n851 VSS 0.25808f
C954 VAPWR.n852 VSS 0.25808f
C955 VAPWR.n853 VSS 0.00867f
C956 VAPWR.n854 VSS 0.00867f
C957 VAPWR.n855 VSS 0.00867f
C958 VAPWR.n856 VSS 0.00867f
C959 VAPWR.n857 VSS 0.00867f
C960 VAPWR.n858 VSS 0.00867f
C961 VAPWR.n859 VSS 0.00867f
C962 VAPWR.n860 VSS 0.25808f
C963 VAPWR.n861 VSS 0.18639f
C964 VAPWR.t44 VSS 0.12904f
C965 VAPWR.n862 VSS 0.20073f
C966 VAPWR.n863 VSS 0.00867f
C967 VAPWR.n864 VSS 0.00867f
C968 VAPWR.n865 VSS 0.00867f
C969 VAPWR.n866 VSS 0.00867f
C970 VAPWR.n867 VSS 0.00867f
C971 VAPWR.n868 VSS 0.00867f
C972 VAPWR.n869 VSS 0.00867f
C973 VAPWR.n870 VSS 0.25808f
C974 VAPWR.n871 VSS 0.25808f
C975 VAPWR.n872 VSS 0.25808f
C976 VAPWR.n873 VSS 0.00867f
C977 VAPWR.n874 VSS 0.00867f
C978 VAPWR.n875 VSS 0.00867f
C979 VAPWR.n876 VSS 0.00867f
C980 VAPWR.n877 VSS 0.00867f
C981 VAPWR.n878 VSS 0.00867f
C982 VAPWR.n879 VSS 0.00867f
C983 VAPWR.n880 VSS 0.25808f
C984 VAPWR.n881 VSS 0.15771f
C985 VAPWR.t6 VSS 0.12904f
C986 VAPWR.n883 VSS 0.00867f
C987 VAPWR.n886 VSS 0.00867f
C988 VAPWR.n889 VSS 0.00867f
C989 VAPWR.n892 VSS 0.00867f
C990 VAPWR.n895 VSS 0.00867f
C991 VAPWR.n898 VSS 0.00867f
C992 VAPWR.n901 VSS 0.70254f
C993 VAPWR.n902 VSS 0.0201f
C994 VAPWR.n903 VSS 0.32977f
C995 VAPWR.n904 VSS 0.2294f
C996 VAPWR.n905 VSS 0.00867f
C997 VAPWR.n906 VSS 0.00867f
C998 VAPWR.n907 VSS 0.00867f
C999 VAPWR.n908 VSS 0.00958f
C1000 VAPWR.n909 VSS 0.03796f
C1001 VAPWR.n910 VSS 0.00892f
C1002 VAPWR.n911 VSS 0.02014f
C1003 VAPWR.n912 VSS 0.00867f
C1004 VAPWR.n913 VSS 0.00867f
C1005 VAPWR.n914 VSS 0.00542f
C1006 VAPWR.n915 VSS 0.00542f
C1007 VAPWR.n916 VSS 0.00542f
C1008 VAPWR.n917 VSS 0.00867f
C1009 VAPWR.n918 VSS 0.00867f
C1010 VAPWR.n919 VSS 0.00867f
C1011 VAPWR.n920 VSS 0.00542f
C1012 VAPWR.n921 VSS 0.00542f
C1013 VAPWR.n922 VSS 0.00542f
C1014 VAPWR.n923 VSS 0.00867f
C1015 VAPWR.n924 VSS 0.00867f
C1016 VAPWR.n925 VSS 0.00867f
C1017 VAPWR.n926 VSS 0.00542f
C1018 VAPWR.n927 VSS 0.00542f
C1019 VAPWR.n928 VSS 0.00407f
C1020 VAPWR.n929 VSS 0.00867f
C1021 VAPWR.n930 VSS 0.00867f
C1022 VAPWR.n931 VSS 0.00407f
C1023 VAPWR.n932 VSS 0.00542f
C1024 VAPWR.n933 VSS 0.00542f
C1025 VAPWR.n934 VSS 0.00867f
C1026 VAPWR.n935 VSS 0.00867f
C1027 VAPWR.n936 VSS 0.00867f
C1028 VAPWR.n937 VSS 0.00542f
C1029 VAPWR.n938 VSS 0.00542f
C1030 VAPWR.n939 VSS 0.00542f
C1031 VAPWR.n940 VSS 0.00867f
C1032 VAPWR.n941 VSS 0.00867f
C1033 VAPWR.n942 VSS 0.00867f
C1034 VAPWR.n943 VSS 0.00542f
C1035 VAPWR.n944 VSS 0.00542f
C1036 VAPWR.n945 VSS 0.00542f
C1037 VAPWR.n946 VSS 0.00867f
C1038 VAPWR.n947 VSS 0.00867f
C1039 VAPWR.n948 VSS 0.02014f
C1040 VAPWR.n949 VSS 0.00849f
C1041 VAPWR.n950 VSS 0.08421f
C1042 VAPWR.n951 VSS 0.061f
C1043 VAPWR.n952 VSS 0.26983f
C1044 VAPWR.n953 VSS 0.04337f
C1045 VAPWR.n954 VSS 0.00867f
C1046 VAPWR.n955 VSS 0.00867f
C1047 VAPWR.n956 VSS 0.00867f
C1048 VAPWR.n957 VSS 0.06506f
C1049 VAPWR.n958 VSS 0.06506f
C1050 VAPWR.n959 VSS 0.03615f
C1051 VAPWR.n960 VSS 0.00867f
C1052 VAPWR.n961 VSS 0.00867f
C1053 VAPWR.n962 VSS 0.00867f
C1054 VAPWR.n963 VSS 0.06506f
C1055 VAPWR.n964 VSS 0.04699f
C1056 VAPWR.n965 VSS 0.26983f
C1057 VAPWR.n966 VSS 0.0506f
C1058 VAPWR.n967 VSS 0.00867f
C1059 VAPWR.n968 VSS 0.00867f
C1060 VAPWR.n969 VSS 0.00867f
C1061 VAPWR.n970 VSS 0.06506f
C1062 VAPWR.n971 VSS 0.06506f
C1063 VAPWR.n972 VSS 0.06506f
C1064 VAPWR.n973 VSS 0.00867f
C1065 VAPWR.n974 VSS 0.00867f
C1066 VAPWR.n975 VSS 0.00867f
C1067 VAPWR.n976 VSS 0.06506f
C1068 VAPWR.n977 VSS 0.06506f
C1069 VAPWR.n978 VSS 0.06506f
C1070 VAPWR.n979 VSS 0.00867f
C1071 VAPWR.n980 VSS 0.00867f
C1072 VAPWR.n981 VSS 0.00867f
C1073 VAPWR.n982 VSS 0.0506f
C1074 VAPWR.n983 VSS 0.06032f
C1075 VAPWR.n984 VSS 0.04699f
C1076 VAPWR.n985 VSS 0.06506f
C1077 VAPWR.n986 VSS 0.00867f
C1078 VAPWR.n987 VSS 0.00867f
C1079 VAPWR.n988 VSS 0.00867f
C1080 VAPWR.n989 VSS 0.06506f
C1081 VAPWR.n990 VSS 0.34727f
C1082 VAPWR.n991 VSS 0.06506f
C1083 VAPWR.n992 VSS 0.00867f
C1084 VAPWR.n993 VSS 0.00867f
C1085 VAPWR.n994 VSS 0.00867f
C1086 VAPWR.n995 VSS 0.06506f
C1087 VAPWR.n996 VSS 0.06506f
C1088 VAPWR.n997 VSS 0.0506f
C1089 VAPWR.n998 VSS 0.00867f
C1090 VAPWR.n999 VSS 0.00867f
C1091 VAPWR.n1000 VSS 0.04699f
C1092 VAPWR.n1001 VSS 0.06506f
C1093 VAPWR.n1002 VSS 0.06506f
C1094 VAPWR.n1003 VSS 0.00867f
C1095 VAPWR.n1004 VSS 0.00867f
C1096 VAPWR.n1005 VSS 0.00867f
C1097 VAPWR.n1006 VSS 0.35542f
C1098 VAPWR.n1007 VSS 0.06506f
C1099 VAPWR.n1008 VSS 0.06506f
C1100 VAPWR.n1009 VSS 0.00867f
C1101 VAPWR.n1010 VSS 0.00867f
C1102 VAPWR.n1011 VSS 0.00867f
C1103 VAPWR.n1012 VSS 0.04699f
C1104 VAPWR.n1013 VSS 0.32289f
C1105 VAPWR.n1014 VSS 0.0506f
C1106 VAPWR.n1015 VSS 0.06506f
C1107 VAPWR.n1016 VSS 0.00867f
C1108 VAPWR.n1017 VSS 0.00867f
C1109 VAPWR.n1018 VSS 0.00867f
C1110 VAPWR.n1019 VSS 0.06145f
C1111 VAPWR.n1020 VSS 0.32289f
C1112 VAPWR.n1021 VSS 0.03615f
C1113 VAPWR.n1022 VSS 0.06506f
C1114 VAPWR.n1023 VSS 0.00867f
C1115 VAPWR.n1024 VSS 0.00867f
C1116 VAPWR.n1025 VSS 0.00867f
C1117 VAPWR.n1026 VSS 0.06506f
C1118 VAPWR.n1027 VSS 0.04337f
C1119 VAPWR.n1028 VSS 0.32289f
C1120 VAPWR.n1029 VSS 0.05422f
C1121 VAPWR.n1030 VSS 0.00867f
C1122 VAPWR.n1031 VSS 0.00867f
C1123 VAPWR.n1032 VSS 0.00867f
C1124 VAPWR.n1033 VSS 0.06506f
C1125 VAPWR.n1034 VSS 0.05783f
C1126 VAPWR.n1035 VSS 0.32289f
C1127 VAPWR.n1036 VSS 0.03976f
C1128 VAPWR.n1037 VSS 0.00867f
C1129 VAPWR.n1038 VSS 0.00867f
C1130 VAPWR.n1039 VSS 0.00867f
C1131 VAPWR.n1040 VSS 0.04383f
C1132 VAPWR.n1041 VSS 12.4917f
C1133 in.t1 VSS 0.30265f
C1134 in.t0 VSS 0.22785f
C1135 in.n0 VSS 1.26479f
C1136 en.t1 VSS 0.3261f
C1137 en.t0 VSS 0.26583f
C1138 en.n0 VSS 0.98026f
C1139 out.n0 VSS 0.02351f
C1140 out.n1 VSS 0.00898f
C1141 out.n2 VSS 0.00898f
C1142 out.n3 VSS 0.00898f
C1143 out.n4 VSS 0.02351f
C1144 out.n5 VSS 0.00898f
C1145 out.n6 VSS 0.00898f
C1146 out.n7 VSS 0.00898f
C1147 out.n8 VSS 0.02351f
C1148 out.n9 VSS 0.00898f
C1149 out.n10 VSS 0.00898f
C1150 out.n11 VSS 0.00898f
C1151 out.n12 VSS 0.02351f
C1152 out.n13 VSS 0.00898f
C1153 out.n14 VSS 0.00898f
C1154 out.n15 VSS 0.00898f
C1155 out.n16 VSS 0.02351f
C1156 out.n17 VSS 0.00898f
C1157 out.n18 VSS 0.00188f
C1158 out.n19 VSS 0.00898f
C1159 out.n20 VSS 0.00898f
C1160 out.n21 VSS 0.00898f
C1161 out.n22 VSS 0.00898f
C1162 out.n23 VSS 0.04154f
C1163 out.n24 VSS 0.00799f
C1164 out.n25 VSS 0.00679f
C1165 out.t0 VSS 0.06655f
C1166 out.n26 VSS 0.00271f
C1167 out.n27 VSS 0.00799f
C1168 out.n28 VSS 0.00679f
C1169 out.n29 VSS 0.00799f
C1170 out.n30 VSS 0.00679f
C1171 out.n32 VSS 0.01553f
C1172 out.n33 VSS 0.00679f
C1173 out.n34 VSS 0.01553f
C1174 out.n35 VSS 0.00679f
C1175 out.n36 VSS 0.00799f
C1176 out.n37 VSS 0.00679f
C1177 out.t9 VSS 0.06655f
C1178 out.n39 VSS 0.13755f
C1179 out.n41 VSS 0.00843f
C1180 out.n42 VSS 0.00799f
C1181 out.n43 VSS 0.30146f
C1182 out.n44 VSS 0.34109f
C1183 out.n45 VSS 0.00188f
C1184 out.n46 VSS 0.00898f
C1185 out.n47 VSS 0.30146f
C1186 out.n48 VSS 0.00799f
C1187 out.n49 VSS 0.00679f
C1188 out.t17 VSS 0.06655f
C1189 out.n51 VSS 0.01553f
C1190 out.n52 VSS 0.00679f
C1191 out.n53 VSS 0.01553f
C1192 out.n54 VSS 0.00679f
C1193 out.n56 VSS 0.00799f
C1194 out.n57 VSS 0.00679f
C1195 out.n58 VSS 0.00799f
C1196 out.n59 VSS 0.00679f
C1197 out.n61 VSS 0.00799f
C1198 out.n62 VSS 0.00843f
C1199 out.n63 VSS 0.04154f
C1200 out.t15 VSS 0.06655f
C1201 out.n64 VSS 0.13755f
C1202 out.n65 VSS 0.00271f
C1203 out.n66 VSS 0.00679f
C1204 out.n67 VSS 0.00799f
C1205 out.n68 VSS 0.00898f
C1206 out.n69 VSS 0.53243f
C1207 out.n70 VSS 0.00188f
C1208 out.n71 VSS 0.00898f
C1209 out.n72 VSS 0.30146f
C1210 out.n73 VSS 0.00799f
C1211 out.n74 VSS 0.00679f
C1212 out.t22 VSS 0.06655f
C1213 out.n76 VSS 0.01553f
C1214 out.n77 VSS 0.00679f
C1215 out.n78 VSS 0.01553f
C1216 out.n79 VSS 0.00679f
C1217 out.n81 VSS 0.00799f
C1218 out.n82 VSS 0.00679f
C1219 out.n83 VSS 0.00799f
C1220 out.n84 VSS 0.00679f
C1221 out.n86 VSS 0.00799f
C1222 out.n87 VSS 0.00843f
C1223 out.n88 VSS 0.04154f
C1224 out.t20 VSS 0.06655f
C1225 out.n89 VSS 0.13755f
C1226 out.n90 VSS 0.00271f
C1227 out.n91 VSS 0.00679f
C1228 out.n92 VSS 0.00799f
C1229 out.n93 VSS 0.00898f
C1230 out.n94 VSS 0.53243f
C1231 out.n95 VSS 0.00188f
C1232 out.n96 VSS 0.00898f
C1233 out.n97 VSS 0.30146f
C1234 out.n98 VSS 0.00799f
C1235 out.n99 VSS 0.00679f
C1236 out.t2 VSS 0.06655f
C1237 out.n101 VSS 0.01553f
C1238 out.n102 VSS 0.00679f
C1239 out.n103 VSS 0.01553f
C1240 out.n104 VSS 0.00679f
C1241 out.n106 VSS 0.00799f
C1242 out.n107 VSS 0.00679f
C1243 out.n108 VSS 0.00799f
C1244 out.n109 VSS 0.00679f
C1245 out.n111 VSS 0.00799f
C1246 out.n112 VSS 0.00843f
C1247 out.n113 VSS 0.04154f
C1248 out.t5 VSS 0.06655f
C1249 out.n114 VSS 0.13755f
C1250 out.n115 VSS 0.00271f
C1251 out.n116 VSS 0.00679f
C1252 out.n117 VSS 0.00799f
C1253 out.n118 VSS 0.00898f
C1254 out.n119 VSS 0.53243f
C1255 out.n120 VSS 0.00188f
C1256 out.n121 VSS 0.00898f
C1257 out.n122 VSS 0.30146f
C1258 out.n123 VSS 0.00799f
C1259 out.n124 VSS 0.00679f
C1260 out.t4 VSS 0.06655f
C1261 out.n126 VSS 0.01553f
C1262 out.n127 VSS 0.00679f
C1263 out.n128 VSS 0.01553f
C1264 out.n129 VSS 0.00679f
C1265 out.n131 VSS 0.00799f
C1266 out.n132 VSS 0.00679f
C1267 out.n133 VSS 0.00799f
C1268 out.n134 VSS 0.00679f
C1269 out.n136 VSS 0.00799f
C1270 out.n137 VSS 0.00843f
C1271 out.n138 VSS 0.04154f
C1272 out.t24 VSS 0.06655f
C1273 out.n139 VSS 0.13755f
C1274 out.n140 VSS 0.00271f
C1275 out.n141 VSS 0.00679f
C1276 out.n142 VSS 0.00799f
C1277 out.n143 VSS 0.00898f
C1278 out.n144 VSS 0.44757f
C1279 out.n145 VSS 1.32324f
C1280 out.n146 VSS 1.986f
C1281 out.n147 VSS 0.02351f
C1282 out.n148 VSS 0.00898f
C1283 out.n149 VSS 0.00898f
C1284 out.n150 VSS 0.00898f
C1285 out.n151 VSS 0.02351f
C1286 out.n152 VSS 0.00898f
C1287 out.n153 VSS 0.00898f
C1288 out.n154 VSS 0.00898f
C1289 out.n155 VSS 0.02351f
C1290 out.n156 VSS 0.00898f
C1291 out.n157 VSS 0.00898f
C1292 out.n158 VSS 0.00898f
C1293 out.n159 VSS 0.02351f
C1294 out.n160 VSS 0.00898f
C1295 out.n161 VSS 0.00898f
C1296 out.n162 VSS 0.00898f
C1297 out.n163 VSS 0.00188f
C1298 out.n164 VSS 0.00898f
C1299 out.n165 VSS 0.30146f
C1300 out.n166 VSS 0.00799f
C1301 out.n167 VSS 0.00679f
C1302 out.t25 VSS 0.06655f
C1303 out.n169 VSS 0.01553f
C1304 out.n170 VSS 0.00679f
C1305 out.n171 VSS 0.01553f
C1306 out.n172 VSS 0.00679f
C1307 out.n174 VSS 0.00799f
C1308 out.n175 VSS 0.00679f
C1309 out.n176 VSS 0.00799f
C1310 out.n177 VSS 0.00679f
C1311 out.n179 VSS 0.00799f
C1312 out.n180 VSS 0.00843f
C1313 out.n181 VSS 0.04154f
C1314 out.t23 VSS 0.06655f
C1315 out.n182 VSS 0.13755f
C1316 out.n183 VSS 0.00271f
C1317 out.n184 VSS 0.00679f
C1318 out.n185 VSS 0.00799f
C1319 out.n186 VSS 0.00898f
C1320 out.n187 VSS 0.35107f
C1321 out.n188 VSS 0.00188f
C1322 out.n189 VSS 0.00898f
C1323 out.n190 VSS 0.30146f
C1324 out.n191 VSS 0.00799f
C1325 out.n192 VSS 0.00679f
C1326 out.t18 VSS 0.06655f
C1327 out.n194 VSS 0.01553f
C1328 out.n195 VSS 0.00679f
C1329 out.n196 VSS 0.01553f
C1330 out.n197 VSS 0.00679f
C1331 out.n199 VSS 0.00799f
C1332 out.n200 VSS 0.00679f
C1333 out.n201 VSS 0.00799f
C1334 out.n202 VSS 0.00679f
C1335 out.n204 VSS 0.00799f
C1336 out.n205 VSS 0.00843f
C1337 out.n206 VSS 0.04154f
C1338 out.t8 VSS 0.06655f
C1339 out.n207 VSS 0.13755f
C1340 out.n208 VSS 0.00271f
C1341 out.n209 VSS 0.00679f
C1342 out.n210 VSS 0.00799f
C1343 out.n211 VSS 0.00898f
C1344 out.n212 VSS 0.53243f
C1345 out.n213 VSS 0.00188f
C1346 out.n214 VSS 0.00898f
C1347 out.n215 VSS 0.30146f
C1348 out.n216 VSS 0.00799f
C1349 out.n217 VSS 0.00679f
C1350 out.t21 VSS 0.06655f
C1351 out.n219 VSS 0.01553f
C1352 out.n220 VSS 0.00679f
C1353 out.n221 VSS 0.01553f
C1354 out.n222 VSS 0.00679f
C1355 out.n224 VSS 0.00799f
C1356 out.n225 VSS 0.00679f
C1357 out.n226 VSS 0.00799f
C1358 out.n227 VSS 0.00679f
C1359 out.n229 VSS 0.00799f
C1360 out.n230 VSS 0.00843f
C1361 out.n231 VSS 0.04154f
C1362 out.t16 VSS 0.06655f
C1363 out.n232 VSS 0.13755f
C1364 out.n233 VSS 0.00271f
C1365 out.n234 VSS 0.00679f
C1366 out.n235 VSS 0.00799f
C1367 out.n236 VSS 0.00898f
C1368 out.n237 VSS 0.53243f
C1369 out.n238 VSS 0.00188f
C1370 out.n239 VSS 0.00898f
C1371 out.n240 VSS 0.30146f
C1372 out.n241 VSS 0.00799f
C1373 out.n242 VSS 0.00679f
C1374 out.t19 VSS 0.06655f
C1375 out.n244 VSS 0.01553f
C1376 out.n245 VSS 0.00679f
C1377 out.n246 VSS 0.01553f
C1378 out.n247 VSS 0.00679f
C1379 out.n249 VSS 0.00799f
C1380 out.n250 VSS 0.00679f
C1381 out.n251 VSS 0.00799f
C1382 out.n252 VSS 0.00679f
C1383 out.n254 VSS 0.00799f
C1384 out.n255 VSS 0.00843f
C1385 out.n256 VSS 0.04154f
C1386 out.t26 VSS 0.06655f
C1387 out.n257 VSS 0.13755f
C1388 out.n258 VSS 0.00271f
C1389 out.n259 VSS 0.00679f
C1390 out.n260 VSS 0.00799f
C1391 out.n261 VSS 0.00898f
C1392 out.n262 VSS 1.77774f
C1393 out.n263 VSS 0.19637f
C1394 out.n264 VSS 0.00898f
C1395 out.n265 VSS 0.00188f
C1396 out.n266 VSS 0.16492f
C1397 out.n267 VSS 0.00898f
C1398 out.n268 VSS 0.00188f
C1399 out.n269 VSS 0.16492f
C1400 out.n270 VSS 0.00898f
C1401 out.n271 VSS 0.00188f
C1402 out.n272 VSS 0.16492f
C1403 out.n273 VSS 0.00898f
C1404 out.n274 VSS 0.00188f
C1405 out.n275 VSS 0.16492f
C1406 out.n276 VSS 0.00898f
C1407 out.n277 VSS 0.00188f
C1408 out.n278 VSS 0.16492f
C1409 out.n279 VSS 0.00898f
C1410 out.n280 VSS 0.00188f
C1411 out.n281 VSS 0.00898f
C1412 out.n282 VSS 0.00278f
C1413 out.n283 VSS 0.01553f
C1414 out.n284 VSS 0.00679f
C1415 out.t3 VSS 0.03631f
C1416 out.n285 VSS 0.01553f
C1417 out.n286 VSS 0.00821f
C1418 out.n287 VSS 0.00368f
C1419 out.t11 VSS 0.03631f
C1420 out.n288 VSS 0.07537f
C1421 out.n290 VSS 0.00799f
C1422 out.n291 VSS 0.00679f
C1423 out.n292 VSS 0.00679f
C1424 out.n293 VSS 0.00799f
C1425 out.n294 VSS 0.02344f
C1426 out.n295 VSS 0.22739f
C1427 out.n296 VSS 0.00898f
C1428 out.n297 VSS 0.00278f
C1429 out.n298 VSS 0.01553f
C1430 out.n299 VSS 0.00679f
C1431 out.t28 VSS 0.03631f
C1432 out.n300 VSS 0.01553f
C1433 out.n301 VSS 0.00821f
C1434 out.n302 VSS 0.00368f
C1435 out.t7 VSS 0.03631f
C1436 out.n303 VSS 0.07537f
C1437 out.n305 VSS 0.00799f
C1438 out.n306 VSS 0.00679f
C1439 out.n307 VSS 0.00679f
C1440 out.n308 VSS 0.00799f
C1441 out.n309 VSS 0.02344f
C1442 out.n310 VSS 0.35495f
C1443 out.n311 VSS 0.00898f
C1444 out.n312 VSS 0.00278f
C1445 out.n313 VSS 0.01553f
C1446 out.n314 VSS 0.00679f
C1447 out.t1 VSS 0.03631f
C1448 out.n315 VSS 0.01553f
C1449 out.n316 VSS 0.00821f
C1450 out.n317 VSS 0.00368f
C1451 out.t12 VSS 0.03631f
C1452 out.n318 VSS 0.07537f
C1453 out.n320 VSS 0.00799f
C1454 out.n321 VSS 0.00679f
C1455 out.n322 VSS 0.00679f
C1456 out.n323 VSS 0.00799f
C1457 out.n324 VSS 0.02344f
C1458 out.n325 VSS 0.3422f
C1459 out.n326 VSS 1.4892f
C1460 out.n327 VSS 0.00898f
C1461 out.n328 VSS 0.00278f
C1462 out.n329 VSS 0.01553f
C1463 out.n330 VSS 0.00679f
C1464 out.t14 VSS 0.03631f
C1465 out.n331 VSS 0.01553f
C1466 out.n332 VSS 0.00821f
C1467 out.n333 VSS 0.00368f
C1468 out.t10 VSS 0.03631f
C1469 out.n334 VSS 0.07537f
C1470 out.n336 VSS 0.00799f
C1471 out.n337 VSS 0.00679f
C1472 out.n338 VSS 0.00679f
C1473 out.n339 VSS 0.00799f
C1474 out.n340 VSS 0.02344f
C1475 out.n341 VSS 0.19023f
C1476 out.n342 VSS 0.00898f
C1477 out.n343 VSS 0.00278f
C1478 out.n344 VSS 0.01553f
C1479 out.n345 VSS 0.00679f
C1480 out.t6 VSS 0.03631f
C1481 out.n346 VSS 0.01553f
C1482 out.n347 VSS 0.00821f
C1483 out.n348 VSS 0.00368f
C1484 out.t13 VSS 0.03631f
C1485 out.n349 VSS 0.07537f
C1486 out.n351 VSS 0.00799f
C1487 out.n352 VSS 0.00679f
C1488 out.n353 VSS 0.00679f
C1489 out.n354 VSS 0.00799f
C1490 out.n355 VSS 0.02344f
C1491 out.n356 VSS 0.35495f
C1492 out.n357 VSS 0.00898f
C1493 out.n358 VSS 0.01494f
C1494 out.n359 VSS 0.02062f
C1495 out.n360 VSS 0.01198f
C1496 out.n361 VSS 0.01198f
C1497 out.n362 VSS 0.00907f
C1498 out.t27 VSS 0.01777f
C1499 out.n363 VSS 0.0268f
C1500 out.n364 VSS 0.00746f
C1501 out.n365 VSS 0.01553f
C1502 out.n366 VSS 0.00679f
C1503 out.n367 VSS 0.01553f
C1504 out.n368 VSS 0.00679f
C1505 out.n369 VSS 0.00799f
C1506 out.n370 VSS 0.00679f
C1507 out.n371 VSS 0.00679f
C1508 out.n372 VSS 0.00799f
C1509 out.n373 VSS 0.02726f
C1510 out.n374 VSS 1.38481f
C1511 out.n375 VSS 2.90714f
C1512 out.n376 VSS 1.57066f
C1513 out.n377 VSS 16.3615f
.ends
