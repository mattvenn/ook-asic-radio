* amp_dpc_t: magic R+C extraction of layout/amp_dpc_t.gds (layout/pex.sh)
.subckt amp_dpc_t inp inn nb outp outn VDD VSS
X0 outn.t2 inp.t1 sp VSS.t20 sky130_fd_pr__nfet_01v8 ad=0.75 pd=5.3 as=0.75 ps=5.3 w=5 l=0.15
X1 VDD.t1 outn.t4 VSS.t22 sky130_fd_pr__res_high_po_0p69 l=7.38
X2 sp inp.t0 outn.t1 VSS.t21 sky130_fd_pr__nfet_01v8 ad=1.5 pd=10.6 as=0.75 ps=5.3 w=5 l=0.15
X3 sp sn sky130_fd_pr__cap_mim_m3_1 l=21.33 w=6.8
X4 VSS.t8 nb.t8 sp VSS.t7 sky130_fd_pr__nfet_01v8 ad=0.45 pd=3.3 as=0.45 ps=3.3 w=3 l=0.5
X5 outp.t4 VDD.t0 VSS.t22 sky130_fd_pr__res_high_po_0p69 l=7.38
X6 sp nb.t9 VSS.t6 VSS.t5 sky130_fd_pr__nfet_01v8 ad=0.45 pd=3.3 as=0.45 ps=3.3 w=3 l=0.5
X7 sn nb.t5 VSS.t1 VSS.t0 sky130_fd_pr__nfet_01v8 ad=0.45 pd=3.3 as=0.9 ps=6.6 w=3 l=0.5
X8 VSS.t17 nb.t0 sn VSS.t11 sky130_fd_pr__nfet_01v8 ad=0.9 pd=6.6 as=0.45 ps=3.3 w=3 l=0.5
X9 sn nb.t1 VSS.t16 VSS.t9 sky130_fd_pr__nfet_01v8 ad=0.45 pd=3.3 as=0.45 ps=3.3 w=3 l=0.5
X10 VSS.t4 nb.t10 sp VSS.t3 sky130_fd_pr__nfet_01v8 ad=0.45 pd=3.3 as=0.45 ps=3.3 w=3 l=0.5
X11 VSS.t15 nb.t2 sn VSS.t7 sky130_fd_pr__nfet_01v8 ad=0.45 pd=3.3 as=0.45 ps=3.3 w=3 l=0.5
X12 sn nb.t3 VSS.t14 VSS.t5 sky130_fd_pr__nfet_01v8 ad=0.45 pd=3.3 as=0.45 ps=3.3 w=3 l=0.5
X13 outp.t0 inn.t3 sn VSS.t18 sky130_fd_pr__nfet_01v8 ad=0.75 pd=5.3 as=1.5 ps=10.6 w=5 l=0.15
X14 sn inn.t2 outp.t3 VSS.t19 sky130_fd_pr__nfet_01v8 ad=0.75 pd=5.3 as=0.75 ps=5.3 w=5 l=0.15
X15 sn sp sky130_fd_pr__cap_mim_m3_1 l=21.33 w=6.8
X16 sp nb.t11 VSS.t2 VSS.t0 sky130_fd_pr__nfet_01v8 ad=0.45 pd=3.3 as=0.9 ps=6.6 w=3 l=0.5
X17 outp.t2 inn.t1 sn VSS.t20 sky130_fd_pr__nfet_01v8 ad=0.75 pd=5.3 as=0.75 ps=5.3 w=5 l=0.15
X18 VSS.t12 nb.t6 sp VSS.t11 sky130_fd_pr__nfet_01v8 ad=0.9 pd=6.6 as=0.45 ps=3.3 w=3 l=0.5
X19 sn inn.t0 outp.t1 VSS.t21 sky130_fd_pr__nfet_01v8 ad=1.5 pd=10.6 as=0.75 ps=5.3 w=5 l=0.15
X20 outn.t0 inp.t3 sp VSS.t18 sky130_fd_pr__nfet_01v8 ad=0.75 pd=5.3 as=1.5 ps=10.6 w=5 l=0.15
X21 sp nb.t7 VSS.t10 VSS.t9 sky130_fd_pr__nfet_01v8 ad=0.45 pd=3.3 as=0.45 ps=3.3 w=3 l=0.5
X22 VSS.t13 nb.t4 sn VSS.t3 sky130_fd_pr__nfet_01v8 ad=0.45 pd=3.3 as=0.45 ps=3.3 w=3 l=0.5
X23 sp inp.t2 outn.t3 VSS.t19 sky130_fd_pr__nfet_01v8 ad=0.75 pd=5.3 as=0.75 ps=5.3 w=5 l=0.15
R0 outp.n6 outp.n5 86.1871
R1 outp.n13 outp.n12 86.1871
R2 outp.n4 outp.n3 33.2743
R3 outp.n11 outp.n10 33.2743
R4 outp.n7 outp.n6 21.958
R5 outp.n14 outp.n13 21.958
R6 outp.n5 outp.n4 17.3653
R7 outp.n12 outp.n11 17.3653
R8 outp.n6 outp.n3 12.6288
R9 outp.n13 outp.n10 12.6288
R10 outp.n3 outp.n2 9.3005
R11 outp.n10 outp.n9 9.3005
R12 outp.n17 outp 6.86738
R13 outp outp.n17 5.12526
R14 outp.n8 outp.n1 4.55338
R15 outp.n15 outp.n0 4.55338
R16 outp.n15 outp.n14 4.5005
R17 outp.n8 outp.n7 4.5005
R18 outp.n5 outp.t3 3.6005
R19 outp.n5 outp.t0 3.6005
R20 outp.n12 outp.t1 3.6005
R21 outp.n12 outp.t2 3.6005
R22 outp.n16 outp.t4 3.31268
R23 outp outp.n16 2.59529
R24 outp.n17 outp 2.27824
R25 outp.n4 outp.n1 1.08791
R26 outp.n11 outp.n0 1.08791
R27 outp.n16 outp.n15 0.357643
R28 outp.n15 outp.n8 0.268357
R29 outp.n7 outp.n2 0.126462
R30 outp.n14 outp.n9 0.126462
R31 outp.n2 outp.n1 0.0149231
R32 outp.n9 outp.n0 0.0149231
R33 inn.n0 inn.t0 1283.35
R34 inn.n1 inn.t2 1283.29
R35 inn.n2 inn.t3 1058.39
R36 inn.n0 inn.t1 1058.36
R37 inn inn.n2 2.76478
R38 inn.n1 inn.n0 0.0609839
R39 inn.n2 inn.n1 0.0314035
R40 nb.n5 nb.t0 408.675
R41 nb.n0 nb.t6 408.675
R42 nb.n8 nb.t4 408.567
R43 nb.n6 nb.t2 408.567
R44 nb.n3 nb.t10 408.567
R45 nb.n1 nb.t8 408.567
R46 nb.n9 nb.t5 341.087
R47 nb.n7 nb.t3 341.087
R48 nb.n5 nb.t1 341.087
R49 nb.n4 nb.t11 341.087
R50 nb.n2 nb.t9 341.087
R51 nb.n0 nb.t7 341.087
R52 nb.n10 nb.n9 4.55552
R53 nb.n10 nb.n4 4.55452
R54 nb.n10 nb 3.188
R55 nb nb.n10 0.313
R56 nb.n6 nb.n5 0.108027
R57 nb.n7 nb.n6 0.108027
R58 nb.n8 nb.n7 0.108027
R59 nb.n9 nb.n8 0.108027
R60 nb.n1 nb.n0 0.108027
R61 nb.n2 nb.n1 0.108027
R62 nb.n3 nb.n2 0.108027
R63 nb.n4 nb.n3 0.108027
R64 outn.n10 outn.n9 185
R65 outn.n3 outn.n2 86.1871
R66 outn.n5 outn.n4 33.2746
R67 outn.n12 outn.n9 27.1064
R68 outn.n12 outn.n11 26.125
R69 outn.n7 outn.n2 21.958
R70 outn.n4 outn.n3 17.3652
R71 outn.n11 outn.n10 13.6337
R72 outn.n5 outn.n2 12.6288
R73 outn.n14 outn.n9 9.32967
R74 outn.n6 outn.n5 9.3005
R75 outn.n13 outn.n12 9.3005
R76 outn.n18 outn.n17 6.8205
R77 outn.n18 outn 5.18401
R78 outn.n8 outn.n1 4.55338
R79 outn.n15 outn.n0 4.55338
R80 outn.n15 outn.n14 4.5005
R81 outn.n8 outn.n7 4.5005
R82 outn.n3 outn.t3 3.6005
R83 outn.n3 outn.t0 3.6005
R84 outn.n10 outn.t1 3.6005
R85 outn.n10 outn.t2 3.6005
R86 outn.n11 outn.n0 3.54039
R87 outn.n16 outn.t4 3.31245
R88 outn outn.n18 2.21949
R89 outn.n17 outn.n16 2.20467
R90 outn.n4 outn.n1 1.0884
R91 outn.n17 outn 0.391125
R92 outn.n16 outn.n15 0.357643
R93 outn.n15 outn.n8 0.268357
R94 outn.n7 outn.n6 0.126462
R95 outn.n14 outn.n13 0.126462
R96 outn.n6 outn.n1 0.0149231
R97 outn.n13 outn.n0 0.0149231
R98 inp.n0 inp.t0 1283.35
R99 inp.n1 inp.t2 1283.29
R100 inp.n2 inp.t3 1058.39
R101 inp.n0 inp.t1 1058.36
R102 inp inp.n2 2.76478
R103 inp.n1 inp.n0 0.0609839
R104 inp.n2 inp.n1 0.0314035
R105 VDD.n0 VDD.t0 5.52828
R106 VDD.n1 VDD.t1 5.52807
R107 VDD.n1 VDD.n0 4.60689
R108 VDD VDD.n1 0.51925
R109 VDD.n0 VDD 0.51925
R110 VSS.n741 VSS.n91 585
R111 VSS.n741 VSS.n98 585
R112 VSS.n742 VSS.n70 585
R113 VSS.n743 VSS.n742 585
R114 VSS.n740 VSS.n69 585
R115 VSS.n740 VSS.n739 585
R116 VSS.n154 VSS.n153 585
R117 VSS.n162 VSS.n154 585
R118 VSS.n160 VSS.n63 585
R119 VSS.n586 VSS.n160 585
R120 VSS.n575 VSS.n62 585
R121 VSS.n575 VSS.n574 585
R122 VSS.n576 VSS.n59 585
R123 VSS.n577 VSS.n576 585
R124 VSS.n572 VSS.n171 585
R125 VSS.n572 VSS.n571 585
R126 VSS.n170 VSS.n53 585
R127 VSS.n172 VSS.n170 585
R128 VSS.n180 VSS.n52 585
R129 VSS.n561 VSS.n180 585
R130 VSS.n549 VSS.n49 585
R131 VSS.n549 VSS.n178 585
R132 VSS.n551 VSS.n550 585
R133 VSS.n552 VSS.n551 585
R134 VSS.n548 VSS.n43 585
R135 VSS.n548 VSS.n547 585
R136 VSS.n189 VSS.n42 585
R137 VSS.n191 VSS.n189 585
R138 VSS.n198 VSS.n41 585
R139 VSS.n537 VSS.n198 585
R140 VSS.n341 VSS.n15 585
R141 VSS.n341 VSS.n197 585
R142 VSS.n343 VSS.n342 585
R143 VSS.n347 VSS.n340 585
R144 VSS.n349 VSS.n348 585
R145 VSS.n351 VSS.n350 585
R146 VSS.n353 VSS.n352 585
R147 VSS.n357 VSS.n338 585
R148 VSS.n359 VSS.n358 585
R149 VSS.n361 VSS.n360 585
R150 VSS.n363 VSS.n362 585
R151 VSS.n367 VSS.n336 585
R152 VSS.n369 VSS.n368 585
R153 VSS.n371 VSS.n370 585
R154 VSS.n373 VSS.n372 585
R155 VSS.n377 VSS.n334 585
R156 VSS.n379 VSS.n378 585
R157 VSS.n381 VSS.n380 585
R158 VSS.n383 VSS.n382 585
R159 VSS.n387 VSS.n332 585
R160 VSS.n389 VSS.n388 585
R161 VSS.n391 VSS.n390 585
R162 VSS.n393 VSS.n392 585
R163 VSS.n397 VSS.n330 585
R164 VSS.n399 VSS.n398 585
R165 VSS.n401 VSS.n400 585
R166 VSS.n403 VSS.n402 585
R167 VSS.n407 VSS.n328 585
R168 VSS.n409 VSS.n408 585
R169 VSS.n411 VSS.n410 585
R170 VSS.n413 VSS.n412 585
R171 VSS.n417 VSS.n326 585
R172 VSS.n419 VSS.n418 585
R173 VSS.n421 VSS.n420 585
R174 VSS.n423 VSS.n422 585
R175 VSS.n427 VSS.n324 585
R176 VSS.n429 VSS.n428 585
R177 VSS.n431 VSS.n430 585
R178 VSS.n433 VSS.n432 585
R179 VSS.n437 VSS.n322 585
R180 VSS.n439 VSS.n438 585
R181 VSS.n441 VSS.n440 585
R182 VSS.n443 VSS.n442 585
R183 VSS.n447 VSS.n320 585
R184 VSS.n449 VSS.n448 585
R185 VSS.n451 VSS.n450 585
R186 VSS.n453 VSS.n452 585
R187 VSS.n318 VSS.n317 585
R188 VSS.n458 VSS.n457 585
R189 VSS.n460 VSS.n458 585
R190 VSS.n733 VSS.n732 585
R191 VSS.n726 VSS.n594 585
R192 VSS.n728 VSS.n727 585
R193 VSS.n725 VSS.n724 585
R194 VSS.n723 VSS.n722 585
R195 VSS.n716 VSS.n596 585
R196 VSS.n718 VSS.n717 585
R197 VSS.n715 VSS.n714 585
R198 VSS.n713 VSS.n712 585
R199 VSS.n706 VSS.n598 585
R200 VSS.n708 VSS.n707 585
R201 VSS.n705 VSS.n704 585
R202 VSS.n703 VSS.n702 585
R203 VSS.n696 VSS.n600 585
R204 VSS.n698 VSS.n697 585
R205 VSS.n695 VSS.n694 585
R206 VSS.n693 VSS.n692 585
R207 VSS.n686 VSS.n602 585
R208 VSS.n688 VSS.n687 585
R209 VSS.n685 VSS.n684 585
R210 VSS.n683 VSS.n682 585
R211 VSS.n676 VSS.n604 585
R212 VSS.n678 VSS.n677 585
R213 VSS.n675 VSS.n674 585
R214 VSS.n673 VSS.n672 585
R215 VSS.n666 VSS.n606 585
R216 VSS.n668 VSS.n667 585
R217 VSS.n665 VSS.n664 585
R218 VSS.n663 VSS.n662 585
R219 VSS.n656 VSS.n608 585
R220 VSS.n658 VSS.n657 585
R221 VSS.n655 VSS.n654 585
R222 VSS.n653 VSS.n652 585
R223 VSS.n646 VSS.n610 585
R224 VSS.n648 VSS.n647 585
R225 VSS.n645 VSS.n644 585
R226 VSS.n643 VSS.n642 585
R227 VSS.n636 VSS.n612 585
R228 VSS.n638 VSS.n637 585
R229 VSS.n635 VSS.n634 585
R230 VSS.n633 VSS.n632 585
R231 VSS.n626 VSS.n614 585
R232 VSS.n628 VSS.n627 585
R233 VSS.n625 VSS.n624 585
R234 VSS.n623 VSS.n622 585
R235 VSS.n617 VSS.n616 585
R236 VSS.n618 VSS.n99 585
R237 VSS.n876 VSS.n99 585
R238 VSS.n735 VSS.n734 585
R239 VSS.n734 VSS.n98 585
R240 VSS.n736 VSS.n152 585
R241 VSS.n743 VSS.n152 585
R242 VSS.n738 VSS.n737 585
R243 VSS.n739 VSS.n738 585
R244 VSS.n156 VSS.n155 585
R245 VSS.n162 VSS.n155 585
R246 VSS.n588 VSS.n587 585
R247 VSS.n587 VSS.n586 585
R248 VSS.n159 VSS.n158 585
R249 VSS.n574 VSS.n159 585
R250 VSS.n568 VSS.n169 585
R251 VSS.n577 VSS.n169 585
R252 VSS.n570 VSS.n569 585
R253 VSS.n571 VSS.n570 585
R254 VSS.n174 VSS.n173 585
R255 VSS.n173 VSS.n172 585
R256 VSS.n563 VSS.n562 585
R257 VSS.n562 VSS.n561 585
R258 VSS.n177 VSS.n176 585
R259 VSS.n178 VSS.n177 585
R260 VSS.n544 VSS.n188 585
R261 VSS.n552 VSS.n188 585
R262 VSS.n546 VSS.n545 585
R263 VSS.n547 VSS.n546 585
R264 VSS.n193 VSS.n192 585
R265 VSS.n192 VSS.n191 585
R266 VSS.n539 VSS.n538 585
R267 VSS.n538 VSS.n537 585
R268 VSS.n196 VSS.n195 585
R269 VSS.n197 VSS.n196 585
R270 VSS.n201 VSS.n199 585
R271 VSS.n199 VSS.n197 585
R272 VSS.n536 VSS.n535 585
R273 VSS.n537 VSS.n536 585
R274 VSS.n202 VSS.n200 585
R275 VSS.n200 VSS.n191 585
R276 VSS.n187 VSS.n186 585
R277 VSS.n547 VSS.n187 585
R278 VSS.n554 VSS.n553 585
R279 VSS.n553 VSS.n552 585
R280 VSS.n183 VSS.n181 585
R281 VSS.n181 VSS.n178 585
R282 VSS.n560 VSS.n559 585
R283 VSS.n561 VSS.n560 585
R284 VSS.n184 VSS.n182 585
R285 VSS.n182 VSS.n172 585
R286 VSS.n168 VSS.n167 585
R287 VSS.n571 VSS.n168 585
R288 VSS.n579 VSS.n578 585
R289 VSS.n578 VSS.n577 585
R290 VSS.n164 VSS.n161 585
R291 VSS.n574 VSS.n161 585
R292 VSS.n585 VSS.n584 585
R293 VSS.n586 VSS.n585 585
R294 VSS.n165 VSS.n163 585
R295 VSS.n163 VSS.n162 585
R296 VSS.n150 VSS.n149 585
R297 VSS.n739 VSS.n150 585
R298 VSS.n745 VSS.n744 585
R299 VSS.n744 VSS.n743 585
R300 VSS.n146 VSS.n144 585
R301 VSS.n144 VSS.n98 585
R302 VSS.n884 VSS.n94 585
R303 VSS.n878 VSS.n93 585
R304 VSS.n880 VSS.n879 585
R305 VSS.n808 VSS.n96 585
R306 VSS.n810 VSS.n809 585
R307 VSS.n807 VSS.n806 585
R308 VSS.n814 VSS.n805 585
R309 VSS.n815 VSS.n804 585
R310 VSS.n816 VSS.n803 585
R311 VSS.n801 VSS.n800 585
R312 VSS.n820 VSS.n799 585
R313 VSS.n821 VSS.n798 585
R314 VSS.n822 VSS.n797 585
R315 VSS.n795 VSS.n794 585
R316 VSS.n826 VSS.n793 585
R317 VSS.n827 VSS.n792 585
R318 VSS.n828 VSS.n791 585
R319 VSS.n789 VSS.n788 585
R320 VSS.n832 VSS.n787 585
R321 VSS.n833 VSS.n786 585
R322 VSS.n834 VSS.n785 585
R323 VSS.n783 VSS.n782 585
R324 VSS.n838 VSS.n781 585
R325 VSS.n839 VSS.n780 585
R326 VSS.n840 VSS.n779 585
R327 VSS.n777 VSS.n776 585
R328 VSS.n844 VSS.n775 585
R329 VSS.n845 VSS.n774 585
R330 VSS.n846 VSS.n773 585
R331 VSS.n771 VSS.n770 585
R332 VSS.n850 VSS.n769 585
R333 VSS.n851 VSS.n768 585
R334 VSS.n852 VSS.n767 585
R335 VSS.n765 VSS.n764 585
R336 VSS.n856 VSS.n763 585
R337 VSS.n857 VSS.n762 585
R338 VSS.n858 VSS.n761 585
R339 VSS.n759 VSS.n758 585
R340 VSS.n862 VSS.n757 585
R341 VSS.n863 VSS.n756 585
R342 VSS.n864 VSS.n755 585
R343 VSS.n753 VSS.n752 585
R344 VSS.n868 VSS.n751 585
R345 VSS.n869 VSS.n750 585
R346 VSS.n870 VSS.n749 585
R347 VSS.n147 VSS.n145 585
R348 VSS.n875 VSS.n874 585
R349 VSS.n876 VSS.n875 585
R350 VSS.n885 VSS.n92 585
R351 VSS.n98 VSS.n92 585
R352 VSS.n151 VSS.n68 585
R353 VSS.n743 VSS.n151 585
R354 VSS.n890 VSS.n67 585
R355 VSS.n739 VSS.n67 585
R356 VSS.n891 VSS.n66 585
R357 VSS.n162 VSS.n66 585
R358 VSS.n892 VSS.n65 585
R359 VSS.n586 VSS.n65 585
R360 VSS.n573 VSS.n58 585
R361 VSS.n574 VSS.n573 585
R362 VSS.n897 VSS.n57 585
R363 VSS.n577 VSS.n57 585
R364 VSS.n898 VSS.n56 585
R365 VSS.n571 VSS.n56 585
R366 VSS.n899 VSS.n55 585
R367 VSS.n172 VSS.n55 585
R368 VSS.n179 VSS.n48 585
R369 VSS.n561 VSS.n179 585
R370 VSS.n904 VSS.n47 585
R371 VSS.n178 VSS.n47 585
R372 VSS.n905 VSS.n46 585
R373 VSS.n552 VSS.n46 585
R374 VSS.n906 VSS.n45 585
R375 VSS.n547 VSS.n45 585
R376 VSS.n190 VSS.n40 585
R377 VSS.n191 VSS.n190 585
R378 VSS.n910 VSS.n39 585
R379 VSS.n537 VSS.n39 585
R380 VSS.n911 VSS.n38 585
R381 VSS.n197 VSS.n38 585
R382 VSS.n530 VSS.n204 585
R383 VSS.n529 VSS.n205 585
R384 VSS.n528 VSS.n206 585
R385 VSS.n460 VSS.n206 585
R386 VSS.n262 VSS.n207 585
R387 VSS.n524 VSS.n209 585
R388 VSS.n523 VSS.n210 585
R389 VSS.n522 VSS.n211 585
R390 VSS.n265 VSS.n212 585
R391 VSS.n518 VSS.n214 585
R392 VSS.n517 VSS.n215 585
R393 VSS.n516 VSS.n216 585
R394 VSS.n268 VSS.n217 585
R395 VSS.n512 VSS.n219 585
R396 VSS.n511 VSS.n220 585
R397 VSS.n510 VSS.n221 585
R398 VSS.n271 VSS.n222 585
R399 VSS.n506 VSS.n224 585
R400 VSS.n505 VSS.n225 585
R401 VSS.n504 VSS.n226 585
R402 VSS.n274 VSS.n227 585
R403 VSS.n500 VSS.n229 585
R404 VSS.n499 VSS.n230 585
R405 VSS.n498 VSS.n231 585
R406 VSS.n277 VSS.n232 585
R407 VSS.n494 VSS.n234 585
R408 VSS.n493 VSS.n235 585
R409 VSS.n492 VSS.n236 585
R410 VSS.n280 VSS.n237 585
R411 VSS.n488 VSS.n239 585
R412 VSS.n487 VSS.n240 585
R413 VSS.n486 VSS.n241 585
R414 VSS.n283 VSS.n242 585
R415 VSS.n482 VSS.n244 585
R416 VSS.n481 VSS.n245 585
R417 VSS.n480 VSS.n246 585
R418 VSS.n286 VSS.n247 585
R419 VSS.n476 VSS.n249 585
R420 VSS.n475 VSS.n250 585
R421 VSS.n474 VSS.n251 585
R422 VSS.n289 VSS.n252 585
R423 VSS.n470 VSS.n254 585
R424 VSS.n469 VSS.n255 585
R425 VSS.n468 VSS.n256 585
R426 VSS.n292 VSS.n257 585
R427 VSS.n464 VSS.n260 585
R428 VSS.n463 VSS.n462 585
R429 VSS.n261 VSS.n37 585
R430 VSS.n741 VSS.n99 509.738
R431 VSS.n734 VSS.n733 509.738
R432 VSS.n458 VSS.n196 509.738
R433 VSS.n342 VSS.n341 509.738
R434 VSS.n875 VSS.n144 509.738
R435 VSS.n94 VSS.n92 509.738
R436 VSS.n261 VSS.n38 509.738
R437 VSS.n204 VSS.n199 509.738
R438 VSS.n34 VSS.n33 256.483
R439 VSS.n24 VSS.n23 256.483
R440 VSS.n89 VSS.n88 256.483
R441 VSS.n79 VSS.n78 256.483
R442 VSS.n460 VSS.n294 254.01
R443 VSS.n460 VSS.n295 254.01
R444 VSS.n460 VSS.n296 254.01
R445 VSS.n460 VSS.n297 254.01
R446 VSS.n460 VSS.n298 254.01
R447 VSS.n460 VSS.n299 254.01
R448 VSS.n460 VSS.n300 254.01
R449 VSS.n460 VSS.n301 254.01
R450 VSS.n460 VSS.n302 254.01
R451 VSS.n460 VSS.n303 254.01
R452 VSS.n460 VSS.n304 254.01
R453 VSS.n460 VSS.n305 254.01
R454 VSS.n460 VSS.n306 254.01
R455 VSS.n460 VSS.n307 254.01
R456 VSS.n460 VSS.n308 254.01
R457 VSS.n460 VSS.n309 254.01
R458 VSS.n460 VSS.n310 254.01
R459 VSS.n460 VSS.n311 254.01
R460 VSS.n460 VSS.n312 254.01
R461 VSS.n460 VSS.n313 254.01
R462 VSS.n460 VSS.n314 254.01
R463 VSS.n460 VSS.n315 254.01
R464 VSS.n460 VSS.n316 254.01
R465 VSS.n876 VSS.n122 254.01
R466 VSS.n876 VSS.n121 254.01
R467 VSS.n876 VSS.n120 254.01
R468 VSS.n876 VSS.n119 254.01
R469 VSS.n876 VSS.n118 254.01
R470 VSS.n876 VSS.n117 254.01
R471 VSS.n876 VSS.n116 254.01
R472 VSS.n876 VSS.n115 254.01
R473 VSS.n876 VSS.n114 254.01
R474 VSS.n876 VSS.n113 254.01
R475 VSS.n876 VSS.n112 254.01
R476 VSS.n876 VSS.n111 254.01
R477 VSS.n876 VSS.n110 254.01
R478 VSS.n876 VSS.n109 254.01
R479 VSS.n876 VSS.n108 254.01
R480 VSS.n876 VSS.n107 254.01
R481 VSS.n876 VSS.n106 254.01
R482 VSS.n876 VSS.n105 254.01
R483 VSS.n876 VSS.n104 254.01
R484 VSS.n876 VSS.n103 254.01
R485 VSS.n876 VSS.n102 254.01
R486 VSS.n876 VSS.n101 254.01
R487 VSS.n876 VSS.n100 254.01
R488 VSS.n877 VSS.n876 254.01
R489 VSS.n876 VSS.n97 254.01
R490 VSS.n876 VSS.n123 254.01
R491 VSS.n876 VSS.n124 254.01
R492 VSS.n876 VSS.n125 254.01
R493 VSS.n876 VSS.n126 254.01
R494 VSS.n876 VSS.n127 254.01
R495 VSS.n876 VSS.n128 254.01
R496 VSS.n876 VSS.n129 254.01
R497 VSS.n876 VSS.n130 254.01
R498 VSS.n876 VSS.n131 254.01
R499 VSS.n876 VSS.n132 254.01
R500 VSS.n876 VSS.n133 254.01
R501 VSS.n876 VSS.n134 254.01
R502 VSS.n876 VSS.n135 254.01
R503 VSS.n876 VSS.n136 254.01
R504 VSS.n876 VSS.n137 254.01
R505 VSS.n876 VSS.n138 254.01
R506 VSS.n876 VSS.n139 254.01
R507 VSS.n876 VSS.n140 254.01
R508 VSS.n876 VSS.n141 254.01
R509 VSS.n876 VSS.n142 254.01
R510 VSS.n876 VSS.n143 254.01
R511 VSS.n460 VSS.n459 254.01
R512 VSS.n460 VSS.n263 254.01
R513 VSS.n460 VSS.n264 254.01
R514 VSS.n460 VSS.n266 254.01
R515 VSS.n460 VSS.n267 254.01
R516 VSS.n460 VSS.n269 254.01
R517 VSS.n460 VSS.n270 254.01
R518 VSS.n460 VSS.n272 254.01
R519 VSS.n460 VSS.n273 254.01
R520 VSS.n460 VSS.n275 254.01
R521 VSS.n460 VSS.n276 254.01
R522 VSS.n460 VSS.n278 254.01
R523 VSS.n460 VSS.n279 254.01
R524 VSS.n460 VSS.n281 254.01
R525 VSS.n460 VSS.n282 254.01
R526 VSS.n460 VSS.n284 254.01
R527 VSS.n460 VSS.n285 254.01
R528 VSS.n460 VSS.n287 254.01
R529 VSS.n460 VSS.n288 254.01
R530 VSS.n460 VSS.n290 254.01
R531 VSS.n460 VSS.n291 254.01
R532 VSS.n460 VSS.n293 254.01
R533 VSS.n461 VSS.n460 254.01
R534 VSS.n33 VSS.n32 185
R535 VSS.n29 VSS.n28 185
R536 VSS.n19 VSS.n18 185
R537 VSS.n23 VSS.n22 185
R538 VSS.n88 VSS.n87 185
R539 VSS.n84 VSS.n83 185
R540 VSS.n74 VSS.n73 185
R541 VSS.n78 VSS.n77 185
R542 VSS.n20 VSS.t12 180.934
R543 VSS.n75 VSS.t2 180.934
R544 VSS.n30 VSS.t17 180.934
R545 VSS.n85 VSS.t1 180.934
R546 VSS.n616 VSS.n99 177.3
R547 VSS.n624 VSS.n623 177.3
R548 VSS.n627 VSS.n626 177.3
R549 VSS.n634 VSS.n633 177.3
R550 VSS.n637 VSS.n636 177.3
R551 VSS.n644 VSS.n643 177.3
R552 VSS.n647 VSS.n646 177.3
R553 VSS.n654 VSS.n653 177.3
R554 VSS.n657 VSS.n656 177.3
R555 VSS.n664 VSS.n663 177.3
R556 VSS.n667 VSS.n666 177.3
R557 VSS.n674 VSS.n673 177.3
R558 VSS.n677 VSS.n676 177.3
R559 VSS.n684 VSS.n683 177.3
R560 VSS.n687 VSS.n686 177.3
R561 VSS.n694 VSS.n693 177.3
R562 VSS.n697 VSS.n696 177.3
R563 VSS.n704 VSS.n703 177.3
R564 VSS.n707 VSS.n706 177.3
R565 VSS.n714 VSS.n713 177.3
R566 VSS.n717 VSS.n716 177.3
R567 VSS.n724 VSS.n723 177.3
R568 VSS.n727 VSS.n726 177.3
R569 VSS.n538 VSS.n196 177.3
R570 VSS.n538 VSS.n192 177.3
R571 VSS.n546 VSS.n192 177.3
R572 VSS.n546 VSS.n188 177.3
R573 VSS.n188 VSS.n177 177.3
R574 VSS.n562 VSS.n177 177.3
R575 VSS.n562 VSS.n173 177.3
R576 VSS.n570 VSS.n173 177.3
R577 VSS.n570 VSS.n169 177.3
R578 VSS.n169 VSS.n159 177.3
R579 VSS.n587 VSS.n159 177.3
R580 VSS.n587 VSS.n155 177.3
R581 VSS.n738 VSS.n155 177.3
R582 VSS.n738 VSS.n152 177.3
R583 VSS.n734 VSS.n152 177.3
R584 VSS.n348 VSS.n347 177.3
R585 VSS.n352 VSS.n351 177.3
R586 VSS.n358 VSS.n357 177.3
R587 VSS.n362 VSS.n361 177.3
R588 VSS.n368 VSS.n367 177.3
R589 VSS.n372 VSS.n371 177.3
R590 VSS.n378 VSS.n377 177.3
R591 VSS.n382 VSS.n381 177.3
R592 VSS.n388 VSS.n387 177.3
R593 VSS.n392 VSS.n391 177.3
R594 VSS.n398 VSS.n397 177.3
R595 VSS.n402 VSS.n401 177.3
R596 VSS.n408 VSS.n407 177.3
R597 VSS.n412 VSS.n411 177.3
R598 VSS.n418 VSS.n417 177.3
R599 VSS.n422 VSS.n421 177.3
R600 VSS.n428 VSS.n427 177.3
R601 VSS.n432 VSS.n431 177.3
R602 VSS.n438 VSS.n437 177.3
R603 VSS.n442 VSS.n441 177.3
R604 VSS.n448 VSS.n447 177.3
R605 VSS.n452 VSS.n451 177.3
R606 VSS.n458 VSS.n317 177.3
R607 VSS.n341 VSS.n198 177.3
R608 VSS.n198 VSS.n189 177.3
R609 VSS.n548 VSS.n189 177.3
R610 VSS.n551 VSS.n548 177.3
R611 VSS.n551 VSS.n549 177.3
R612 VSS.n549 VSS.n180 177.3
R613 VSS.n180 VSS.n170 177.3
R614 VSS.n572 VSS.n170 177.3
R615 VSS.n576 VSS.n572 177.3
R616 VSS.n576 VSS.n575 177.3
R617 VSS.n575 VSS.n160 177.3
R618 VSS.n160 VSS.n154 177.3
R619 VSS.n740 VSS.n154 177.3
R620 VSS.n742 VSS.n740 177.3
R621 VSS.n742 VSS.n741 177.3
R622 VSS.n875 VSS.n145 177.3
R623 VSS.n750 VSS.n749 177.3
R624 VSS.n752 VSS.n751 177.3
R625 VSS.n756 VSS.n755 177.3
R626 VSS.n758 VSS.n757 177.3
R627 VSS.n762 VSS.n761 177.3
R628 VSS.n764 VSS.n763 177.3
R629 VSS.n768 VSS.n767 177.3
R630 VSS.n770 VSS.n769 177.3
R631 VSS.n774 VSS.n773 177.3
R632 VSS.n776 VSS.n775 177.3
R633 VSS.n780 VSS.n779 177.3
R634 VSS.n782 VSS.n781 177.3
R635 VSS.n786 VSS.n785 177.3
R636 VSS.n788 VSS.n787 177.3
R637 VSS.n792 VSS.n791 177.3
R638 VSS.n794 VSS.n793 177.3
R639 VSS.n798 VSS.n797 177.3
R640 VSS.n800 VSS.n799 177.3
R641 VSS.n804 VSS.n803 177.3
R642 VSS.n806 VSS.n805 177.3
R643 VSS.n809 VSS.n808 177.3
R644 VSS.n879 VSS.n878 177.3
R645 VSS.n39 VSS.n38 177.3
R646 VSS.n190 VSS.n39 177.3
R647 VSS.n190 VSS.n45 177.3
R648 VSS.n46 VSS.n45 177.3
R649 VSS.n47 VSS.n46 177.3
R650 VSS.n179 VSS.n47 177.3
R651 VSS.n179 VSS.n55 177.3
R652 VSS.n56 VSS.n55 177.3
R653 VSS.n57 VSS.n56 177.3
R654 VSS.n573 VSS.n57 177.3
R655 VSS.n573 VSS.n65 177.3
R656 VSS.n66 VSS.n65 177.3
R657 VSS.n67 VSS.n66 177.3
R658 VSS.n151 VSS.n67 177.3
R659 VSS.n151 VSS.n92 177.3
R660 VSS.n206 VSS.n205 177.3
R661 VSS.n262 VSS.n206 177.3
R662 VSS.n210 VSS.n209 177.3
R663 VSS.n265 VSS.n211 177.3
R664 VSS.n215 VSS.n214 177.3
R665 VSS.n268 VSS.n216 177.3
R666 VSS.n220 VSS.n219 177.3
R667 VSS.n271 VSS.n221 177.3
R668 VSS.n225 VSS.n224 177.3
R669 VSS.n274 VSS.n226 177.3
R670 VSS.n230 VSS.n229 177.3
R671 VSS.n277 VSS.n231 177.3
R672 VSS.n235 VSS.n234 177.3
R673 VSS.n280 VSS.n236 177.3
R674 VSS.n240 VSS.n239 177.3
R675 VSS.n283 VSS.n241 177.3
R676 VSS.n245 VSS.n244 177.3
R677 VSS.n286 VSS.n246 177.3
R678 VSS.n250 VSS.n249 177.3
R679 VSS.n289 VSS.n251 177.3
R680 VSS.n255 VSS.n254 177.3
R681 VSS.n292 VSS.n256 177.3
R682 VSS.n462 VSS.n260 177.3
R683 VSS.n536 VSS.n199 177.3
R684 VSS.n536 VSS.n200 177.3
R685 VSS.n200 VSS.n187 177.3
R686 VSS.n553 VSS.n187 177.3
R687 VSS.n553 VSS.n181 177.3
R688 VSS.n560 VSS.n181 177.3
R689 VSS.n560 VSS.n182 177.3
R690 VSS.n182 VSS.n168 177.3
R691 VSS.n578 VSS.n168 177.3
R692 VSS.n578 VSS.n161 177.3
R693 VSS.n585 VSS.n161 177.3
R694 VSS.n585 VSS.n163 177.3
R695 VSS.n163 VSS.n150 177.3
R696 VSS.n744 VSS.n150 177.3
R697 VSS.n744 VSS.n144 177.3
R698 VSS.n33 VSS.n28 144
R699 VSS.n23 VSS.n18 144
R700 VSS.n88 VSS.n83 144
R701 VSS.n78 VSS.n73 144
R702 VSS.n623 VSS.n100 76.985
R703 VSS.n627 VSS.n101 76.985
R704 VSS.n633 VSS.n102 76.985
R705 VSS.n637 VSS.n103 76.985
R706 VSS.n643 VSS.n104 76.985
R707 VSS.n647 VSS.n105 76.985
R708 VSS.n653 VSS.n106 76.985
R709 VSS.n657 VSS.n107 76.985
R710 VSS.n663 VSS.n108 76.985
R711 VSS.n667 VSS.n109 76.985
R712 VSS.n673 VSS.n110 76.985
R713 VSS.n677 VSS.n111 76.985
R714 VSS.n683 VSS.n112 76.985
R715 VSS.n687 VSS.n113 76.985
R716 VSS.n693 VSS.n114 76.985
R717 VSS.n697 VSS.n115 76.985
R718 VSS.n703 VSS.n116 76.985
R719 VSS.n707 VSS.n117 76.985
R720 VSS.n713 VSS.n118 76.985
R721 VSS.n717 VSS.n119 76.985
R722 VSS.n723 VSS.n120 76.985
R723 VSS.n727 VSS.n121 76.985
R724 VSS.n733 VSS.n122 76.985
R725 VSS.n342 VSS.n294 76.985
R726 VSS.n348 VSS.n295 76.985
R727 VSS.n352 VSS.n296 76.985
R728 VSS.n358 VSS.n297 76.985
R729 VSS.n362 VSS.n298 76.985
R730 VSS.n368 VSS.n299 76.985
R731 VSS.n372 VSS.n300 76.985
R732 VSS.n378 VSS.n301 76.985
R733 VSS.n382 VSS.n302 76.985
R734 VSS.n388 VSS.n303 76.985
R735 VSS.n392 VSS.n304 76.985
R736 VSS.n398 VSS.n305 76.985
R737 VSS.n402 VSS.n306 76.985
R738 VSS.n408 VSS.n307 76.985
R739 VSS.n412 VSS.n308 76.985
R740 VSS.n418 VSS.n309 76.985
R741 VSS.n422 VSS.n310 76.985
R742 VSS.n428 VSS.n311 76.985
R743 VSS.n432 VSS.n312 76.985
R744 VSS.n438 VSS.n313 76.985
R745 VSS.n442 VSS.n314 76.985
R746 VSS.n448 VSS.n315 76.985
R747 VSS.n452 VSS.n316 76.985
R748 VSS.n347 VSS.n294 76.985
R749 VSS.n351 VSS.n295 76.985
R750 VSS.n357 VSS.n296 76.985
R751 VSS.n361 VSS.n297 76.985
R752 VSS.n367 VSS.n298 76.985
R753 VSS.n371 VSS.n299 76.985
R754 VSS.n377 VSS.n300 76.985
R755 VSS.n381 VSS.n301 76.985
R756 VSS.n387 VSS.n302 76.985
R757 VSS.n391 VSS.n303 76.985
R758 VSS.n397 VSS.n304 76.985
R759 VSS.n401 VSS.n305 76.985
R760 VSS.n407 VSS.n306 76.985
R761 VSS.n411 VSS.n307 76.985
R762 VSS.n417 VSS.n308 76.985
R763 VSS.n421 VSS.n309 76.985
R764 VSS.n427 VSS.n310 76.985
R765 VSS.n431 VSS.n311 76.985
R766 VSS.n437 VSS.n312 76.985
R767 VSS.n441 VSS.n313 76.985
R768 VSS.n447 VSS.n314 76.985
R769 VSS.n451 VSS.n315 76.985
R770 VSS.n317 VSS.n316 76.985
R771 VSS.n726 VSS.n122 76.985
R772 VSS.n724 VSS.n121 76.985
R773 VSS.n716 VSS.n120 76.985
R774 VSS.n714 VSS.n119 76.985
R775 VSS.n706 VSS.n118 76.985
R776 VSS.n704 VSS.n117 76.985
R777 VSS.n696 VSS.n116 76.985
R778 VSS.n694 VSS.n115 76.985
R779 VSS.n686 VSS.n114 76.985
R780 VSS.n684 VSS.n113 76.985
R781 VSS.n676 VSS.n112 76.985
R782 VSS.n674 VSS.n111 76.985
R783 VSS.n666 VSS.n110 76.985
R784 VSS.n664 VSS.n109 76.985
R785 VSS.n656 VSS.n108 76.985
R786 VSS.n654 VSS.n107 76.985
R787 VSS.n646 VSS.n106 76.985
R788 VSS.n644 VSS.n105 76.985
R789 VSS.n636 VSS.n104 76.985
R790 VSS.n634 VSS.n103 76.985
R791 VSS.n626 VSS.n102 76.985
R792 VSS.n624 VSS.n101 76.985
R793 VSS.n616 VSS.n100 76.985
R794 VSS.n749 VSS.n143 76.985
R795 VSS.n751 VSS.n142 76.985
R796 VSS.n755 VSS.n141 76.985
R797 VSS.n757 VSS.n140 76.985
R798 VSS.n761 VSS.n139 76.985
R799 VSS.n763 VSS.n138 76.985
R800 VSS.n767 VSS.n137 76.985
R801 VSS.n769 VSS.n136 76.985
R802 VSS.n773 VSS.n135 76.985
R803 VSS.n775 VSS.n134 76.985
R804 VSS.n779 VSS.n133 76.985
R805 VSS.n781 VSS.n132 76.985
R806 VSS.n785 VSS.n131 76.985
R807 VSS.n787 VSS.n130 76.985
R808 VSS.n791 VSS.n129 76.985
R809 VSS.n793 VSS.n128 76.985
R810 VSS.n797 VSS.n127 76.985
R811 VSS.n799 VSS.n126 76.985
R812 VSS.n803 VSS.n125 76.985
R813 VSS.n805 VSS.n124 76.985
R814 VSS.n809 VSS.n123 76.985
R815 VSS.n879 VSS.n97 76.985
R816 VSS.n877 VSS.n94 76.985
R817 VSS.n459 VSS.n204 76.985
R818 VSS.n263 VSS.n262 76.985
R819 VSS.n264 VSS.n210 76.985
R820 VSS.n266 VSS.n265 76.985
R821 VSS.n267 VSS.n215 76.985
R822 VSS.n269 VSS.n268 76.985
R823 VSS.n270 VSS.n220 76.985
R824 VSS.n272 VSS.n271 76.985
R825 VSS.n273 VSS.n225 76.985
R826 VSS.n275 VSS.n274 76.985
R827 VSS.n276 VSS.n230 76.985
R828 VSS.n278 VSS.n277 76.985
R829 VSS.n279 VSS.n235 76.985
R830 VSS.n281 VSS.n280 76.985
R831 VSS.n282 VSS.n240 76.985
R832 VSS.n284 VSS.n283 76.985
R833 VSS.n285 VSS.n245 76.985
R834 VSS.n287 VSS.n286 76.985
R835 VSS.n288 VSS.n250 76.985
R836 VSS.n290 VSS.n289 76.985
R837 VSS.n291 VSS.n255 76.985
R838 VSS.n293 VSS.n292 76.985
R839 VSS.n462 VSS.n461 76.985
R840 VSS.n878 VSS.n877 76.985
R841 VSS.n808 VSS.n97 76.985
R842 VSS.n806 VSS.n123 76.985
R843 VSS.n804 VSS.n124 76.985
R844 VSS.n800 VSS.n125 76.985
R845 VSS.n798 VSS.n126 76.985
R846 VSS.n794 VSS.n127 76.985
R847 VSS.n792 VSS.n128 76.985
R848 VSS.n788 VSS.n129 76.985
R849 VSS.n786 VSS.n130 76.985
R850 VSS.n782 VSS.n131 76.985
R851 VSS.n780 VSS.n132 76.985
R852 VSS.n776 VSS.n133 76.985
R853 VSS.n774 VSS.n134 76.985
R854 VSS.n770 VSS.n135 76.985
R855 VSS.n768 VSS.n136 76.985
R856 VSS.n764 VSS.n137 76.985
R857 VSS.n762 VSS.n138 76.985
R858 VSS.n758 VSS.n139 76.985
R859 VSS.n756 VSS.n140 76.985
R860 VSS.n752 VSS.n141 76.985
R861 VSS.n750 VSS.n142 76.985
R862 VSS.n145 VSS.n143 76.985
R863 VSS.n459 VSS.n205 76.985
R864 VSS.n263 VSS.n209 76.985
R865 VSS.n264 VSS.n211 76.985
R866 VSS.n266 VSS.n214 76.985
R867 VSS.n267 VSS.n216 76.985
R868 VSS.n269 VSS.n219 76.985
R869 VSS.n270 VSS.n221 76.985
R870 VSS.n272 VSS.n224 76.985
R871 VSS.n273 VSS.n226 76.985
R872 VSS.n275 VSS.n229 76.985
R873 VSS.n276 VSS.n231 76.985
R874 VSS.n278 VSS.n234 76.985
R875 VSS.n279 VSS.n236 76.985
R876 VSS.n281 VSS.n239 76.985
R877 VSS.n282 VSS.n241 76.985
R878 VSS.n284 VSS.n244 76.985
R879 VSS.n285 VSS.n246 76.985
R880 VSS.n287 VSS.n249 76.985
R881 VSS.n288 VSS.n251 76.985
R882 VSS.n290 VSS.n254 76.985
R883 VSS.n291 VSS.n256 76.985
R884 VSS.n293 VSS.n260 76.985
R885 VSS.n461 VSS.n261 76.985
R886 VSS.t17 VSS.n28 72.0005
R887 VSS.t12 VSS.n18 72.0005
R888 VSS.t1 VSS.n83 72.0005
R889 VSS.t2 VSS.n73 72.0005
R890 VSS.n460 VSS.n197 34.6462
R891 VSS.n876 VSS.n98 34.6462
R892 VSS.n618 VSS.n91 33.1205
R893 VSS.n735 VSS.n732 33.1205
R894 VSS.n457 VSS.n195 33.1205
R895 VSS.n343 VSS.n15 33.1205
R896 VSS.n530 VSS.n201 33.1205
R897 VSS.n874 VSS.n146 33.1205
R898 VSS.n885 VSS.n884 33.1205
R899 VSS.n911 VSS.n37 33.1205
R900 VSS.n32 VSS.n27 27.1064
R901 VSS.n32 VSS.n29 27.1064
R902 VSS.n22 VSS.n19 27.1064
R903 VSS.n22 VSS.n17 27.1064
R904 VSS.n87 VSS.n82 27.1064
R905 VSS.n87 VSS.n84 27.1064
R906 VSS.n77 VSS.n74 27.1064
R907 VSS.n77 VSS.n72 27.1064
R908 VSS.n35 VSS.n34 25.7818
R909 VSS.n25 VSS.n24 25.7818
R910 VSS.n90 VSS.n89 25.7818
R911 VSS.n80 VSS.n79 25.7818
R912 VSS.n537 VSS.n197 24.9454
R913 VSS.n547 VSS.n191 24.9454
R914 VSS.n561 VSS.n178 24.9454
R915 VSS.n571 VSS.n172 24.9454
R916 VSS.n743 VSS.n98 24.9454
R917 VSS.n902 VSS.n51 24.9139
R918 VSS.n895 VSS.n61 24.9139
R919 VSS.n902 VSS.n50 24.9139
R920 VSS.n895 VSS.n60 24.9139
R921 VSS.n162 VSS.t20 23.906
R922 VSS.n537 VSS.t11 23.5596
R923 VSS.n552 VSS.t22 22.5202
R924 VSS.t9 VSS.n178 20.7879
R925 VSS.n574 VSS.t3 20.7879
R926 VSS.n577 VSS.t21 19.7485
R927 VSS.n739 VSS.t19 17.6698
R928 VSS.t7 VSS.n172 15.2446
R929 VSS.n571 VSS.t5 15.2446
R930 VSS.t0 VSS.t18 12.1265
R931 VSS.n618 VSS.n617 11.5205
R932 VSS.n622 VSS.n617 11.5205
R933 VSS.n625 VSS.n622 11.5205
R934 VSS.n628 VSS.n625 11.5205
R935 VSS.n628 VSS.n614 11.5205
R936 VSS.n632 VSS.n614 11.5205
R937 VSS.n635 VSS.n632 11.5205
R938 VSS.n638 VSS.n635 11.5205
R939 VSS.n638 VSS.n612 11.5205
R940 VSS.n642 VSS.n612 11.5205
R941 VSS.n645 VSS.n642 11.5205
R942 VSS.n648 VSS.n645 11.5205
R943 VSS.n648 VSS.n610 11.5205
R944 VSS.n652 VSS.n610 11.5205
R945 VSS.n655 VSS.n652 11.5205
R946 VSS.n658 VSS.n655 11.5205
R947 VSS.n658 VSS.n608 11.5205
R948 VSS.n662 VSS.n608 11.5205
R949 VSS.n665 VSS.n662 11.5205
R950 VSS.n668 VSS.n665 11.5205
R951 VSS.n668 VSS.n606 11.5205
R952 VSS.n672 VSS.n606 11.5205
R953 VSS.n675 VSS.n672 11.5205
R954 VSS.n678 VSS.n675 11.5205
R955 VSS.n678 VSS.n604 11.5205
R956 VSS.n682 VSS.n604 11.5205
R957 VSS.n685 VSS.n682 11.5205
R958 VSS.n688 VSS.n685 11.5205
R959 VSS.n688 VSS.n602 11.5205
R960 VSS.n692 VSS.n602 11.5205
R961 VSS.n695 VSS.n692 11.5205
R962 VSS.n698 VSS.n695 11.5205
R963 VSS.n698 VSS.n600 11.5205
R964 VSS.n702 VSS.n600 11.5205
R965 VSS.n705 VSS.n702 11.5205
R966 VSS.n708 VSS.n705 11.5205
R967 VSS.n708 VSS.n598 11.5205
R968 VSS.n712 VSS.n598 11.5205
R969 VSS.n715 VSS.n712 11.5205
R970 VSS.n718 VSS.n715 11.5205
R971 VSS.n718 VSS.n596 11.5205
R972 VSS.n722 VSS.n596 11.5205
R973 VSS.n725 VSS.n722 11.5205
R974 VSS.n728 VSS.n725 11.5205
R975 VSS.n728 VSS.n594 11.5205
R976 VSS.n732 VSS.n594 11.5205
R977 VSS.n539 VSS.n195 11.5205
R978 VSS.n539 VSS.n193 11.5205
R979 VSS.n545 VSS.n193 11.5205
R980 VSS.n545 VSS.n544 11.5205
R981 VSS.n544 VSS.n176 11.5205
R982 VSS.n563 VSS.n176 11.5205
R983 VSS.n563 VSS.n174 11.5205
R984 VSS.n569 VSS.n174 11.5205
R985 VSS.n569 VSS.n568 11.5205
R986 VSS.n568 VSS.n158 11.5205
R987 VSS.n588 VSS.n158 11.5205
R988 VSS.n588 VSS.n156 11.5205
R989 VSS.n737 VSS.n156 11.5205
R990 VSS.n737 VSS.n736 11.5205
R991 VSS.n736 VSS.n735 11.5205
R992 VSS.n343 VSS.n340 11.5205
R993 VSS.n349 VSS.n340 11.5205
R994 VSS.n350 VSS.n349 11.5205
R995 VSS.n353 VSS.n350 11.5205
R996 VSS.n353 VSS.n338 11.5205
R997 VSS.n359 VSS.n338 11.5205
R998 VSS.n360 VSS.n359 11.5205
R999 VSS.n363 VSS.n360 11.5205
R1000 VSS.n363 VSS.n336 11.5205
R1001 VSS.n369 VSS.n336 11.5205
R1002 VSS.n370 VSS.n369 11.5205
R1003 VSS.n373 VSS.n370 11.5205
R1004 VSS.n373 VSS.n334 11.5205
R1005 VSS.n379 VSS.n334 11.5205
R1006 VSS.n380 VSS.n379 11.5205
R1007 VSS.n383 VSS.n380 11.5205
R1008 VSS.n383 VSS.n332 11.5205
R1009 VSS.n389 VSS.n332 11.5205
R1010 VSS.n390 VSS.n389 11.5205
R1011 VSS.n393 VSS.n390 11.5205
R1012 VSS.n393 VSS.n330 11.5205
R1013 VSS.n399 VSS.n330 11.5205
R1014 VSS.n400 VSS.n399 11.5205
R1015 VSS.n403 VSS.n400 11.5205
R1016 VSS.n403 VSS.n328 11.5205
R1017 VSS.n409 VSS.n328 11.5205
R1018 VSS.n410 VSS.n409 11.5205
R1019 VSS.n413 VSS.n410 11.5205
R1020 VSS.n413 VSS.n326 11.5205
R1021 VSS.n419 VSS.n326 11.5205
R1022 VSS.n420 VSS.n419 11.5205
R1023 VSS.n423 VSS.n420 11.5205
R1024 VSS.n423 VSS.n324 11.5205
R1025 VSS.n429 VSS.n324 11.5205
R1026 VSS.n430 VSS.n429 11.5205
R1027 VSS.n433 VSS.n430 11.5205
R1028 VSS.n433 VSS.n322 11.5205
R1029 VSS.n439 VSS.n322 11.5205
R1030 VSS.n440 VSS.n439 11.5205
R1031 VSS.n443 VSS.n440 11.5205
R1032 VSS.n443 VSS.n320 11.5205
R1033 VSS.n449 VSS.n320 11.5205
R1034 VSS.n450 VSS.n449 11.5205
R1035 VSS.n453 VSS.n450 11.5205
R1036 VSS.n453 VSS.n318 11.5205
R1037 VSS.n457 VSS.n318 11.5205
R1038 VSS.n41 VSS.n15 11.5205
R1039 VSS.n42 VSS.n41 11.5205
R1040 VSS.n43 VSS.n42 11.5205
R1041 VSS.n550 VSS.n43 11.5205
R1042 VSS.n550 VSS.n49 11.5205
R1043 VSS.n52 VSS.n49 11.5205
R1044 VSS.n53 VSS.n52 11.5205
R1045 VSS.n171 VSS.n53 11.5205
R1046 VSS.n171 VSS.n59 11.5205
R1047 VSS.n62 VSS.n59 11.5205
R1048 VSS.n63 VSS.n62 11.5205
R1049 VSS.n153 VSS.n63 11.5205
R1050 VSS.n153 VSS.n69 11.5205
R1051 VSS.n70 VSS.n69 11.5205
R1052 VSS.n91 VSS.n70 11.5205
R1053 VSS.n535 VSS.n201 11.5205
R1054 VSS.n535 VSS.n202 11.5205
R1055 VSS.n202 VSS.n186 11.5205
R1056 VSS.n554 VSS.n186 11.5205
R1057 VSS.n554 VSS.n183 11.5205
R1058 VSS.n559 VSS.n183 11.5205
R1059 VSS.n559 VSS.n184 11.5205
R1060 VSS.n184 VSS.n167 11.5205
R1061 VSS.n579 VSS.n167 11.5205
R1062 VSS.n579 VSS.n164 11.5205
R1063 VSS.n584 VSS.n164 11.5205
R1064 VSS.n584 VSS.n165 11.5205
R1065 VSS.n165 VSS.n149 11.5205
R1066 VSS.n745 VSS.n149 11.5205
R1067 VSS.n745 VSS.n146 11.5205
R1068 VSS.n874 VSS.n147 11.5205
R1069 VSS.n870 VSS.n147 11.5205
R1070 VSS.n870 VSS.n869 11.5205
R1071 VSS.n869 VSS.n868 11.5205
R1072 VSS.n868 VSS.n753 11.5205
R1073 VSS.n864 VSS.n753 11.5205
R1074 VSS.n864 VSS.n863 11.5205
R1075 VSS.n863 VSS.n862 11.5205
R1076 VSS.n862 VSS.n759 11.5205
R1077 VSS.n858 VSS.n759 11.5205
R1078 VSS.n858 VSS.n857 11.5205
R1079 VSS.n857 VSS.n856 11.5205
R1080 VSS.n856 VSS.n765 11.5205
R1081 VSS.n852 VSS.n765 11.5205
R1082 VSS.n852 VSS.n851 11.5205
R1083 VSS.n851 VSS.n850 11.5205
R1084 VSS.n850 VSS.n771 11.5205
R1085 VSS.n846 VSS.n771 11.5205
R1086 VSS.n846 VSS.n845 11.5205
R1087 VSS.n845 VSS.n844 11.5205
R1088 VSS.n844 VSS.n777 11.5205
R1089 VSS.n840 VSS.n777 11.5205
R1090 VSS.n840 VSS.n839 11.5205
R1091 VSS.n839 VSS.n838 11.5205
R1092 VSS.n838 VSS.n783 11.5205
R1093 VSS.n834 VSS.n783 11.5205
R1094 VSS.n834 VSS.n833 11.5205
R1095 VSS.n833 VSS.n832 11.5205
R1096 VSS.n832 VSS.n789 11.5205
R1097 VSS.n828 VSS.n789 11.5205
R1098 VSS.n828 VSS.n827 11.5205
R1099 VSS.n827 VSS.n826 11.5205
R1100 VSS.n826 VSS.n795 11.5205
R1101 VSS.n822 VSS.n795 11.5205
R1102 VSS.n822 VSS.n821 11.5205
R1103 VSS.n821 VSS.n820 11.5205
R1104 VSS.n820 VSS.n801 11.5205
R1105 VSS.n816 VSS.n801 11.5205
R1106 VSS.n816 VSS.n815 11.5205
R1107 VSS.n815 VSS.n814 11.5205
R1108 VSS.n814 VSS.n807 11.5205
R1109 VSS.n810 VSS.n807 11.5205
R1110 VSS.n810 VSS.n96 11.5205
R1111 VSS.n880 VSS.n96 11.5205
R1112 VSS.n880 VSS.n93 11.5205
R1113 VSS.n884 VSS.n93 11.5205
R1114 VSS.n911 VSS.n910 11.5205
R1115 VSS.n910 VSS.n40 11.5205
R1116 VSS.n906 VSS.n40 11.5205
R1117 VSS.n906 VSS.n905 11.5205
R1118 VSS.n905 VSS.n904 11.5205
R1119 VSS.n904 VSS.n48 11.5205
R1120 VSS.n899 VSS.n48 11.5205
R1121 VSS.n899 VSS.n898 11.5205
R1122 VSS.n898 VSS.n897 11.5205
R1123 VSS.n897 VSS.n58 11.5205
R1124 VSS.n892 VSS.n58 11.5205
R1125 VSS.n892 VSS.n891 11.5205
R1126 VSS.n891 VSS.n890 11.5205
R1127 VSS.n890 VSS.n68 11.5205
R1128 VSS.n885 VSS.n68 11.5205
R1129 VSS.n530 VSS.n529 11.5205
R1130 VSS.n529 VSS.n528 11.5205
R1131 VSS.n528 VSS.n207 11.5205
R1132 VSS.n524 VSS.n207 11.5205
R1133 VSS.n524 VSS.n523 11.5205
R1134 VSS.n523 VSS.n522 11.5205
R1135 VSS.n522 VSS.n212 11.5205
R1136 VSS.n518 VSS.n212 11.5205
R1137 VSS.n518 VSS.n517 11.5205
R1138 VSS.n517 VSS.n516 11.5205
R1139 VSS.n516 VSS.n217 11.5205
R1140 VSS.n512 VSS.n217 11.5205
R1141 VSS.n512 VSS.n511 11.5205
R1142 VSS.n511 VSS.n510 11.5205
R1143 VSS.n510 VSS.n222 11.5205
R1144 VSS.n506 VSS.n222 11.5205
R1145 VSS.n506 VSS.n505 11.5205
R1146 VSS.n505 VSS.n504 11.5205
R1147 VSS.n504 VSS.n227 11.5205
R1148 VSS.n500 VSS.n227 11.5205
R1149 VSS.n500 VSS.n499 11.5205
R1150 VSS.n499 VSS.n498 11.5205
R1151 VSS.n498 VSS.n232 11.5205
R1152 VSS.n494 VSS.n232 11.5205
R1153 VSS.n494 VSS.n493 11.5205
R1154 VSS.n493 VSS.n492 11.5205
R1155 VSS.n492 VSS.n237 11.5205
R1156 VSS.n488 VSS.n237 11.5205
R1157 VSS.n488 VSS.n487 11.5205
R1158 VSS.n487 VSS.n486 11.5205
R1159 VSS.n486 VSS.n242 11.5205
R1160 VSS.n482 VSS.n242 11.5205
R1161 VSS.n482 VSS.n481 11.5205
R1162 VSS.n481 VSS.n480 11.5205
R1163 VSS.n480 VSS.n247 11.5205
R1164 VSS.n476 VSS.n247 11.5205
R1165 VSS.n476 VSS.n475 11.5205
R1166 VSS.n475 VSS.n474 11.5205
R1167 VSS.n474 VSS.n252 11.5205
R1168 VSS.n470 VSS.n252 11.5205
R1169 VSS.n470 VSS.n469 11.5205
R1170 VSS.n469 VSS.n468 11.5205
R1171 VSS.n468 VSS.n257 11.5205
R1172 VSS.n464 VSS.n257 11.5205
R1173 VSS.n464 VSS.n463 11.5205
R1174 VSS.n463 VSS.n37 11.5205
R1175 VSS.n743 VSS.t18 11.4336
R1176 VSS.n561 VSS.t7 9.70129
R1177 VSS.n577 VSS.t5 9.70129
R1178 VSS.n22 VSS.n21 9.3005
R1179 VSS.n17 VSS.n16 9.3005
R1180 VSS.n27 VSS.n26 9.3005
R1181 VSS.n32 VSS.n31 9.3005
R1182 VSS.n77 VSS.n76 9.3005
R1183 VSS.n72 VSS.n71 9.3005
R1184 VSS.n82 VSS.n81 9.3005
R1185 VSS.n87 VSS.n86 9.3005
R1186 VSS.n540 VSS.n539 9.3005
R1187 VSS.n541 VSS.n193 9.3005
R1188 VSS.n545 VSS.n542 9.3005
R1189 VSS.n544 VSS.n543 9.3005
R1190 VSS.n176 VSS.n175 9.3005
R1191 VSS.n564 VSS.n563 9.3005
R1192 VSS.n565 VSS.n174 9.3005
R1193 VSS.n569 VSS.n566 9.3005
R1194 VSS.n568 VSS.n567 9.3005
R1195 VSS.n158 VSS.n157 9.3005
R1196 VSS.n589 VSS.n588 9.3005
R1197 VSS.n590 VSS.n156 9.3005
R1198 VSS.n737 VSS.n591 9.3005
R1199 VSS.n736 VSS.n592 9.3005
R1200 VSS.n735 VSS.n593 9.3005
R1201 VSS.n195 VSS.n194 9.3005
R1202 VSS.n344 VSS.n343 9.3005
R1203 VSS.n345 VSS.n340 9.3005
R1204 VSS.n349 VSS.n346 9.3005
R1205 VSS.n350 VSS.n339 9.3005
R1206 VSS.n354 VSS.n353 9.3005
R1207 VSS.n355 VSS.n338 9.3005
R1208 VSS.n359 VSS.n356 9.3005
R1209 VSS.n360 VSS.n337 9.3005
R1210 VSS.n364 VSS.n363 9.3005
R1211 VSS.n365 VSS.n336 9.3005
R1212 VSS.n369 VSS.n366 9.3005
R1213 VSS.n370 VSS.n335 9.3005
R1214 VSS.n374 VSS.n373 9.3005
R1215 VSS.n375 VSS.n334 9.3005
R1216 VSS.n379 VSS.n376 9.3005
R1217 VSS.n380 VSS.n333 9.3005
R1218 VSS.n384 VSS.n383 9.3005
R1219 VSS.n385 VSS.n332 9.3005
R1220 VSS.n389 VSS.n386 9.3005
R1221 VSS.n390 VSS.n331 9.3005
R1222 VSS.n394 VSS.n393 9.3005
R1223 VSS.n395 VSS.n330 9.3005
R1224 VSS.n399 VSS.n396 9.3005
R1225 VSS.n400 VSS.n329 9.3005
R1226 VSS.n404 VSS.n403 9.3005
R1227 VSS.n405 VSS.n328 9.3005
R1228 VSS.n409 VSS.n406 9.3005
R1229 VSS.n410 VSS.n327 9.3005
R1230 VSS.n414 VSS.n413 9.3005
R1231 VSS.n415 VSS.n326 9.3005
R1232 VSS.n419 VSS.n416 9.3005
R1233 VSS.n420 VSS.n325 9.3005
R1234 VSS.n424 VSS.n423 9.3005
R1235 VSS.n425 VSS.n324 9.3005
R1236 VSS.n429 VSS.n426 9.3005
R1237 VSS.n430 VSS.n323 9.3005
R1238 VSS.n434 VSS.n433 9.3005
R1239 VSS.n435 VSS.n322 9.3005
R1240 VSS.n439 VSS.n436 9.3005
R1241 VSS.n440 VSS.n321 9.3005
R1242 VSS.n444 VSS.n443 9.3005
R1243 VSS.n445 VSS.n320 9.3005
R1244 VSS.n449 VSS.n446 9.3005
R1245 VSS.n450 VSS.n319 9.3005
R1246 VSS.n454 VSS.n453 9.3005
R1247 VSS.n455 VSS.n318 9.3005
R1248 VSS.n457 VSS.n456 9.3005
R1249 VSS.n531 VSS.n530 9.3005
R1250 VSS.n529 VSS.n203 9.3005
R1251 VSS.n528 VSS.n527 9.3005
R1252 VSS.n526 VSS.n207 9.3005
R1253 VSS.n525 VSS.n524 9.3005
R1254 VSS.n523 VSS.n208 9.3005
R1255 VSS.n522 VSS.n521 9.3005
R1256 VSS.n520 VSS.n212 9.3005
R1257 VSS.n519 VSS.n518 9.3005
R1258 VSS.n517 VSS.n213 9.3005
R1259 VSS.n516 VSS.n515 9.3005
R1260 VSS.n514 VSS.n217 9.3005
R1261 VSS.n513 VSS.n512 9.3005
R1262 VSS.n511 VSS.n218 9.3005
R1263 VSS.n510 VSS.n509 9.3005
R1264 VSS.n508 VSS.n222 9.3005
R1265 VSS.n507 VSS.n506 9.3005
R1266 VSS.n505 VSS.n223 9.3005
R1267 VSS.n504 VSS.n503 9.3005
R1268 VSS.n502 VSS.n227 9.3005
R1269 VSS.n501 VSS.n500 9.3005
R1270 VSS.n499 VSS.n228 9.3005
R1271 VSS.n498 VSS.n497 9.3005
R1272 VSS.n496 VSS.n232 9.3005
R1273 VSS.n495 VSS.n494 9.3005
R1274 VSS.n493 VSS.n233 9.3005
R1275 VSS.n492 VSS.n491 9.3005
R1276 VSS.n490 VSS.n237 9.3005
R1277 VSS.n489 VSS.n488 9.3005
R1278 VSS.n487 VSS.n238 9.3005
R1279 VSS.n486 VSS.n485 9.3005
R1280 VSS.n484 VSS.n242 9.3005
R1281 VSS.n483 VSS.n482 9.3005
R1282 VSS.n481 VSS.n243 9.3005
R1283 VSS.n480 VSS.n479 9.3005
R1284 VSS.n478 VSS.n247 9.3005
R1285 VSS.n477 VSS.n476 9.3005
R1286 VSS.n475 VSS.n248 9.3005
R1287 VSS.n474 VSS.n473 9.3005
R1288 VSS.n472 VSS.n252 9.3005
R1289 VSS.n471 VSS.n470 9.3005
R1290 VSS.n469 VSS.n253 9.3005
R1291 VSS.n468 VSS.n467 9.3005
R1292 VSS.n466 VSS.n257 9.3005
R1293 VSS.n465 VSS.n464 9.3005
R1294 VSS.n463 VSS.n259 9.3005
R1295 VSS.n258 VSS.n37 9.3005
R1296 VSS.n532 VSS.n201 9.3005
R1297 VSS.n535 VSS.n534 9.3005
R1298 VSS.n533 VSS.n202 9.3005
R1299 VSS.n186 VSS.n185 9.3005
R1300 VSS.n555 VSS.n554 9.3005
R1301 VSS.n556 VSS.n183 9.3005
R1302 VSS.n559 VSS.n558 9.3005
R1303 VSS.n557 VSS.n184 9.3005
R1304 VSS.n167 VSS.n166 9.3005
R1305 VSS.n580 VSS.n579 9.3005
R1306 VSS.n581 VSS.n164 9.3005
R1307 VSS.n584 VSS.n583 9.3005
R1308 VSS.n582 VSS.n165 9.3005
R1309 VSS.n149 VSS.n148 9.3005
R1310 VSS.n746 VSS.n745 9.3005
R1311 VSS.n747 VSS.n146 9.3005
R1312 VSS.n884 VSS.n883 9.3005
R1313 VSS.n882 VSS.n93 9.3005
R1314 VSS.n881 VSS.n880 9.3005
R1315 VSS.n96 VSS.n95 9.3005
R1316 VSS.n811 VSS.n810 9.3005
R1317 VSS.n812 VSS.n807 9.3005
R1318 VSS.n814 VSS.n813 9.3005
R1319 VSS.n815 VSS.n802 9.3005
R1320 VSS.n817 VSS.n816 9.3005
R1321 VSS.n818 VSS.n801 9.3005
R1322 VSS.n820 VSS.n819 9.3005
R1323 VSS.n821 VSS.n796 9.3005
R1324 VSS.n823 VSS.n822 9.3005
R1325 VSS.n824 VSS.n795 9.3005
R1326 VSS.n826 VSS.n825 9.3005
R1327 VSS.n827 VSS.n790 9.3005
R1328 VSS.n829 VSS.n828 9.3005
R1329 VSS.n830 VSS.n789 9.3005
R1330 VSS.n832 VSS.n831 9.3005
R1331 VSS.n833 VSS.n784 9.3005
R1332 VSS.n835 VSS.n834 9.3005
R1333 VSS.n836 VSS.n783 9.3005
R1334 VSS.n838 VSS.n837 9.3005
R1335 VSS.n839 VSS.n778 9.3005
R1336 VSS.n841 VSS.n840 9.3005
R1337 VSS.n842 VSS.n777 9.3005
R1338 VSS.n844 VSS.n843 9.3005
R1339 VSS.n845 VSS.n772 9.3005
R1340 VSS.n847 VSS.n846 9.3005
R1341 VSS.n848 VSS.n771 9.3005
R1342 VSS.n850 VSS.n849 9.3005
R1343 VSS.n851 VSS.n766 9.3005
R1344 VSS.n853 VSS.n852 9.3005
R1345 VSS.n854 VSS.n765 9.3005
R1346 VSS.n856 VSS.n855 9.3005
R1347 VSS.n857 VSS.n760 9.3005
R1348 VSS.n859 VSS.n858 9.3005
R1349 VSS.n860 VSS.n759 9.3005
R1350 VSS.n862 VSS.n861 9.3005
R1351 VSS.n863 VSS.n754 9.3005
R1352 VSS.n865 VSS.n864 9.3005
R1353 VSS.n866 VSS.n753 9.3005
R1354 VSS.n868 VSS.n867 9.3005
R1355 VSS.n869 VSS.n748 9.3005
R1356 VSS.n871 VSS.n870 9.3005
R1357 VSS.n872 VSS.n147 9.3005
R1358 VSS.n874 VSS.n873 9.3005
R1359 VSS.n732 VSS.n731 9.3005
R1360 VSS.n730 VSS.n594 9.3005
R1361 VSS.n729 VSS.n728 9.3005
R1362 VSS.n725 VSS.n595 9.3005
R1363 VSS.n722 VSS.n721 9.3005
R1364 VSS.n720 VSS.n596 9.3005
R1365 VSS.n719 VSS.n718 9.3005
R1366 VSS.n715 VSS.n597 9.3005
R1367 VSS.n712 VSS.n711 9.3005
R1368 VSS.n710 VSS.n598 9.3005
R1369 VSS.n709 VSS.n708 9.3005
R1370 VSS.n705 VSS.n599 9.3005
R1371 VSS.n702 VSS.n701 9.3005
R1372 VSS.n700 VSS.n600 9.3005
R1373 VSS.n699 VSS.n698 9.3005
R1374 VSS.n695 VSS.n601 9.3005
R1375 VSS.n692 VSS.n691 9.3005
R1376 VSS.n690 VSS.n602 9.3005
R1377 VSS.n689 VSS.n688 9.3005
R1378 VSS.n685 VSS.n603 9.3005
R1379 VSS.n682 VSS.n681 9.3005
R1380 VSS.n680 VSS.n604 9.3005
R1381 VSS.n679 VSS.n678 9.3005
R1382 VSS.n675 VSS.n605 9.3005
R1383 VSS.n672 VSS.n671 9.3005
R1384 VSS.n670 VSS.n606 9.3005
R1385 VSS.n669 VSS.n668 9.3005
R1386 VSS.n665 VSS.n607 9.3005
R1387 VSS.n662 VSS.n661 9.3005
R1388 VSS.n660 VSS.n608 9.3005
R1389 VSS.n659 VSS.n658 9.3005
R1390 VSS.n655 VSS.n609 9.3005
R1391 VSS.n652 VSS.n651 9.3005
R1392 VSS.n650 VSS.n610 9.3005
R1393 VSS.n649 VSS.n648 9.3005
R1394 VSS.n645 VSS.n611 9.3005
R1395 VSS.n642 VSS.n641 9.3005
R1396 VSS.n640 VSS.n612 9.3005
R1397 VSS.n639 VSS.n638 9.3005
R1398 VSS.n635 VSS.n613 9.3005
R1399 VSS.n632 VSS.n631 9.3005
R1400 VSS.n630 VSS.n614 9.3005
R1401 VSS.n629 VSS.n628 9.3005
R1402 VSS.n625 VSS.n615 9.3005
R1403 VSS.n622 VSS.n621 9.3005
R1404 VSS.n620 VSS.n617 9.3005
R1405 VSS.n619 VSS.n618 9.3005
R1406 VSS.n912 VSS.n15 9.3005
R1407 VSS.n909 VSS.n41 9.3005
R1408 VSS.n908 VSS.n42 9.3005
R1409 VSS.n907 VSS.n43 9.3005
R1410 VSS.n550 VSS.n44 9.3005
R1411 VSS.n903 VSS.n49 9.3005
R1412 VSS.n901 VSS.n52 9.3005
R1413 VSS.n900 VSS.n53 9.3005
R1414 VSS.n171 VSS.n54 9.3005
R1415 VSS.n896 VSS.n59 9.3005
R1416 VSS.n894 VSS.n62 9.3005
R1417 VSS.n893 VSS.n63 9.3005
R1418 VSS.n153 VSS.n64 9.3005
R1419 VSS.n889 VSS.n69 9.3005
R1420 VSS.n888 VSS.n70 9.3005
R1421 VSS.n886 VSS.n91 9.3005
R1422 VSS.n886 VSS.n885 9.3005
R1423 VSS.n888 VSS.n68 9.3005
R1424 VSS.n890 VSS.n889 9.3005
R1425 VSS.n891 VSS.n64 9.3005
R1426 VSS.n893 VSS.n892 9.3005
R1427 VSS.n894 VSS.n58 9.3005
R1428 VSS.n897 VSS.n896 9.3005
R1429 VSS.n898 VSS.n54 9.3005
R1430 VSS.n900 VSS.n899 9.3005
R1431 VSS.n901 VSS.n48 9.3005
R1432 VSS.n904 VSS.n903 9.3005
R1433 VSS.n905 VSS.n44 9.3005
R1434 VSS.n907 VSS.n906 9.3005
R1435 VSS.n908 VSS.n40 9.3005
R1436 VSS.n910 VSS.n909 9.3005
R1437 VSS.n912 VSS.n911 9.3005
R1438 VSS.n34 VSS.n27 9.2683
R1439 VSS.n24 VSS.n17 9.2683
R1440 VSS.n89 VSS.n82 9.2683
R1441 VSS.n79 VSS.n72 9.2683
R1442 VSS.n162 VSS.t19 7.27609
R1443 VSS.n30 VSS.n29 6.31057
R1444 VSS.n85 VSS.n84 6.31057
R1445 VSS.n20 VSS.n19 6.31055
R1446 VSS.n75 VSS.n74 6.31055
R1447 VSS.n51 VSS.t16 6.0005
R1448 VSS.n51 VSS.t15 6.0005
R1449 VSS.n50 VSS.t10 6.0005
R1450 VSS.n50 VSS.t8 6.0005
R1451 VSS.n61 VSS.t14 6.0005
R1452 VSS.n61 VSS.t13 6.0005
R1453 VSS.n60 VSS.t6 6.0005
R1454 VSS.n60 VSS.t4 6.0005
R1455 VSS.n574 VSS.t21 5.19735
R1456 VSS.n552 VSS.t9 4.15798
R1457 VSS.n586 VSS.t3 4.15798
R1458 VSS.n937 VSS.n936 3.48626
R1459 VSS.n915 VSS.n11 3.4105
R1460 VSS.n917 VSS.n916 3.4105
R1461 VSS.n9 VSS.n8 3.4105
R1462 VSS.n922 VSS.n921 3.4105
R1463 VSS.n923 VSS.n7 3.4105
R1464 VSS.n925 VSS.n924 3.4105
R1465 VSS.n5 VSS.n4 3.4105
R1466 VSS.n931 VSS.n930 3.4105
R1467 VSS.n932 VSS.n3 3.4105
R1468 VSS.n934 VSS.n933 3.4105
R1469 VSS.n11 VSS.n10 3.4105
R1470 VSS.n918 VSS.n917 3.4105
R1471 VSS.n919 VSS.n9 3.4105
R1472 VSS.n921 VSS.n920 3.4105
R1473 VSS.n7 VSS.n6 3.4105
R1474 VSS.n926 VSS.n925 3.4105
R1475 VSS.n927 VSS.n5 3.4105
R1476 VSS.n930 VSS.n929 3.4105
R1477 VSS.n928 VSS.n3 3.4105
R1478 VSS.n934 VSS.n2 3.4105
R1479 VSS.n936 VSS.n935 3.4105
R1480 VSS.n938 VSS.n937 2.85893
R1481 VSS.n547 VSS.t22 2.4257
R1482 VSS.n933 VSS.n1 1.79814
R1483 VSS.t11 VSS.n191 1.38633
R1484 VSS.n739 VSS.t0 1.38633
R1485 VSS.n21 VSS.n20 1.16652
R1486 VSS.n76 VSS.n75 1.16652
R1487 VSS.n31 VSS.n30 1.1665
R1488 VSS.n86 VSS.n85 1.1665
R1489 VSS.n586 VSS.t20 1.03987
R1490 VSS.n914 VSS.n12 0.497687
R1491 VSS.n14 VSS.n12 0.49671
R1492 VSS.n456 VSS.n194 0.323938
R1493 VSS.n731 VSS.n593 0.323938
R1494 VSS.n532 VSS.n531 0.323938
R1495 VSS.n873 VSS.n747 0.323938
R1496 VSS.n36 VSS.n25 0.296333
R1497 VSS.n36 VSS.n35 0.296333
R1498 VSS.n887 VSS.n80 0.296333
R1499 VSS.n887 VSS.n90 0.296333
R1500 VSS.n938 VSS 0.270841
R1501 VSS.n344 VSS.n13 0.167687
R1502 VSS.n258 VSS.n13 0.167687
R1503 VSS.n883 VSS.n0 0.167687
R1504 VSS.n619 VSS.n0 0.167687
R1505 VSS.n21 VSS.n16 0.1505
R1506 VSS.n25 VSS.n16 0.1505
R1507 VSS.n35 VSS.n26 0.1505
R1508 VSS.n31 VSS.n26 0.1505
R1509 VSS.n76 VSS.n71 0.1505
R1510 VSS.n80 VSS.n71 0.1505
R1511 VSS.n90 VSS.n81 0.1505
R1512 VSS.n86 VSS.n81 0.1505
R1513 VSS.n939 VSS.n938 0.140339
R1514 VSS.n345 VSS.n344 0.113
R1515 VSS.n346 VSS.n345 0.113
R1516 VSS.n346 VSS.n339 0.113
R1517 VSS.n354 VSS.n339 0.113
R1518 VSS.n355 VSS.n354 0.113
R1519 VSS.n356 VSS.n355 0.113
R1520 VSS.n356 VSS.n337 0.113
R1521 VSS.n364 VSS.n337 0.113
R1522 VSS.n365 VSS.n364 0.113
R1523 VSS.n366 VSS.n365 0.113
R1524 VSS.n366 VSS.n335 0.113
R1525 VSS.n374 VSS.n335 0.113
R1526 VSS.n375 VSS.n374 0.113
R1527 VSS.n376 VSS.n375 0.113
R1528 VSS.n376 VSS.n333 0.113
R1529 VSS.n384 VSS.n333 0.113
R1530 VSS.n385 VSS.n384 0.113
R1531 VSS.n386 VSS.n385 0.113
R1532 VSS.n386 VSS.n331 0.113
R1533 VSS.n394 VSS.n331 0.113
R1534 VSS.n395 VSS.n394 0.113
R1535 VSS.n396 VSS.n395 0.113
R1536 VSS.n396 VSS.n329 0.113
R1537 VSS.n404 VSS.n329 0.113
R1538 VSS.n405 VSS.n404 0.113
R1539 VSS.n406 VSS.n405 0.113
R1540 VSS.n406 VSS.n327 0.113
R1541 VSS.n414 VSS.n327 0.113
R1542 VSS.n415 VSS.n414 0.113
R1543 VSS.n416 VSS.n415 0.113
R1544 VSS.n416 VSS.n325 0.113
R1545 VSS.n424 VSS.n325 0.113
R1546 VSS.n425 VSS.n424 0.113
R1547 VSS.n426 VSS.n425 0.113
R1548 VSS.n426 VSS.n323 0.113
R1549 VSS.n434 VSS.n323 0.113
R1550 VSS.n435 VSS.n434 0.113
R1551 VSS.n436 VSS.n435 0.113
R1552 VSS.n436 VSS.n321 0.113
R1553 VSS.n444 VSS.n321 0.113
R1554 VSS.n445 VSS.n444 0.113
R1555 VSS.n446 VSS.n445 0.113
R1556 VSS.n446 VSS.n319 0.113
R1557 VSS.n454 VSS.n319 0.113
R1558 VSS.n455 VSS.n454 0.113
R1559 VSS.n456 VSS.n455 0.113
R1560 VSS.n540 VSS.n194 0.113
R1561 VSS.n541 VSS.n540 0.113
R1562 VSS.n542 VSS.n541 0.113
R1563 VSS.n543 VSS.n542 0.113
R1564 VSS.n543 VSS.n175 0.113
R1565 VSS.n564 VSS.n175 0.113
R1566 VSS.n565 VSS.n564 0.113
R1567 VSS.n566 VSS.n565 0.113
R1568 VSS.n567 VSS.n566 0.113
R1569 VSS.n567 VSS.n157 0.113
R1570 VSS.n589 VSS.n157 0.113
R1571 VSS.n590 VSS.n589 0.113
R1572 VSS.n591 VSS.n590 0.113
R1573 VSS.n592 VSS.n591 0.113
R1574 VSS.n593 VSS.n592 0.113
R1575 VSS.n531 VSS.n203 0.113
R1576 VSS.n527 VSS.n203 0.113
R1577 VSS.n527 VSS.n526 0.113
R1578 VSS.n526 VSS.n525 0.113
R1579 VSS.n525 VSS.n208 0.113
R1580 VSS.n521 VSS.n208 0.113
R1581 VSS.n521 VSS.n520 0.113
R1582 VSS.n520 VSS.n519 0.113
R1583 VSS.n519 VSS.n213 0.113
R1584 VSS.n515 VSS.n213 0.113
R1585 VSS.n515 VSS.n514 0.113
R1586 VSS.n514 VSS.n513 0.113
R1587 VSS.n513 VSS.n218 0.113
R1588 VSS.n509 VSS.n218 0.113
R1589 VSS.n509 VSS.n508 0.113
R1590 VSS.n508 VSS.n507 0.113
R1591 VSS.n507 VSS.n223 0.113
R1592 VSS.n503 VSS.n223 0.113
R1593 VSS.n503 VSS.n502 0.113
R1594 VSS.n502 VSS.n501 0.113
R1595 VSS.n501 VSS.n228 0.113
R1596 VSS.n497 VSS.n228 0.113
R1597 VSS.n497 VSS.n496 0.113
R1598 VSS.n496 VSS.n495 0.113
R1599 VSS.n495 VSS.n233 0.113
R1600 VSS.n491 VSS.n233 0.113
R1601 VSS.n491 VSS.n490 0.113
R1602 VSS.n490 VSS.n489 0.113
R1603 VSS.n489 VSS.n238 0.113
R1604 VSS.n485 VSS.n238 0.113
R1605 VSS.n485 VSS.n484 0.113
R1606 VSS.n484 VSS.n483 0.113
R1607 VSS.n483 VSS.n243 0.113
R1608 VSS.n479 VSS.n243 0.113
R1609 VSS.n479 VSS.n478 0.113
R1610 VSS.n478 VSS.n477 0.113
R1611 VSS.n477 VSS.n248 0.113
R1612 VSS.n473 VSS.n248 0.113
R1613 VSS.n473 VSS.n472 0.113
R1614 VSS.n472 VSS.n471 0.113
R1615 VSS.n471 VSS.n253 0.113
R1616 VSS.n467 VSS.n253 0.113
R1617 VSS.n467 VSS.n466 0.113
R1618 VSS.n466 VSS.n465 0.113
R1619 VSS.n465 VSS.n259 0.113
R1620 VSS.n259 VSS.n258 0.113
R1621 VSS.n534 VSS.n532 0.113
R1622 VSS.n534 VSS.n533 0.113
R1623 VSS.n533 VSS.n185 0.113
R1624 VSS.n555 VSS.n185 0.113
R1625 VSS.n556 VSS.n555 0.113
R1626 VSS.n558 VSS.n556 0.113
R1627 VSS.n558 VSS.n557 0.113
R1628 VSS.n557 VSS.n166 0.113
R1629 VSS.n580 VSS.n166 0.113
R1630 VSS.n581 VSS.n580 0.113
R1631 VSS.n583 VSS.n581 0.113
R1632 VSS.n583 VSS.n582 0.113
R1633 VSS.n582 VSS.n148 0.113
R1634 VSS.n746 VSS.n148 0.113
R1635 VSS.n747 VSS.n746 0.113
R1636 VSS.n873 VSS.n872 0.113
R1637 VSS.n872 VSS.n871 0.113
R1638 VSS.n871 VSS.n748 0.113
R1639 VSS.n867 VSS.n748 0.113
R1640 VSS.n867 VSS.n866 0.113
R1641 VSS.n866 VSS.n865 0.113
R1642 VSS.n865 VSS.n754 0.113
R1643 VSS.n861 VSS.n754 0.113
R1644 VSS.n861 VSS.n860 0.113
R1645 VSS.n860 VSS.n859 0.113
R1646 VSS.n859 VSS.n760 0.113
R1647 VSS.n855 VSS.n760 0.113
R1648 VSS.n855 VSS.n854 0.113
R1649 VSS.n854 VSS.n853 0.113
R1650 VSS.n853 VSS.n766 0.113
R1651 VSS.n849 VSS.n766 0.113
R1652 VSS.n849 VSS.n848 0.113
R1653 VSS.n848 VSS.n847 0.113
R1654 VSS.n847 VSS.n772 0.113
R1655 VSS.n843 VSS.n772 0.113
R1656 VSS.n843 VSS.n842 0.113
R1657 VSS.n842 VSS.n841 0.113
R1658 VSS.n841 VSS.n778 0.113
R1659 VSS.n837 VSS.n778 0.113
R1660 VSS.n837 VSS.n836 0.113
R1661 VSS.n836 VSS.n835 0.113
R1662 VSS.n835 VSS.n784 0.113
R1663 VSS.n831 VSS.n784 0.113
R1664 VSS.n831 VSS.n830 0.113
R1665 VSS.n830 VSS.n829 0.113
R1666 VSS.n829 VSS.n790 0.113
R1667 VSS.n825 VSS.n790 0.113
R1668 VSS.n825 VSS.n824 0.113
R1669 VSS.n824 VSS.n823 0.113
R1670 VSS.n823 VSS.n796 0.113
R1671 VSS.n819 VSS.n796 0.113
R1672 VSS.n819 VSS.n818 0.113
R1673 VSS.n818 VSS.n817 0.113
R1674 VSS.n817 VSS.n802 0.113
R1675 VSS.n813 VSS.n802 0.113
R1676 VSS.n813 VSS.n812 0.113
R1677 VSS.n812 VSS.n811 0.113
R1678 VSS.n811 VSS.n95 0.113
R1679 VSS.n881 VSS.n95 0.113
R1680 VSS.n882 VSS.n881 0.113
R1681 VSS.n883 VSS.n882 0.113
R1682 VSS.n620 VSS.n619 0.113
R1683 VSS.n621 VSS.n620 0.113
R1684 VSS.n621 VSS.n615 0.113
R1685 VSS.n629 VSS.n615 0.113
R1686 VSS.n630 VSS.n629 0.113
R1687 VSS.n631 VSS.n630 0.113
R1688 VSS.n631 VSS.n613 0.113
R1689 VSS.n639 VSS.n613 0.113
R1690 VSS.n640 VSS.n639 0.113
R1691 VSS.n641 VSS.n640 0.113
R1692 VSS.n641 VSS.n611 0.113
R1693 VSS.n649 VSS.n611 0.113
R1694 VSS.n650 VSS.n649 0.113
R1695 VSS.n651 VSS.n650 0.113
R1696 VSS.n651 VSS.n609 0.113
R1697 VSS.n659 VSS.n609 0.113
R1698 VSS.n660 VSS.n659 0.113
R1699 VSS.n661 VSS.n660 0.113
R1700 VSS.n661 VSS.n607 0.113
R1701 VSS.n669 VSS.n607 0.113
R1702 VSS.n670 VSS.n669 0.113
R1703 VSS.n671 VSS.n670 0.113
R1704 VSS.n671 VSS.n605 0.113
R1705 VSS.n679 VSS.n605 0.113
R1706 VSS.n680 VSS.n679 0.113
R1707 VSS.n681 VSS.n680 0.113
R1708 VSS.n681 VSS.n603 0.113
R1709 VSS.n689 VSS.n603 0.113
R1710 VSS.n690 VSS.n689 0.113
R1711 VSS.n691 VSS.n690 0.113
R1712 VSS.n691 VSS.n601 0.113
R1713 VSS.n699 VSS.n601 0.113
R1714 VSS.n700 VSS.n699 0.113
R1715 VSS.n701 VSS.n700 0.113
R1716 VSS.n701 VSS.n599 0.113
R1717 VSS.n709 VSS.n599 0.113
R1718 VSS.n710 VSS.n709 0.113
R1719 VSS.n711 VSS.n710 0.113
R1720 VSS.n711 VSS.n597 0.113
R1721 VSS.n719 VSS.n597 0.113
R1722 VSS.n720 VSS.n719 0.113
R1723 VSS.n721 VSS.n720 0.113
R1724 VSS.n721 VSS.n595 0.113
R1725 VSS.n729 VSS.n595 0.113
R1726 VSS.n730 VSS.n729 0.113
R1727 VSS.n731 VSS.n730 0.113
R1728 VSS.n915 VSS.n914 0.0762576
R1729 VSS.n916 VSS.n915 0.0762576
R1730 VSS.n916 VSS.n8 0.0762576
R1731 VSS.n922 VSS.n8 0.0762576
R1732 VSS.n923 VSS.n922 0.0762576
R1733 VSS.n924 VSS.n923 0.0762576
R1734 VSS.n924 VSS.n4 0.0762576
R1735 VSS.n931 VSS.n4 0.0762576
R1736 VSS.n932 VSS.n931 0.0762576
R1737 VSS.n933 VSS.n932 0.0762576
R1738 VSS.n14 VSS.n10 0.0762576
R1739 VSS.n918 VSS.n10 0.0762576
R1740 VSS.n919 VSS.n918 0.0762576
R1741 VSS.n920 VSS.n919 0.0762576
R1742 VSS.n920 VSS.n6 0.0762576
R1743 VSS.n926 VSS.n6 0.0762576
R1744 VSS.n927 VSS.n926 0.0762576
R1745 VSS.n929 VSS.n927 0.0762576
R1746 VSS.n929 VSS.n928 0.0762576
R1747 VSS.n928 VSS.n2 0.0762576
R1748 VSS.n936 VSS.n2 0.0762576
R1749 VSS.n913 VSS.n14 0.0708125
R1750 VSS.n914 VSS.n913 0.0708125
R1751 VSS.n12 VSS.n11 0.0349407
R1752 VSS.n886 VSS.n0 0.0228214
R1753 VSS.n909 VSS.n908 0.0165714
R1754 VSS.n908 VSS.n907 0.0165714
R1755 VSS.n907 VSS.n44 0.0165714
R1756 VSS.n903 VSS.n44 0.0165714
R1757 VSS.n901 VSS.n900 0.0165714
R1758 VSS.n900 VSS.n54 0.0165714
R1759 VSS.n896 VSS.n54 0.0165714
R1760 VSS.n894 VSS.n893 0.0165714
R1761 VSS.n893 VSS.n64 0.0165714
R1762 VSS.n889 VSS.n64 0.0165714
R1763 VSS.n889 VSS.n888 0.0165714
R1764 VSS.n913 VSS.n13 0.0150089
R1765 VSS.n912 VSS.n36 0.0138929
R1766 VSS.n887 VSS.n886 0.0138929
R1767 VSS VSS.n939 0.0138929
R1768 VSS.n902 VSS.n901 0.0121071
R1769 VSS.n896 VSS.n895 0.0121071
R1770 VSS.n917 VSS.n11 0.0099
R1771 VSS.n917 VSS.n9 0.0099
R1772 VSS.n921 VSS.n9 0.0099
R1773 VSS.n921 VSS.n7 0.0099
R1774 VSS.n925 VSS.n7 0.0099
R1775 VSS.n925 VSS.n5 0.0099
R1776 VSS.n930 VSS.n5 0.0099
R1777 VSS.n930 VSS.n3 0.0099
R1778 VSS.n934 VSS.n3 0.0099
R1779 VSS.n935 VSS.n934 0.0099
R1780 VSS.n939 VSS.n0 0.00942857
R1781 VSS.n913 VSS.n912 0.0083125
R1782 VSS.n937 VSS.n1 0.00574517
R1783 VSS.n935 VSS.n1 0.00564204
R1784 VSS.n903 VSS.n902 0.00496429
R1785 VSS.n895 VSS.n894 0.00496429
R1786 VSS.n909 VSS.n36 0.00317857
R1787 VSS.n888 VSS.n887 0.00317857
C0 outn inn 0
C1 outn inp 0.41676f
C2 nb outp 0.14199f
C3 sn outp 5.63656f
C4 sp outp 0.02033f
C5 VDD inn 0.02635f
C6 outn VDD 7.35285f
C7 inp VDD 0.02635f
C8 sn nb 1.70822f
C9 nb sp 1.66152f
C10 sn sp 2.52049f
C11 outn outp 0.05311f
C12 inn outp 0.41664f
C13 nb outn 0.14213f
C14 nb inn 0.04485f
C15 nb inp 0.04485f
C16 sn outn 0.49599f
C17 sn inn 0.64265f
C18 sn inp 0
C19 outn sp 6.67323f
C20 inp sp 0.64262f
C21 sp inn -0
C22 VDD outp 7.17562f
C23 nb VDD 0.07645f
C24 sn VDD 4.28531f
C25 sp VDD 3.40034f
C26 outp VSS 8.98992f
C27 inn VSS 1.13415f
C28 nb VSS 11.60504f
C29 outn VSS 7.75277f
C30 inp VSS 1.13424f
C31 VDD VSS 16.05705f
C32 sn VSS 9.59733f
C33 sp VSS 9.66154f
C34 VDD.t1 VSS 0.7185f
C35 VDD.t0 VSS 0.71852f
C36 VDD.n0 VSS 9.82756f
C37 VDD.n1 VSS 9.82804f
C38 inp.t3 VSS 0.10958f
C39 inp.t0 VSS 0.11898f
C40 inp.t1 VSS 0.10958f
C41 inp.n0 VSS 0.26389f
C42 inp.t2 VSS 0.11897f
C43 inp.n1 VSS 0.13172f
C44 inp.n2 VSS 0.14908f
C45 outn.t4 VSS 1.50381f
C46 outn.n0 VSS 0.46851f
C47 outn.n1 VSS 0.38672f
C48 outn.n2 VSS 0.00826f
C49 outn.t3 VSS 0.12389f
C50 outn.t0 VSS 0.12389f
C51 outn.n3 VSS 0.27269f
C52 outn.n4 VSS 0.11808f
C53 outn.n5 VSS 0.02481f
C54 outn.n6 VSS 0.01434f
C55 outn.n7 VSS 0.04619f
C56 outn.n8 VSS 0.10623f
C57 outn.n9 VSS 0.01943f
C58 outn.t1 VSS 0.12389f
C59 outn.t2 VSS 0.12389f
C60 outn.n10 VSS 0.27269f
C61 outn.n11 VSS 0.03629f
C62 outn.n12 VSS 0.02481f
C63 outn.n13 VSS 0.01434f
C64 outn.n14 VSS 0.03501f
C65 outn.n15 VSS 0.16867f
C66 outn.n16 VSS 1.93089f
C67 outn.n17 VSS 0.59715f
C68 outn.n18 VSS 4.21226f
C69 nb.t6 VSS 0.1496f
C70 nb.t7 VSS 0.13052f
C71 nb.n0 VSS 0.20133f
C72 nb.t8 VSS 0.14957f
C73 nb.n1 VSS 0.11722f
C74 nb.t9 VSS 0.13052f
C75 nb.n2 VSS 0.10309f
C76 nb.t10 VSS 0.14957f
C77 nb.n3 VSS 0.11722f
C78 nb.t11 VSS 0.13052f
C79 nb.n4 VSS 0.18604f
C80 nb.t0 VSS 0.1496f
C81 nb.t1 VSS 0.13052f
C82 nb.n5 VSS 0.20133f
C83 nb.t2 VSS 0.14957f
C84 nb.n6 VSS 0.11722f
C85 nb.t3 VSS 0.13052f
C86 nb.n7 VSS 0.10309f
C87 nb.t4 VSS 0.14957f
C88 nb.n8 VSS 0.11722f
C89 nb.t5 VSS 0.13052f
C90 nb.n9 VSS 0.18603f
C91 nb.n10 VSS 0.45837f
C92 inn.t3 VSS 0.1095f
C93 inn.t0 VSS 0.11889f
C94 inn.t1 VSS 0.1095f
C95 inn.n0 VSS 0.2637f
C96 inn.t2 VSS 0.11889f
C97 inn.n1 VSS 0.13162f
C98 inn.n2 VSS 0.14897f
C99 outp.t4 VSS 1.33631f
C100 outp.n0 VSS 0.34353f
C101 outp.n1 VSS 0.34353f
C102 outp.n2 VSS 0.01274f
C103 outp.n3 VSS 0.02204f
C104 outp.t3 VSS 0.11006f
C105 outp.n4 VSS 0.10491f
C106 outp.t0 VSS 0.11006f
C107 outp.n5 VSS 0.24224f
C108 outp.n6 VSS 0.00733f
C109 outp.n7 VSS 0.04103f
C110 outp.n8 VSS 0.09437f
C111 outp.n9 VSS 0.01274f
C112 outp.n10 VSS 0.02204f
C113 outp.t1 VSS 0.11006f
C114 outp.n11 VSS 0.10491f
C115 outp.t2 VSS 0.11006f
C116 outp.n12 VSS 0.24224f
C117 outp.n13 VSS 0.00733f
C118 outp.n14 VSS 0.04103f
C119 outp.n15 VSS 0.14984f
C120 outp.n16 VSS 1.78808f
C121 outp.n17 VSS 3.74255f
.ends
