* tx_ls: magic R+C extraction of layout/tx_ls.gds (layout/pex.sh)
.subckt tx_ls in A B VDD VAPWR VSS
X0 ctrl_n ctrl VDD.t7 VDD.t6 sky130_fd_pr__pfet_01v8_hvt ad=0.3 pd=2.3 as=0.6 ps=4.6 w=2 l=0.15
X1 B.t2 ctrl_n VSS.t3 VSS.t2 sky130_fd_pr__nfet_g5v0d10v5 ad=0.441 pd=3.24 as=0.882 ps=6.48 w=2.94 l=0.5
X2 B.t0 A.t5 VAPWR.t1 VAPWR.t0 sky130_fd_pr__pfet_g5v0d10v5 ad=0.252 pd=1.98 as=0.504 ps=3.96 w=1.68 l=0.5
X3 A.t0 B.t5 VAPWR.t5 VAPWR.t4 sky130_fd_pr__pfet_g5v0d10v5 ad=0.252 pd=1.98 as=0.504 ps=3.96 w=1.68 l=0.5
X4 VAPWR.t3 A.t4 B.t1 VAPWR.t2 sky130_fd_pr__pfet_g5v0d10v5 ad=0.504 pd=3.96 as=0.252 ps=1.98 w=1.68 l=0.5
X5 VAPWR.t7 B.t4 A.t1 VAPWR.t6 sky130_fd_pr__pfet_g5v0d10v5 ad=0.504 pd=3.96 as=0.252 ps=1.98 w=1.68 l=0.5
X6 ctrl_n ctrl VSS.t9 VSS.t8 sky130_fd_pr__nfet_01v8 ad=0.504 pd=3.96 as=0.504 ps=3.96 w=1.68 l=0.15
X7 VSS.t7 ctrl A.t3 VSS.t6 sky130_fd_pr__nfet_g5v0d10v5 ad=0.882 pd=6.48 as=0.441 ps=3.24 w=2.94 l=0.5
X8 VSS.t5 ctrl_n B.t3 VSS.t4 sky130_fd_pr__nfet_g5v0d10v5 ad=0.882 pd=6.48 as=0.441 ps=3.24 w=2.94 l=0.5
X9 ctrl in.t1 VDD.t5 VDD.t4 sky130_fd_pr__pfet_01v8 ad=0.9 pd=6.6 as=0.45 ps=3.3 w=3 l=0.15
X10 ctrl in.t0 VSS.t1 VSS.t0 sky130_fd_pr__nfet_01v8 ad=0.9 pd=6.6 as=0.9 ps=6.6 w=3 l=0.15
X11 VDD.t3 in.t2 ctrl VDD.t2 sky130_fd_pr__pfet_01v8 ad=0.45 pd=3.3 as=0.45 ps=3.3 w=3 l=0.15
X12 ctrl in.t3 VDD.t1 VDD.t0 sky130_fd_pr__pfet_01v8 ad=0.45 pd=3.3 as=0.9 ps=6.6 w=3 l=0.15
X13 A.t2 ctrl VSS.t11 VSS.t10 sky130_fd_pr__nfet_g5v0d10v5 ad=0.441 pd=3.24 as=0.882 ps=6.48 w=2.94 l=0.5
X14 VDD.t9 ctrl ctrl_n VDD.t8 sky130_fd_pr__pfet_01v8_hvt ad=0.6 pd=4.6 as=0.3 ps=2.3 w=2 l=0.15
R0 A.n10 A.t4 345.05
R1 A.n5 A.n4 292.517
R2 A.n6 A.n5 285.877
R3 A.n10 A.t5 277.462
R4 A.n4 A.n3 29.8328
R5 A.n9 A.n0 28.1247
R6 A.n7 A.n6 22.5735
R7 A.n5 A.t1 17.0541
R8 A.n5 A.t0 17.0541
R9 A.n6 A.n3 13.2471
R10 A.n3 A.n2 9.3005
R11 A.n0 A.t3 5.81683
R12 A.n0 A.t2 5.81683
R13 A.n4 A.n1 4.74601
R14 A.n8 A.n1 4.60461
R15 A.n8 A.n7 4.5005
R16 A.n11 A.n10 3.2079
R17 A.n11 A.n9 1.90105
R18 A.n9 A.n8 1.79425
R19 A A.n11 0.197329
R20 A.n7 A.n2 0.0741111
R21 A.n2 A.n1 0.0157778
R22 B.n0 B.t4 345.05
R23 B.n5 B.n4 292.517
R24 B.n6 B.n5 285.877
R25 B.n0 B.t5 277.462
R26 B.n4 B.n3 29.8328
R27 B.n10 B.n9 28.6944
R28 B.n7 B.n6 22.5735
R29 B.n5 B.t1 17.0541
R30 B.n5 B.t0 17.0541
R31 B.n6 B.n3 13.2471
R32 B.n3 B.n2 9.3005
R33 B.n9 B.t3 5.81683
R34 B.n9 B.t2 5.81683
R35 B.n4 B.n1 4.74601
R36 B.n8 B.n1 4.60461
R37 B.n8 B.n7 4.5005
R38 B.n11 B.n0 2.85734
R39 B.n10 B.n8 1.19733
R40 B.n11 B.n10 0.853
R41 B B.n11 0.117899
R42 B.n7 B.n2 0.0741111
R43 B.n2 B.n1 0.0157778
R44 in.n0 in.t2 961.957
R45 in.n2 in.t0 739.949
R46 in.n0 in.t1 737.083
R47 in.n1 in.t3 737.039
R48 in.n2 in.n1 1.66191
R49 in.n3 in.n2 0.874049
R50 in.n1 in.n0 0.0441828
R51 in.n3 in 0.03575
R52 in in.n3 0.0221258
R53 VAPWR.n163 VAPWR.n9 247.951
R54 VAPWR.n166 VAPWR.n29 247.951
R55 VAPWR.n104 VAPWR.n56 247.951
R56 VAPWR.n100 VAPWR.n54 247.951
R57 VAPWR.n7 VAPWR.t5 230.542
R58 VAPWR.n198 VAPWR.t7 230.542
R59 VAPWR.n137 VAPWR.t1 230.542
R60 VAPWR.n52 VAPWR.t3 230.542
R61 VAPWR.n54 VAPWR.n53 185
R62 VAPWR.n55 VAPWR.n54 185
R63 VAPWR.n114 VAPWR.n113 185
R64 VAPWR.n113 VAPWR.n112 185
R65 VAPWR.n51 VAPWR.n50 185
R66 VAPWR.n50 VAPWR.t2 185
R67 VAPWR.n119 VAPWR.n118 185
R68 VAPWR.n120 VAPWR.n119 185
R69 VAPWR.n42 VAPWR.n41 185
R70 VAPWR.n121 VAPWR.n42 185
R71 VAPWR.n135 VAPWR.n134 185
R72 VAPWR.n134 VAPWR.n133 185
R73 VAPWR.n39 VAPWR.n38 185
R74 VAPWR.n132 VAPWR.n38 185
R75 VAPWR.n141 VAPWR.n140 185
R76 VAPWR.n141 VAPWR.n36 185
R77 VAPWR.n142 VAPWR.n2 185
R78 VAPWR.n143 VAPWR.n142 185
R79 VAPWR.n196 VAPWR.n3 185
R80 VAPWR.n144 VAPWR.n3 185
R81 VAPWR.n195 VAPWR.n4 185
R82 VAPWR.n145 VAPWR.n4 185
R83 VAPWR.n194 VAPWR.n5 185
R84 VAPWR.n30 VAPWR.n5 185
R85 VAPWR.n153 VAPWR.n6 185
R86 VAPWR.t4 VAPWR.n153 185
R87 VAPWR.n190 VAPWR.n8 185
R88 VAPWR.n154 VAPWR.n8 185
R89 VAPWR.n189 VAPWR.n9 185
R90 VAPWR.n165 VAPWR.n9 185
R91 VAPWR.n100 VAPWR.n99 185
R92 VAPWR.n69 VAPWR.n68 185
R93 VAPWR.n95 VAPWR.n67 185
R94 VAPWR.n102 VAPWR.n67 185
R95 VAPWR.n94 VAPWR.n72 185
R96 VAPWR.n93 VAPWR.n73 185
R97 VAPWR.n75 VAPWR.n74 185
R98 VAPWR.n89 VAPWR.n77 185
R99 VAPWR.n88 VAPWR.n78 185
R100 VAPWR.n87 VAPWR.n79 185
R101 VAPWR.n81 VAPWR.n80 185
R102 VAPWR.n83 VAPWR.n82 185
R103 VAPWR.n62 VAPWR.n61 185
R104 VAPWR.n105 VAPWR.n104 185
R105 VAPWR.n167 VAPWR.n166 185
R106 VAPWR.n166 VAPWR.n165 185
R107 VAPWR.n28 VAPWR.n27 185
R108 VAPWR.n154 VAPWR.n28 185
R109 VAPWR.n152 VAPWR.n151 185
R110 VAPWR.t4 VAPWR.n152 185
R111 VAPWR.n32 VAPWR.n31 185
R112 VAPWR.n31 VAPWR.n30 185
R113 VAPWR.n147 VAPWR.n146 185
R114 VAPWR.n146 VAPWR.n145 185
R115 VAPWR.n35 VAPWR.n34 185
R116 VAPWR.n144 VAPWR.n35 185
R117 VAPWR.n126 VAPWR.n37 185
R118 VAPWR.n143 VAPWR.n37 185
R119 VAPWR.n46 VAPWR.n44 185
R120 VAPWR.n44 VAPWR.n36 185
R121 VAPWR.n131 VAPWR.n130 185
R122 VAPWR.n132 VAPWR.n131 185
R123 VAPWR.n45 VAPWR.n43 185
R124 VAPWR.n133 VAPWR.n43 185
R125 VAPWR.n123 VAPWR.n122 185
R126 VAPWR.n122 VAPWR.n121 185
R127 VAPWR.n49 VAPWR.n48 185
R128 VAPWR.n120 VAPWR.n49 185
R129 VAPWR.n59 VAPWR.n57 185
R130 VAPWR.n57 VAPWR.t2 185
R131 VAPWR.n111 VAPWR.n110 185
R132 VAPWR.n112 VAPWR.n111 185
R133 VAPWR.n58 VAPWR.n56 185
R134 VAPWR.n56 VAPWR.n55 185
R135 VAPWR.n29 VAPWR.n25 185
R136 VAPWR.n171 VAPWR.n24 185
R137 VAPWR.n172 VAPWR.n23 185
R138 VAPWR.n173 VAPWR.n22 185
R139 VAPWR.n157 VAPWR.n20 185
R140 VAPWR.n177 VAPWR.n19 185
R141 VAPWR.n178 VAPWR.n18 185
R142 VAPWR.n179 VAPWR.n17 185
R143 VAPWR.n160 VAPWR.n15 185
R144 VAPWR.n183 VAPWR.n14 185
R145 VAPWR.n184 VAPWR.n13 185
R146 VAPWR.n185 VAPWR.n12 185
R147 VAPWR.n163 VAPWR.n10 185
R148 VAPWR.n164 VAPWR.n163 185
R149 VAPWR.n163 VAPWR.n12 102.6
R150 VAPWR.n14 VAPWR.n13 102.6
R151 VAPWR.n160 VAPWR.n17 102.6
R152 VAPWR.n19 VAPWR.n18 102.6
R153 VAPWR.n157 VAPWR.n22 102.6
R154 VAPWR.n24 VAPWR.n23 102.6
R155 VAPWR.n111 VAPWR.n56 102.6
R156 VAPWR.n111 VAPWR.n57 102.6
R157 VAPWR.n57 VAPWR.n49 102.6
R158 VAPWR.n122 VAPWR.n49 102.6
R159 VAPWR.n122 VAPWR.n43 102.6
R160 VAPWR.n131 VAPWR.n43 102.6
R161 VAPWR.n131 VAPWR.n44 102.6
R162 VAPWR.n44 VAPWR.n37 102.6
R163 VAPWR.n37 VAPWR.n35 102.6
R164 VAPWR.n146 VAPWR.n35 102.6
R165 VAPWR.n146 VAPWR.n31 102.6
R166 VAPWR.n152 VAPWR.n31 102.6
R167 VAPWR.n152 VAPWR.n28 102.6
R168 VAPWR.n166 VAPWR.n28 102.6
R169 VAPWR.n68 VAPWR.n67 102.6
R170 VAPWR.n72 VAPWR.n67 102.6
R171 VAPWR.n74 VAPWR.n73 102.6
R172 VAPWR.n78 VAPWR.n77 102.6
R173 VAPWR.n80 VAPWR.n79 102.6
R174 VAPWR.n82 VAPWR.n62 102.6
R175 VAPWR.n113 VAPWR.n54 102.6
R176 VAPWR.n113 VAPWR.n50 102.6
R177 VAPWR.n119 VAPWR.n50 102.6
R178 VAPWR.n119 VAPWR.n42 102.6
R179 VAPWR.n134 VAPWR.n42 102.6
R180 VAPWR.n134 VAPWR.n38 102.6
R181 VAPWR.n141 VAPWR.n38 102.6
R182 VAPWR.n142 VAPWR.n141 102.6
R183 VAPWR.n142 VAPWR.n3 102.6
R184 VAPWR.n4 VAPWR.n3 102.6
R185 VAPWR.n5 VAPWR.n4 102.6
R186 VAPWR.n153 VAPWR.n5 102.6
R187 VAPWR.n153 VAPWR.n8 102.6
R188 VAPWR.n9 VAPWR.n8 102.6
R189 VAPWR.n102 VAPWR.n101 72.4195
R190 VAPWR.n102 VAPWR.n63 72.4195
R191 VAPWR.n102 VAPWR.n64 72.4195
R192 VAPWR.n102 VAPWR.n65 72.4195
R193 VAPWR.n102 VAPWR.n66 72.4195
R194 VAPWR.n103 VAPWR.n102 72.4195
R195 VAPWR.n164 VAPWR.n155 72.4195
R196 VAPWR.n164 VAPWR.n156 72.4195
R197 VAPWR.n164 VAPWR.n158 72.4195
R198 VAPWR.n164 VAPWR.n159 72.4195
R199 VAPWR.n164 VAPWR.n161 72.4195
R200 VAPWR.n164 VAPWR.n162 72.4195
R201 VAPWR.n102 VAPWR.n55 66.0875
R202 VAPWR.n165 VAPWR.n164 66.0875
R203 VAPWR.n112 VAPWR.n55 49.5657
R204 VAPWR.n112 VAPWR.t2 49.5657
R205 VAPWR.n120 VAPWR.t2 49.5657
R206 VAPWR.n121 VAPWR.n120 49.5657
R207 VAPWR.n133 VAPWR.n132 49.5657
R208 VAPWR.n132 VAPWR.n36 49.5657
R209 VAPWR.n143 VAPWR.n36 49.5657
R210 VAPWR.n144 VAPWR.n143 49.5657
R211 VAPWR.n145 VAPWR.n30 49.5657
R212 VAPWR.t4 VAPWR.n30 49.5657
R213 VAPWR.n154 VAPWR.t4 49.5657
R214 VAPWR.n165 VAPWR.n154 49.5657
R215 VAPWR.n162 VAPWR.n13 40.1639
R216 VAPWR.n161 VAPWR.n160 40.1639
R217 VAPWR.n159 VAPWR.n18 40.1639
R218 VAPWR.n158 VAPWR.n157 40.1639
R219 VAPWR.n156 VAPWR.n23 40.1639
R220 VAPWR.n155 VAPWR.n29 40.1639
R221 VAPWR.n101 VAPWR.n100 40.1639
R222 VAPWR.n72 VAPWR.n63 40.1639
R223 VAPWR.n74 VAPWR.n64 40.1639
R224 VAPWR.n78 VAPWR.n65 40.1639
R225 VAPWR.n80 VAPWR.n66 40.1639
R226 VAPWR.n103 VAPWR.n62 40.1639
R227 VAPWR.n101 VAPWR.n68 40.1639
R228 VAPWR.n73 VAPWR.n63 40.1639
R229 VAPWR.n77 VAPWR.n64 40.1639
R230 VAPWR.n79 VAPWR.n65 40.1639
R231 VAPWR.n82 VAPWR.n66 40.1639
R232 VAPWR.n104 VAPWR.n103 40.1639
R233 VAPWR.n155 VAPWR.n24 40.1639
R234 VAPWR.n156 VAPWR.n22 40.1639
R235 VAPWR.n158 VAPWR.n19 40.1639
R236 VAPWR.n159 VAPWR.n17 40.1639
R237 VAPWR.n161 VAPWR.n14 40.1639
R238 VAPWR.n162 VAPWR.n12 40.1639
R239 VAPWR.n133 VAPWR.t0 38.5512
R240 VAPWR.t6 VAPWR.n144 38.5512
R241 VAPWR.n99 VAPWR.n53 27.8405
R242 VAPWR.n189 VAPWR.n10 27.8405
R243 VAPWR.n105 VAPWR.n58 27.8405
R244 VAPWR.n167 VAPWR.n25 27.8405
R245 VAPWR.n114 VAPWR.n53 11.5205
R246 VAPWR.n114 VAPWR.n51 11.5205
R247 VAPWR.n118 VAPWR.n51 11.5205
R248 VAPWR.n118 VAPWR.n41 11.5205
R249 VAPWR.n135 VAPWR.n41 11.5205
R250 VAPWR.n135 VAPWR.n39 11.5205
R251 VAPWR.n140 VAPWR.n39 11.5205
R252 VAPWR.n140 VAPWR.n2 11.5205
R253 VAPWR.n196 VAPWR.n2 11.5205
R254 VAPWR.n196 VAPWR.n195 11.5205
R255 VAPWR.n195 VAPWR.n194 11.5205
R256 VAPWR.n194 VAPWR.n6 11.5205
R257 VAPWR.n190 VAPWR.n6 11.5205
R258 VAPWR.n190 VAPWR.n189 11.5205
R259 VAPWR.n99 VAPWR.n69 11.5205
R260 VAPWR.n95 VAPWR.n69 11.5205
R261 VAPWR.n95 VAPWR.n94 11.5205
R262 VAPWR.n94 VAPWR.n93 11.5205
R263 VAPWR.n93 VAPWR.n75 11.5205
R264 VAPWR.n89 VAPWR.n75 11.5205
R265 VAPWR.n89 VAPWR.n88 11.5205
R266 VAPWR.n88 VAPWR.n87 11.5205
R267 VAPWR.n87 VAPWR.n81 11.5205
R268 VAPWR.n83 VAPWR.n81 11.5205
R269 VAPWR.n83 VAPWR.n61 11.5205
R270 VAPWR.n105 VAPWR.n61 11.5205
R271 VAPWR.n110 VAPWR.n58 11.5205
R272 VAPWR.n110 VAPWR.n59 11.5205
R273 VAPWR.n59 VAPWR.n48 11.5205
R274 VAPWR.n123 VAPWR.n48 11.5205
R275 VAPWR.n123 VAPWR.n45 11.5205
R276 VAPWR.n130 VAPWR.n45 11.5205
R277 VAPWR.n130 VAPWR.n46 11.5205
R278 VAPWR.n126 VAPWR.n46 11.5205
R279 VAPWR.n126 VAPWR.n34 11.5205
R280 VAPWR.n147 VAPWR.n34 11.5205
R281 VAPWR.n147 VAPWR.n32 11.5205
R282 VAPWR.n151 VAPWR.n32 11.5205
R283 VAPWR.n151 VAPWR.n27 11.5205
R284 VAPWR.n167 VAPWR.n27 11.5205
R285 VAPWR.n185 VAPWR.n10 11.5205
R286 VAPWR.n185 VAPWR.n184 11.5205
R287 VAPWR.n184 VAPWR.n183 11.5205
R288 VAPWR.n183 VAPWR.n15 11.5205
R289 VAPWR.n179 VAPWR.n15 11.5205
R290 VAPWR.n179 VAPWR.n178 11.5205
R291 VAPWR.n178 VAPWR.n177 11.5205
R292 VAPWR.n177 VAPWR.n20 11.5205
R293 VAPWR.n173 VAPWR.n20 11.5205
R294 VAPWR.n173 VAPWR.n172 11.5205
R295 VAPWR.n172 VAPWR.n171 11.5205
R296 VAPWR.n171 VAPWR.n25 11.5205
R297 VAPWR.n121 VAPWR.t0 11.015
R298 VAPWR.n145 VAPWR.t6 11.015
R299 VAPWR.n169 VAPWR.n25 9.3005
R300 VAPWR.n171 VAPWR.n170 9.3005
R301 VAPWR.n172 VAPWR.n21 9.3005
R302 VAPWR.n174 VAPWR.n173 9.3005
R303 VAPWR.n175 VAPWR.n20 9.3005
R304 VAPWR.n177 VAPWR.n176 9.3005
R305 VAPWR.n178 VAPWR.n16 9.3005
R306 VAPWR.n180 VAPWR.n179 9.3005
R307 VAPWR.n181 VAPWR.n15 9.3005
R308 VAPWR.n183 VAPWR.n182 9.3005
R309 VAPWR.n184 VAPWR.n11 9.3005
R310 VAPWR.n186 VAPWR.n185 9.3005
R311 VAPWR.n187 VAPWR.n10 9.3005
R312 VAPWR.n168 VAPWR.n167 9.3005
R313 VAPWR.n27 VAPWR.n26 9.3005
R314 VAPWR.n151 VAPWR.n150 9.3005
R315 VAPWR.n149 VAPWR.n32 9.3005
R316 VAPWR.n148 VAPWR.n147 9.3005
R317 VAPWR.n34 VAPWR.n33 9.3005
R318 VAPWR.n127 VAPWR.n126 9.3005
R319 VAPWR.n128 VAPWR.n46 9.3005
R320 VAPWR.n130 VAPWR.n129 9.3005
R321 VAPWR.n125 VAPWR.n45 9.3005
R322 VAPWR.n124 VAPWR.n123 9.3005
R323 VAPWR.n48 VAPWR.n47 9.3005
R324 VAPWR.n108 VAPWR.n59 9.3005
R325 VAPWR.n110 VAPWR.n109 9.3005
R326 VAPWR.n107 VAPWR.n58 9.3005
R327 VAPWR.n99 VAPWR.n98 9.3005
R328 VAPWR.n97 VAPWR.n69 9.3005
R329 VAPWR.n96 VAPWR.n95 9.3005
R330 VAPWR.n94 VAPWR.n71 9.3005
R331 VAPWR.n93 VAPWR.n92 9.3005
R332 VAPWR.n91 VAPWR.n75 9.3005
R333 VAPWR.n90 VAPWR.n89 9.3005
R334 VAPWR.n88 VAPWR.n76 9.3005
R335 VAPWR.n87 VAPWR.n86 9.3005
R336 VAPWR.n85 VAPWR.n81 9.3005
R337 VAPWR.n84 VAPWR.n83 9.3005
R338 VAPWR.n61 VAPWR.n60 9.3005
R339 VAPWR.n106 VAPWR.n105 9.3005
R340 VAPWR.n70 VAPWR.n53 9.3005
R341 VAPWR.n115 VAPWR.n114 9.3005
R342 VAPWR.n116 VAPWR.n51 9.3005
R343 VAPWR.n118 VAPWR.n117 9.3005
R344 VAPWR.n41 VAPWR.n40 9.3005
R345 VAPWR.n136 VAPWR.n135 9.3005
R346 VAPWR.n138 VAPWR.n39 9.3005
R347 VAPWR.n140 VAPWR.n139 9.3005
R348 VAPWR.n2 VAPWR.n0 9.3005
R349 VAPWR.n197 VAPWR.n196 9.3005
R350 VAPWR.n195 VAPWR.n1 9.3005
R351 VAPWR.n194 VAPWR.n193 9.3005
R352 VAPWR.n192 VAPWR.n6 9.3005
R353 VAPWR.n191 VAPWR.n190 9.3005
R354 VAPWR.n189 VAPWR.n188 9.3005
R355 VAPWR.n169 VAPWR.n168 0.272375
R356 VAPWR.n107 VAPWR.n106 0.272375
R357 VAPWR VAPWR.n199 0.16047
R358 VAPWR.n188 VAPWR.n187 0.152375
R359 VAPWR.n98 VAPWR.n70 0.152375
R360 VAPWR.n187 VAPWR.n186 0.113
R361 VAPWR.n186 VAPWR.n11 0.113
R362 VAPWR.n182 VAPWR.n11 0.113
R363 VAPWR.n182 VAPWR.n181 0.113
R364 VAPWR.n181 VAPWR.n180 0.113
R365 VAPWR.n180 VAPWR.n16 0.113
R366 VAPWR.n176 VAPWR.n16 0.113
R367 VAPWR.n176 VAPWR.n175 0.113
R368 VAPWR.n175 VAPWR.n174 0.113
R369 VAPWR.n174 VAPWR.n21 0.113
R370 VAPWR.n170 VAPWR.n21 0.113
R371 VAPWR.n170 VAPWR.n169 0.113
R372 VAPWR.n109 VAPWR.n107 0.113
R373 VAPWR.n109 VAPWR.n108 0.113
R374 VAPWR.n108 VAPWR.n47 0.113
R375 VAPWR.n124 VAPWR.n47 0.113
R376 VAPWR.n125 VAPWR.n124 0.113
R377 VAPWR.n129 VAPWR.n125 0.113
R378 VAPWR.n129 VAPWR.n128 0.113
R379 VAPWR.n128 VAPWR.n127 0.113
R380 VAPWR.n127 VAPWR.n33 0.113
R381 VAPWR.n148 VAPWR.n33 0.113
R382 VAPWR.n149 VAPWR.n148 0.113
R383 VAPWR.n150 VAPWR.n149 0.113
R384 VAPWR.n150 VAPWR.n26 0.113
R385 VAPWR.n168 VAPWR.n26 0.113
R386 VAPWR.n98 VAPWR.n97 0.113
R387 VAPWR.n97 VAPWR.n96 0.113
R388 VAPWR.n96 VAPWR.n71 0.113
R389 VAPWR.n92 VAPWR.n71 0.113
R390 VAPWR.n92 VAPWR.n91 0.113
R391 VAPWR.n91 VAPWR.n90 0.113
R392 VAPWR.n90 VAPWR.n76 0.113
R393 VAPWR.n86 VAPWR.n76 0.113
R394 VAPWR.n86 VAPWR.n85 0.113
R395 VAPWR.n85 VAPWR.n84 0.113
R396 VAPWR.n84 VAPWR.n60 0.113
R397 VAPWR.n106 VAPWR.n60 0.113
R398 VAPWR.n116 VAPWR.n115 0.023
R399 VAPWR.n117 VAPWR.n116 0.023
R400 VAPWR.n117 VAPWR.n40 0.023
R401 VAPWR.n136 VAPWR.n40 0.023
R402 VAPWR.n139 VAPWR.n138 0.023
R403 VAPWR.n139 VAPWR.n0 0.023
R404 VAPWR.n197 VAPWR.n1 0.023
R405 VAPWR.n193 VAPWR.n1 0.023
R406 VAPWR.n193 VAPWR.n192 0.023
R407 VAPWR.n192 VAPWR.n191 0.023
R408 VAPWR.n70 VAPWR.n52 0.0205
R409 VAPWR.n188 VAPWR.n7 0.0205
R410 VAPWR.n138 VAPWR.n137 0.0155
R411 VAPWR.n199 VAPWR.n198 0.009875
R412 VAPWR.n137 VAPWR.n136 0.008
R413 VAPWR.n198 VAPWR.n197 0.008
R414 VAPWR.n199 VAPWR.n0 0.006125
R415 VAPWR.n115 VAPWR.n52 0.003
R416 VAPWR.n191 VAPWR.n7 0.003
R417 VDD.n20 VDD.n19 585
R418 VDD.n16 VDD.n15 585
R419 VDD.n21 VDD.n20 571.606
R420 VDD.n17 VDD.t1 397.385
R421 VDD.n153 VDD.n25 280.5
R422 VDD.n155 VDD.n43 280.5
R423 VDD.n111 VDD.n58 280.5
R424 VDD.n107 VDD.n69 280.5
R425 VDD.n20 VDD.n15 236.4
R426 VDD.n70 VDD.n69 185
R427 VDD.n69 VDD.n57 185
R428 VDD.n74 VDD.n55 185
R429 VDD.n118 VDD.n55 185
R430 VDD.n120 VDD.n56 185
R431 VDD.n120 VDD.n119 185
R432 VDD.n121 VDD.n2 185
R433 VDD.n122 VDD.n121 185
R434 VDD.n191 VDD.n3 185
R435 VDD.n49 VDD.n3 185
R436 VDD.n190 VDD.n4 185
R437 VDD.n130 VDD.n4 185
R438 VDD.n189 VDD.n5 185
R439 VDD.n131 VDD.n5 185
R440 VDD.n133 VDD.n6 185
R441 VDD.n134 VDD.n133 185
R442 VDD.n184 VDD.n9 185
R443 VDD.n132 VDD.n9 185
R444 VDD.n183 VDD.n10 185
R445 VDD.n142 VDD.n10 185
R446 VDD.n182 VDD.n11 185
R447 VDD.n143 VDD.n11 185
R448 VDD.n153 VDD.n12 185
R449 VDD.n154 VDD.n153 185
R450 VDD.n107 VDD.n106 185
R451 VDD.n71 VDD.n68 185
R452 VDD.n102 VDD.n67 185
R453 VDD.n109 VDD.n67 185
R454 VDD.n101 VDD.n79 185
R455 VDD.n100 VDD.n80 185
R456 VDD.n82 VDD.n81 185
R457 VDD.n96 VDD.n84 185
R458 VDD.n95 VDD.n85 185
R459 VDD.n94 VDD.n86 185
R460 VDD.n88 VDD.n87 185
R461 VDD.n90 VDD.n89 185
R462 VDD.n62 VDD.n61 185
R463 VDD.n112 VDD.n111 185
R464 VDD.n156 VDD.n155 185
R465 VDD.n155 VDD.n154 185
R466 VDD.n42 VDD.n41 185
R467 VDD.n143 VDD.n42 185
R468 VDD.n141 VDD.n140 185
R469 VDD.n142 VDD.n141 185
R470 VDD.n45 VDD.n44 185
R471 VDD.n132 VDD.n44 185
R472 VDD.n136 VDD.n135 185
R473 VDD.n135 VDD.n134 185
R474 VDD.n48 VDD.n47 185
R475 VDD.n131 VDD.n48 185
R476 VDD.n129 VDD.n128 185
R477 VDD.n130 VDD.n129 185
R478 VDD.n51 VDD.n50 185
R479 VDD.n50 VDD.n49 185
R480 VDD.n124 VDD.n123 185
R481 VDD.n123 VDD.n122 185
R482 VDD.n54 VDD.n53 185
R483 VDD.n119 VDD.n54 185
R484 VDD.n117 VDD.n116 185
R485 VDD.n118 VDD.n117 185
R486 VDD.n59 VDD.n58 185
R487 VDD.n58 VDD.n57 185
R488 VDD.n43 VDD.n39 185
R489 VDD.n161 VDD.n38 185
R490 VDD.n162 VDD.n37 185
R491 VDD.n163 VDD.n36 185
R492 VDD.n146 VDD.n34 185
R493 VDD.n167 VDD.n33 185
R494 VDD.n168 VDD.n32 185
R495 VDD.n169 VDD.n31 185
R496 VDD.n170 VDD.n30 185
R497 VDD.n149 VDD.n28 185
R498 VDD.n174 VDD.n27 185
R499 VDD.n175 VDD.n26 185
R500 VDD.n176 VDD.n25 185
R501 VDD.n152 VDD.n25 185
R502 VDD.n0 VDD.t7 134.649
R503 VDD.n76 VDD.t9 134.649
R504 VDD.t1 VDD.n15 118.201
R505 VDD.n26 VDD.n25 108.001
R506 VDD.n149 VDD.n27 108.001
R507 VDD.n31 VDD.n30 108.001
R508 VDD.n33 VDD.n32 108.001
R509 VDD.n146 VDD.n36 108.001
R510 VDD.n38 VDD.n37 108.001
R511 VDD.n117 VDD.n58 108.001
R512 VDD.n117 VDD.n54 108.001
R513 VDD.n123 VDD.n54 108.001
R514 VDD.n123 VDD.n50 108.001
R515 VDD.n129 VDD.n50 108.001
R516 VDD.n129 VDD.n48 108.001
R517 VDD.n135 VDD.n48 108.001
R518 VDD.n135 VDD.n44 108.001
R519 VDD.n141 VDD.n44 108.001
R520 VDD.n141 VDD.n42 108.001
R521 VDD.n155 VDD.n42 108.001
R522 VDD.n68 VDD.n67 108.001
R523 VDD.n79 VDD.n67 108.001
R524 VDD.n81 VDD.n80 108.001
R525 VDD.n85 VDD.n84 108.001
R526 VDD.n87 VDD.n86 108.001
R527 VDD.n89 VDD.n62 108.001
R528 VDD.n69 VDD.n55 108.001
R529 VDD.n120 VDD.n55 108.001
R530 VDD.n121 VDD.n120 108.001
R531 VDD.n121 VDD.n3 108.001
R532 VDD.n4 VDD.n3 108.001
R533 VDD.n5 VDD.n4 108.001
R534 VDD.n133 VDD.n5 108.001
R535 VDD.n133 VDD.n9 108.001
R536 VDD.n10 VDD.n9 108.001
R537 VDD.n11 VDD.n10 108.001
R538 VDD.n153 VDD.n11 108.001
R539 VDD.n109 VDD.n57 75.0367
R540 VDD.n154 VDD.n152 75.0367
R541 VDD.n186 VDD.n7 74.9836
R542 VDD.n109 VDD.n108 71.6014
R543 VDD.n109 VDD.n63 71.6014
R544 VDD.n109 VDD.n64 71.6014
R545 VDD.n109 VDD.n65 71.6014
R546 VDD.n109 VDD.n66 71.6014
R547 VDD.n110 VDD.n109 71.6014
R548 VDD.n152 VDD.n144 71.6014
R549 VDD.n152 VDD.n145 71.6014
R550 VDD.n152 VDD.n147 71.6014
R551 VDD.n152 VDD.n148 71.6014
R552 VDD.n152 VDD.n150 71.6014
R553 VDD.n152 VDD.n151 71.6014
R554 VDD.n118 VDD.n57 49.5657
R555 VDD.n122 VDD.n49 49.5657
R556 VDD.n130 VDD.n49 49.5657
R557 VDD.n131 VDD.n130 49.5657
R558 VDD.n134 VDD.n131 49.5657
R559 VDD.n154 VDD.n143 49.5657
R560 VDD.n151 VDD.n27 41.8002
R561 VDD.n150 VDD.n30 41.8002
R562 VDD.n148 VDD.n32 41.8002
R563 VDD.n147 VDD.n146 41.8002
R564 VDD.n145 VDD.n37 41.8002
R565 VDD.n144 VDD.n43 41.8002
R566 VDD.n108 VDD.n107 41.8002
R567 VDD.n79 VDD.n63 41.8002
R568 VDD.n81 VDD.n64 41.8002
R569 VDD.n85 VDD.n65 41.8002
R570 VDD.n87 VDD.n66 41.8002
R571 VDD.n110 VDD.n62 41.8002
R572 VDD.n108 VDD.n68 41.8002
R573 VDD.n80 VDD.n63 41.8002
R574 VDD.n84 VDD.n64 41.8002
R575 VDD.n86 VDD.n65 41.8002
R576 VDD.n89 VDD.n66 41.8002
R577 VDD.n111 VDD.n110 41.8002
R578 VDD.n144 VDD.n38 41.8002
R579 VDD.n145 VDD.n36 41.8002
R580 VDD.n147 VDD.n33 41.8002
R581 VDD.n148 VDD.n31 41.8002
R582 VDD.n150 VDD.n149 41.8002
R583 VDD.n151 VDD.n26 41.8002
R584 VDD.t4 VDD.n132 41.3048
R585 VDD.n119 VDD.t8 33.044
R586 VDD.t0 VDD.n142 33.044
R587 VDD.n106 VDD.n70 29.9205
R588 VDD.n176 VDD.n12 29.9205
R589 VDD.n112 VDD.n59 29.9205
R590 VDD.n156 VDD.n39 29.9205
R591 VDD.n119 VDD.t6 28.9135
R592 VDD.n142 VDD.t2 28.9135
R593 VDD.n19 VDD.n14 27.1064
R594 VDD.n19 VDD.n16 27.1064
R595 VDD.n22 VDD.n21 24.8327
R596 VDD.n122 VDD.t6 20.6527
R597 VDD.n132 VDD.t2 20.6527
R598 VDD.t8 VDD.n118 16.5222
R599 VDD.n143 VDD.t0 16.5222
R600 VDD.n74 VDD.n70 11.5205
R601 VDD.n74 VDD.n56 11.5205
R602 VDD.n56 VDD.n2 11.5205
R603 VDD.n191 VDD.n2 11.5205
R604 VDD.n191 VDD.n190 11.5205
R605 VDD.n190 VDD.n189 11.5205
R606 VDD.n189 VDD.n6 11.5205
R607 VDD.n184 VDD.n6 11.5205
R608 VDD.n184 VDD.n183 11.5205
R609 VDD.n183 VDD.n182 11.5205
R610 VDD.n182 VDD.n12 11.5205
R611 VDD.n106 VDD.n71 11.5205
R612 VDD.n102 VDD.n71 11.5205
R613 VDD.n102 VDD.n101 11.5205
R614 VDD.n101 VDD.n100 11.5205
R615 VDD.n100 VDD.n82 11.5205
R616 VDD.n96 VDD.n82 11.5205
R617 VDD.n96 VDD.n95 11.5205
R618 VDD.n95 VDD.n94 11.5205
R619 VDD.n94 VDD.n88 11.5205
R620 VDD.n90 VDD.n88 11.5205
R621 VDD.n90 VDD.n61 11.5205
R622 VDD.n112 VDD.n61 11.5205
R623 VDD.n116 VDD.n59 11.5205
R624 VDD.n116 VDD.n53 11.5205
R625 VDD.n124 VDD.n53 11.5205
R626 VDD.n124 VDD.n51 11.5205
R627 VDD.n128 VDD.n51 11.5205
R628 VDD.n128 VDD.n47 11.5205
R629 VDD.n136 VDD.n47 11.5205
R630 VDD.n136 VDD.n45 11.5205
R631 VDD.n140 VDD.n45 11.5205
R632 VDD.n140 VDD.n41 11.5205
R633 VDD.n156 VDD.n41 11.5205
R634 VDD.n176 VDD.n175 11.5205
R635 VDD.n175 VDD.n174 11.5205
R636 VDD.n174 VDD.n28 11.5205
R637 VDD.n170 VDD.n28 11.5205
R638 VDD.n170 VDD.n169 11.5205
R639 VDD.n169 VDD.n168 11.5205
R640 VDD.n168 VDD.n167 11.5205
R641 VDD.n167 VDD.n34 11.5205
R642 VDD.n163 VDD.n34 11.5205
R643 VDD.n163 VDD.n162 11.5205
R644 VDD.n162 VDD.n161 11.5205
R645 VDD.n161 VDD.n39 11.5205
R646 VDD.n21 VDD.n14 11.0627
R647 VDD.n7 VDD.t5 9.8505
R648 VDD.n7 VDD.t3 9.8505
R649 VDD.n14 VDD.n13 9.3005
R650 VDD.n19 VDD.n18 9.3005
R651 VDD.n159 VDD.n39 9.3005
R652 VDD.n161 VDD.n160 9.3005
R653 VDD.n162 VDD.n35 9.3005
R654 VDD.n164 VDD.n163 9.3005
R655 VDD.n165 VDD.n34 9.3005
R656 VDD.n167 VDD.n166 9.3005
R657 VDD.n168 VDD.n23 9.3005
R658 VDD.n169 VDD.n29 9.3005
R659 VDD.n171 VDD.n170 9.3005
R660 VDD.n172 VDD.n28 9.3005
R661 VDD.n174 VDD.n173 9.3005
R662 VDD.n175 VDD.n24 9.3005
R663 VDD.n177 VDD.n176 9.3005
R664 VDD.n157 VDD.n156 9.3005
R665 VDD.n41 VDD.n40 9.3005
R666 VDD.n140 VDD.n139 9.3005
R667 VDD.n138 VDD.n45 9.3005
R668 VDD.n137 VDD.n136 9.3005
R669 VDD.n47 VDD.n46 9.3005
R670 VDD.n128 VDD.n127 9.3005
R671 VDD.n126 VDD.n51 9.3005
R672 VDD.n125 VDD.n124 9.3005
R673 VDD.n53 VDD.n52 9.3005
R674 VDD.n116 VDD.n115 9.3005
R675 VDD.n114 VDD.n59 9.3005
R676 VDD.n106 VDD.n105 9.3005
R677 VDD.n104 VDD.n71 9.3005
R678 VDD.n103 VDD.n102 9.3005
R679 VDD.n101 VDD.n78 9.3005
R680 VDD.n100 VDD.n99 9.3005
R681 VDD.n98 VDD.n82 9.3005
R682 VDD.n97 VDD.n96 9.3005
R683 VDD.n95 VDD.n83 9.3005
R684 VDD.n94 VDD.n93 9.3005
R685 VDD.n92 VDD.n88 9.3005
R686 VDD.n91 VDD.n90 9.3005
R687 VDD.n61 VDD.n60 9.3005
R688 VDD.n113 VDD.n112 9.3005
R689 VDD.n77 VDD.n70 9.3005
R690 VDD.n75 VDD.n74 9.3005
R691 VDD.n73 VDD.n56 9.3005
R692 VDD.n72 VDD.n2 9.3005
R693 VDD.n192 VDD.n191 9.3005
R694 VDD.n190 VDD.n1 9.3005
R695 VDD.n189 VDD.n188 9.3005
R696 VDD.n187 VDD.n6 9.3005
R697 VDD.n185 VDD.n184 9.3005
R698 VDD.n183 VDD.n8 9.3005
R699 VDD.n182 VDD.n181 9.3005
R700 VDD.n179 VDD.n12 9.3005
R701 VDD.n134 VDD.t4 8.26137
R702 VDD.n17 VDD.n16 6.45639
R703 VDD.n178 VDD.n23 2.1255
R704 VDD.n158 VDD.n23 2.1255
R705 VDD.n18 VDD.n17 1.04058
R706 VDD.n180 VDD.n22 0.329204
R707 VDD.n159 VDD.n158 0.318937
R708 VDD.n178 VDD.n177 0.300188
R709 VDD.n114 VDD.n113 0.292688
R710 VDD.n177 VDD.n24 0.1805
R711 VDD.n173 VDD.n24 0.1805
R712 VDD.n173 VDD.n172 0.1805
R713 VDD.n172 VDD.n171 0.1805
R714 VDD.n171 VDD.n29 0.1805
R715 VDD.n29 VDD.n23 0.1805
R716 VDD.n166 VDD.n23 0.1805
R717 VDD.n166 VDD.n165 0.1805
R718 VDD.n165 VDD.n164 0.1805
R719 VDD.n164 VDD.n35 0.1805
R720 VDD.n160 VDD.n35 0.1805
R721 VDD.n160 VDD.n159 0.1805
R722 VDD.n22 VDD.n13 0.167167
R723 VDD.n18 VDD.n13 0.167167
R724 VDD.n105 VDD.n77 0.156437
R725 VDD VDD.n193 0.155825
R726 VDD.n158 VDD.n157 0.13175
R727 VDD.n115 VDD.n114 0.113
R728 VDD.n115 VDD.n52 0.113
R729 VDD.n125 VDD.n52 0.113
R730 VDD.n126 VDD.n125 0.113
R731 VDD.n127 VDD.n126 0.113
R732 VDD.n127 VDD.n46 0.113
R733 VDD.n137 VDD.n46 0.113
R734 VDD.n138 VDD.n137 0.113
R735 VDD.n139 VDD.n138 0.113
R736 VDD.n139 VDD.n40 0.113
R737 VDD.n157 VDD.n40 0.113
R738 VDD.n105 VDD.n104 0.113
R739 VDD.n104 VDD.n103 0.113
R740 VDD.n103 VDD.n78 0.113
R741 VDD.n99 VDD.n78 0.113
R742 VDD.n99 VDD.n98 0.113
R743 VDD.n98 VDD.n97 0.113
R744 VDD.n97 VDD.n83 0.113
R745 VDD.n93 VDD.n83 0.113
R746 VDD.n93 VDD.n92 0.113
R747 VDD.n92 VDD.n91 0.113
R748 VDD.n91 VDD.n60 0.113
R749 VDD.n113 VDD.n60 0.113
R750 VDD.n179 VDD.n178 0.02675
R751 VDD.n75 VDD.n73 0.023
R752 VDD.n73 VDD.n72 0.023
R753 VDD.n192 VDD.n1 0.023
R754 VDD.n188 VDD.n1 0.023
R755 VDD.n188 VDD.n187 0.023
R756 VDD.n185 VDD.n8 0.023
R757 VDD.n181 VDD.n8 0.023
R758 VDD.n187 VDD.n186 0.0183125
R759 VDD.n77 VDD.n76 0.0164375
R760 VDD.n180 VDD.n179 0.0164375
R761 VDD.n193 VDD.n192 0.0120625
R762 VDD.n76 VDD.n75 0.0070625
R763 VDD.n181 VDD.n180 0.0070625
R764 VDD.n193 VDD.n0 0.00675
R765 VDD.n72 VDD.n0 0.0051875
R766 VDD.n186 VDD.n185 0.0051875
R767 VSS.n336 VSS.n292 1424.76
R768 VSS.n63 VSS.n61 585
R769 VSS.n61 VSS.n54 585
R770 VSS.n263 VSS.n262 585
R771 VSS.n264 VSS.n263 585
R772 VSS.n81 VSS.n80 585
R773 VSS.n80 VSS.t10 585
R774 VSS.n257 VSS.n256 585
R775 VSS.n256 VSS.n255 585
R776 VSS.n84 VSS.n83 585
R777 VSS.n85 VSS.n84 585
R778 VSS.n232 VSS.n231 585
R779 VSS.n233 VSS.n232 585
R780 VSS.n104 VSS.n103 585
R781 VSS.n103 VSS.n102 585
R782 VSS.n227 VSS.n226 585
R783 VSS.n226 VSS.n225 585
R784 VSS.n107 VSS.n106 585
R785 VSS.n108 VSS.n107 585
R786 VSS.n214 VSS.n213 585
R787 VSS.n215 VSS.n214 585
R788 VSS.n125 VSS.n124 585
R789 VSS.n206 VSS.n124 585
R790 VSS.n209 VSS.n208 585
R791 VSS.n208 VSS.n207 585
R792 VSS.n128 VSS.n127 585
R793 VSS.t4 VSS.n128 585
R794 VSS.n197 VSS.n196 585
R795 VSS.n198 VSS.n197 585
R796 VSS.n146 VSS.n145 585
R797 VSS.n145 VSS.n144 585
R798 VSS.n192 VSS.n191 585
R799 VSS.n149 VSS.n148 585
R800 VSS.n188 VSS.n187 585
R801 VSS.n189 VSS.n188 585
R802 VSS.n186 VSS.n155 585
R803 VSS.n185 VSS.n184 585
R804 VSS.n183 VSS.n182 585
R805 VSS.n181 VSS.n180 585
R806 VSS.n179 VSS.n178 585
R807 VSS.n177 VSS.n176 585
R808 VSS.n175 VSS.n174 585
R809 VSS.n173 VSS.n172 585
R810 VSS.n171 VSS.n170 585
R811 VSS.n169 VSS.n168 585
R812 VSS.n268 VSS.n267 585
R813 VSS.n270 VSS.n269 585
R814 VSS.n272 VSS.n271 585
R815 VSS.n274 VSS.n273 585
R816 VSS.n276 VSS.n275 585
R817 VSS.n278 VSS.n277 585
R818 VSS.n280 VSS.n279 585
R819 VSS.n282 VSS.n281 585
R820 VSS.n284 VSS.n283 585
R821 VSS.n286 VSS.n285 585
R822 VSS.n288 VSS.n287 585
R823 VSS.n289 VSS.n62 585
R824 VSS.n291 VSS.n290 585
R825 VSS.n292 VSS.n291 585
R826 VSS.n266 VSS.n77 585
R827 VSS.n266 VSS.n54 585
R828 VSS.n265 VSS.n79 585
R829 VSS.n265 VSS.n264 585
R830 VSS.n88 VSS.n78 585
R831 VSS.t10 VSS.n78 585
R832 VSS.n254 VSS.n253 585
R833 VSS.n255 VSS.n254 585
R834 VSS.n87 VSS.n86 585
R835 VSS.n86 VSS.n85 585
R836 VSS.n235 VSS.n234 585
R837 VSS.n234 VSS.n233 585
R838 VSS.n101 VSS.n100 585
R839 VSS.n102 VSS.n101 585
R840 VSS.n224 VSS.n223 585
R841 VSS.n225 VSS.n224 585
R842 VSS.n110 VSS.n109 585
R843 VSS.n109 VSS.n108 585
R844 VSS.n217 VSS.n216 585
R845 VSS.n216 VSS.n215 585
R846 VSS.n123 VSS.n122 585
R847 VSS.n206 VSS.n123 585
R848 VSS.n205 VSS.n204 585
R849 VSS.n207 VSS.n205 585
R850 VSS.n130 VSS.n129 585
R851 VSS.n129 VSS.t4 585
R852 VSS.n200 VSS.n199 585
R853 VSS.n199 VSS.n198 585
R854 VSS.n143 VSS.n142 585
R855 VSS.n144 VSS.n143 585
R856 VSS.n53 VSS.n52 585
R857 VSS.n337 VSS.n53 585
R858 VSS.n341 VSS.n340 585
R859 VSS.n340 VSS.n339 585
R860 VSS.n50 VSS.n49 585
R861 VSS.n338 VSS.n49 585
R862 VSS.n346 VSS.n345 585
R863 VSS.n347 VSS.n346 585
R864 VSS.n47 VSS.n46 585
R865 VSS.n348 VSS.n47 585
R866 VSS.n351 VSS.n350 585
R867 VSS.n350 VSS.n349 585
R868 VSS.n44 VSS.n43 585
R869 VSS.n43 VSS.n41 585
R870 VSS.n356 VSS.n355 585
R871 VSS.n357 VSS.n356 585
R872 VSS.n40 VSS.n39 585
R873 VSS.n358 VSS.n40 585
R874 VSS.n361 VSS.n360 585
R875 VSS.n360 VSS.n359 585
R876 VSS.n36 VSS.n34 585
R877 VSS.n34 VSS.n32 585
R878 VSS.n403 VSS.n402 585
R879 VSS.n404 VSS.n403 585
R880 VSS.n407 VSS.n406 585
R881 VSS.n382 VSS.n30 585
R882 VSS.n384 VSS.n383 585
R883 VSS.n385 VSS.n380 585
R884 VSS.n379 VSS.n376 585
R885 VSS.n389 VSS.n375 585
R886 VSS.n390 VSS.n374 585
R887 VSS.n391 VSS.n372 585
R888 VSS.n371 VSS.n369 585
R889 VSS.n395 VSS.n368 585
R890 VSS.n396 VSS.n367 585
R891 VSS.n397 VSS.n365 585
R892 VSS.n37 VSS.n35 585
R893 VSS.n35 VSS.n33 585
R894 VSS.n405 VSS.n17 585
R895 VSS.n405 VSS.n404 585
R896 VSS.n413 VSS.n16 585
R897 VSS.n32 VSS.n16 585
R898 VSS.n414 VSS.n15 585
R899 VSS.n359 VSS.n15 585
R900 VSS.n415 VSS.n14 585
R901 VSS.n358 VSS.n14 585
R902 VSS.n42 VSS.n12 585
R903 VSS.n357 VSS.n42 585
R904 VSS.n419 VSS.n11 585
R905 VSS.n41 VSS.n11 585
R906 VSS.n420 VSS.n10 585
R907 VSS.n349 VSS.n10 585
R908 VSS.n421 VSS.n9 585
R909 VSS.n348 VSS.n9 585
R910 VSS.n48 VSS.n7 585
R911 VSS.n347 VSS.n48 585
R912 VSS.n426 VSS.n6 585
R913 VSS.n338 VSS.n6 585
R914 VSS.n427 VSS.n5 585
R915 VSS.n339 VSS.n5 585
R916 VSS.n428 VSS.n4 585
R917 VSS.n337 VSS.n4 585
R918 VSS.n334 VSS.n333 585
R919 VSS.n301 VSS.n300 585
R920 VSS.n329 VSS.n299 585
R921 VSS.n336 VSS.n299 585
R922 VSS.n328 VSS.n303 585
R923 VSS.n327 VSS.n304 585
R924 VSS.n306 VSS.n305 585
R925 VSS.n323 VSS.n308 585
R926 VSS.n322 VSS.n309 585
R927 VSS.n321 VSS.n310 585
R928 VSS.n312 VSS.n311 585
R929 VSS.n317 VSS.n314 585
R930 VSS.n316 VSS.n315 585
R931 VSS.n297 VSS.n3 585
R932 VSS.n403 VSS.n35 460.488
R933 VSS.n406 VSS.n405 460.488
R934 VSS.n297 VSS.n4 460.488
R935 VSS.n334 VSS.n53 460.488
R936 VSS.n291 VSS.n61 415.425
R937 VSS.n267 VSS.n266 415.425
R938 VSS.n168 VSS.n143 415.425
R939 VSS.n191 VSS.n145 415.425
R940 VSS.n26 VSS.n25 256.483
R941 VSS.n190 VSS.n189 255.031
R942 VSS.n189 VSS.n150 255.031
R943 VSS.n189 VSS.n151 255.031
R944 VSS.n189 VSS.n152 255.031
R945 VSS.n189 VSS.n153 255.031
R946 VSS.n189 VSS.n154 255.031
R947 VSS.n292 VSS.n55 255.031
R948 VSS.n292 VSS.n56 255.031
R949 VSS.n292 VSS.n57 255.031
R950 VSS.n292 VSS.n58 255.031
R951 VSS.n292 VSS.n59 255.031
R952 VSS.n292 VSS.n60 255.031
R953 VSS.n33 VSS.n31 254.01
R954 VSS.n381 VSS.n33 254.01
R955 VSS.n378 VSS.n33 254.01
R956 VSS.n373 VSS.n33 254.01
R957 VSS.n370 VSS.n33 254.01
R958 VSS.n366 VSS.n33 254.01
R959 VSS.n336 VSS.n335 254.01
R960 VSS.n336 VSS.n293 254.01
R961 VSS.n336 VSS.n294 254.01
R962 VSS.n336 VSS.n295 254.01
R963 VSS.n336 VSS.n296 254.01
R964 VSS.n336 VSS.n298 254.01
R965 VSS.n139 VSS.n138 248.305
R966 VSS.n119 VSS.n118 248.305
R967 VSS.n97 VSS.n96 248.305
R968 VSS.n246 VSS.n245 248.305
R969 VSS.n337 VSS.n336 228.381
R970 VSS.n404 VSS.n33 228.381
R971 VSS.n189 VSS.n144 201.143
R972 VSS.n292 VSS.n54 201.143
R973 VSS.n134 VSS.n133 185
R974 VSS.n138 VSS.n137 185
R975 VSS.n114 VSS.n113 185
R976 VSS.n118 VSS.n117 185
R977 VSS.n92 VSS.n91 185
R978 VSS.n96 VSS.n95 185
R979 VSS.n241 VSS.n240 185
R980 VSS.n245 VSS.n244 185
R981 VSS.n21 VSS.n20 185
R982 VSS.n25 VSS.n24 185
R983 VSS.n22 VSS.t1 180.947
R984 VSS.n365 VSS.n35 177.3
R985 VSS.n368 VSS.n367 177.3
R986 VSS.n372 VSS.n371 177.3
R987 VSS.n375 VSS.n374 177.3
R988 VSS.n380 VSS.n379 177.3
R989 VSS.n383 VSS.n382 177.3
R990 VSS.n5 VSS.n4 177.3
R991 VSS.n6 VSS.n5 177.3
R992 VSS.n48 VSS.n6 177.3
R993 VSS.n48 VSS.n9 177.3
R994 VSS.n10 VSS.n9 177.3
R995 VSS.n11 VSS.n10 177.3
R996 VSS.n42 VSS.n11 177.3
R997 VSS.n42 VSS.n14 177.3
R998 VSS.n15 VSS.n14 177.3
R999 VSS.n16 VSS.n15 177.3
R1000 VSS.n405 VSS.n16 177.3
R1001 VSS.n300 VSS.n299 177.3
R1002 VSS.n303 VSS.n299 177.3
R1003 VSS.n305 VSS.n304 177.3
R1004 VSS.n309 VSS.n308 177.3
R1005 VSS.n311 VSS.n310 177.3
R1006 VSS.n315 VSS.n314 177.3
R1007 VSS.n340 VSS.n53 177.3
R1008 VSS.n340 VSS.n49 177.3
R1009 VSS.n346 VSS.n49 177.3
R1010 VSS.n346 VSS.n47 177.3
R1011 VSS.n350 VSS.n47 177.3
R1012 VSS.n350 VSS.n43 177.3
R1013 VSS.n356 VSS.n43 177.3
R1014 VSS.n356 VSS.n40 177.3
R1015 VSS.n360 VSS.n40 177.3
R1016 VSS.n360 VSS.n34 177.3
R1017 VSS.n403 VSS.n34 177.3
R1018 VSS.n135 VSS.t5 175.689
R1019 VSS.n115 VSS.t3 175.689
R1020 VSS.n93 VSS.t7 175.689
R1021 VSS.n242 VSS.t11 175.689
R1022 VSS.n291 VSS.n62 171.9
R1023 VSS.n287 VSS.n286 171.9
R1024 VSS.n283 VSS.n282 171.9
R1025 VSS.n279 VSS.n278 171.9
R1026 VSS.n275 VSS.n274 171.9
R1027 VSS.n271 VSS.n270 171.9
R1028 VSS.n199 VSS.n143 171.9
R1029 VSS.n199 VSS.n129 171.9
R1030 VSS.n205 VSS.n129 171.9
R1031 VSS.n205 VSS.n123 171.9
R1032 VSS.n216 VSS.n123 171.9
R1033 VSS.n216 VSS.n109 171.9
R1034 VSS.n224 VSS.n109 171.9
R1035 VSS.n224 VSS.n101 171.9
R1036 VSS.n234 VSS.n101 171.9
R1037 VSS.n234 VSS.n86 171.9
R1038 VSS.n254 VSS.n86 171.9
R1039 VSS.n254 VSS.n78 171.9
R1040 VSS.n265 VSS.n78 171.9
R1041 VSS.n266 VSS.n265 171.9
R1042 VSS.n188 VSS.n149 171.9
R1043 VSS.n188 VSS.n155 171.9
R1044 VSS.n184 VSS.n183 171.9
R1045 VSS.n180 VSS.n179 171.9
R1046 VSS.n176 VSS.n175 171.9
R1047 VSS.n172 VSS.n171 171.9
R1048 VSS.n197 VSS.n145 171.9
R1049 VSS.n197 VSS.n128 171.9
R1050 VSS.n208 VSS.n128 171.9
R1051 VSS.n208 VSS.n124 171.9
R1052 VSS.n214 VSS.n124 171.9
R1053 VSS.n214 VSS.n107 171.9
R1054 VSS.n226 VSS.n107 171.9
R1055 VSS.n226 VSS.n103 171.9
R1056 VSS.n232 VSS.n103 171.9
R1057 VSS.n232 VSS.n84 171.9
R1058 VSS.n256 VSS.n84 171.9
R1059 VSS.n256 VSS.n80 171.9
R1060 VSS.n263 VSS.n80 171.9
R1061 VSS.n263 VSS.n61 171.9
R1062 VSS.n198 VSS.n144 150.857
R1063 VSS.n198 VSS.t4 150.857
R1064 VSS.n207 VSS.t4 150.857
R1065 VSS.n207 VSS.n206 150.857
R1066 VSS.n215 VSS.n108 150.857
R1067 VSS.n225 VSS.n108 150.857
R1068 VSS.n225 VSS.n102 150.857
R1069 VSS.n233 VSS.n102 150.857
R1070 VSS.n255 VSS.n85 150.857
R1071 VSS.n255 VSS.t10 150.857
R1072 VSS.n264 VSS.t10 150.857
R1073 VSS.n264 VSS.n54 150.857
R1074 VSS.n339 VSS.n337 150.857
R1075 VSS.n339 VSS.n338 150.857
R1076 VSS.n348 VSS.n347 150.857
R1077 VSS.n349 VSS.n348 150.857
R1078 VSS.n349 VSS.n41 150.857
R1079 VSS.n357 VSS.n41 150.857
R1080 VSS.n358 VSS.n357 150.857
R1081 VSS.n359 VSS.n358 150.857
R1082 VSS.n404 VSS.n32 150.857
R1083 VSS.n25 VSS.n20 144
R1084 VSS.n138 VSS.n133 136.8
R1085 VSS.n118 VSS.n113 136.8
R1086 VSS.n96 VSS.n91 136.8
R1087 VSS.n245 VSS.n240 136.8
R1088 VSS.n215 VSS.t2 117.334
R1089 VSS.n233 VSS.t6 117.334
R1090 VSS.n359 VSS.t0 100.572
R1091 VSS.n423 VSS.t9 98.7615
R1092 VSS.n338 VSS.t8 88.0005
R1093 VSS.n367 VSS.n366 76.985
R1094 VSS.n371 VSS.n370 76.985
R1095 VSS.n374 VSS.n373 76.985
R1096 VSS.n379 VSS.n378 76.985
R1097 VSS.n383 VSS.n381 76.985
R1098 VSS.n406 VSS.n31 76.985
R1099 VSS.n335 VSS.n334 76.985
R1100 VSS.n303 VSS.n293 76.985
R1101 VSS.n305 VSS.n294 76.985
R1102 VSS.n309 VSS.n295 76.985
R1103 VSS.n311 VSS.n296 76.985
R1104 VSS.n315 VSS.n298 76.985
R1105 VSS.n382 VSS.n31 76.985
R1106 VSS.n381 VSS.n380 76.985
R1107 VSS.n378 VSS.n375 76.985
R1108 VSS.n373 VSS.n372 76.985
R1109 VSS.n370 VSS.n368 76.985
R1110 VSS.n366 VSS.n365 76.985
R1111 VSS.n335 VSS.n300 76.985
R1112 VSS.n304 VSS.n293 76.985
R1113 VSS.n308 VSS.n294 76.985
R1114 VSS.n310 VSS.n295 76.985
R1115 VSS.n314 VSS.n296 76.985
R1116 VSS.n298 VSS.n297 76.985
R1117 VSS.n287 VSS.n60 74.9406
R1118 VSS.n283 VSS.n59 74.9406
R1119 VSS.n279 VSS.n58 74.9406
R1120 VSS.n275 VSS.n57 74.9406
R1121 VSS.n271 VSS.n56 74.9406
R1122 VSS.n267 VSS.n55 74.9406
R1123 VSS.n191 VSS.n190 74.9406
R1124 VSS.n155 VSS.n150 74.9406
R1125 VSS.n183 VSS.n151 74.9406
R1126 VSS.n179 VSS.n152 74.9406
R1127 VSS.n175 VSS.n153 74.9406
R1128 VSS.n171 VSS.n154 74.9406
R1129 VSS.n190 VSS.n149 74.9406
R1130 VSS.n184 VSS.n150 74.9406
R1131 VSS.n180 VSS.n151 74.9406
R1132 VSS.n176 VSS.n152 74.9406
R1133 VSS.n172 VSS.n153 74.9406
R1134 VSS.n168 VSS.n154 74.9406
R1135 VSS.n270 VSS.n55 74.9406
R1136 VSS.n274 VSS.n56 74.9406
R1137 VSS.n278 VSS.n57 74.9406
R1138 VSS.n282 VSS.n58 74.9406
R1139 VSS.n286 VSS.n59 74.9406
R1140 VSS.n62 VSS.n60 74.9406
R1141 VSS.t1 VSS.n20 72.0005
R1142 VSS.t5 VSS.n133 68.4005
R1143 VSS.t3 VSS.n113 68.4005
R1144 VSS.t7 VSS.n91 68.4005
R1145 VSS.t11 VSS.n240 68.4005
R1146 VSS.n347 VSS.t8 62.8576
R1147 VSS.t0 VSS.n32 50.2862
R1148 VSS.n206 VSS.t2 33.5243
R1149 VSS.t6 VSS.n85 33.5243
R1150 VSS.n333 VSS.n52 29.9205
R1151 VSS.n402 VSS.n37 29.9205
R1152 VSS.n407 VSS.n17 29.9205
R1153 VSS.n428 VSS.n3 29.9205
R1154 VSS.n290 VSS.n63 27.8405
R1155 VSS.n268 VSS.n77 27.8405
R1156 VSS.n169 VSS.n142 27.8405
R1157 VSS.n192 VSS.n146 27.8405
R1158 VSS.n137 VSS.n134 27.1064
R1159 VSS.n137 VSS.n132 27.1064
R1160 VSS.n117 VSS.n114 27.1064
R1161 VSS.n117 VSS.n112 27.1064
R1162 VSS.n95 VSS.n92 27.1064
R1163 VSS.n95 VSS.n90 27.1064
R1164 VSS.n244 VSS.n241 27.1064
R1165 VSS.n244 VSS.n239 27.1064
R1166 VSS.n24 VSS.n21 27.1064
R1167 VSS.n24 VSS.n19 27.1064
R1168 VSS.n27 VSS.n26 25.7818
R1169 VSS.n140 VSS.n139 25.6385
R1170 VSS.n120 VSS.n119 25.6385
R1171 VSS.n98 VSS.n97 25.6385
R1172 VSS.n247 VSS.n246 25.6385
R1173 VSS.n290 VSS.n289 11.5205
R1174 VSS.n289 VSS.n288 11.5205
R1175 VSS.n288 VSS.n285 11.5205
R1176 VSS.n285 VSS.n284 11.5205
R1177 VSS.n284 VSS.n281 11.5205
R1178 VSS.n281 VSS.n280 11.5205
R1179 VSS.n280 VSS.n277 11.5205
R1180 VSS.n277 VSS.n276 11.5205
R1181 VSS.n276 VSS.n273 11.5205
R1182 VSS.n273 VSS.n272 11.5205
R1183 VSS.n272 VSS.n269 11.5205
R1184 VSS.n269 VSS.n268 11.5205
R1185 VSS.n200 VSS.n142 11.5205
R1186 VSS.n200 VSS.n130 11.5205
R1187 VSS.n204 VSS.n130 11.5205
R1188 VSS.n204 VSS.n122 11.5205
R1189 VSS.n217 VSS.n122 11.5205
R1190 VSS.n217 VSS.n110 11.5205
R1191 VSS.n223 VSS.n110 11.5205
R1192 VSS.n223 VSS.n100 11.5205
R1193 VSS.n235 VSS.n100 11.5205
R1194 VSS.n235 VSS.n87 11.5205
R1195 VSS.n253 VSS.n87 11.5205
R1196 VSS.n253 VSS.n88 11.5205
R1197 VSS.n88 VSS.n79 11.5205
R1198 VSS.n79 VSS.n77 11.5205
R1199 VSS.n192 VSS.n148 11.5205
R1200 VSS.n187 VSS.n148 11.5205
R1201 VSS.n187 VSS.n186 11.5205
R1202 VSS.n186 VSS.n185 11.5205
R1203 VSS.n185 VSS.n182 11.5205
R1204 VSS.n182 VSS.n181 11.5205
R1205 VSS.n181 VSS.n178 11.5205
R1206 VSS.n178 VSS.n177 11.5205
R1207 VSS.n177 VSS.n174 11.5205
R1208 VSS.n174 VSS.n173 11.5205
R1209 VSS.n173 VSS.n170 11.5205
R1210 VSS.n170 VSS.n169 11.5205
R1211 VSS.n196 VSS.n146 11.5205
R1212 VSS.n196 VSS.n127 11.5205
R1213 VSS.n209 VSS.n127 11.5205
R1214 VSS.n209 VSS.n125 11.5205
R1215 VSS.n213 VSS.n125 11.5205
R1216 VSS.n213 VSS.n106 11.5205
R1217 VSS.n227 VSS.n106 11.5205
R1218 VSS.n227 VSS.n104 11.5205
R1219 VSS.n231 VSS.n104 11.5205
R1220 VSS.n231 VSS.n83 11.5205
R1221 VSS.n257 VSS.n83 11.5205
R1222 VSS.n257 VSS.n81 11.5205
R1223 VSS.n262 VSS.n81 11.5205
R1224 VSS.n262 VSS.n63 11.5205
R1225 VSS.n341 VSS.n52 11.5205
R1226 VSS.n341 VSS.n50 11.5205
R1227 VSS.n345 VSS.n50 11.5205
R1228 VSS.n345 VSS.n46 11.5205
R1229 VSS.n351 VSS.n46 11.5205
R1230 VSS.n351 VSS.n44 11.5205
R1231 VSS.n355 VSS.n44 11.5205
R1232 VSS.n355 VSS.n39 11.5205
R1233 VSS.n361 VSS.n39 11.5205
R1234 VSS.n361 VSS.n36 11.5205
R1235 VSS.n402 VSS.n36 11.5205
R1236 VSS.n397 VSS.n37 11.5205
R1237 VSS.n397 VSS.n396 11.5205
R1238 VSS.n396 VSS.n395 11.5205
R1239 VSS.n395 VSS.n369 11.5205
R1240 VSS.n391 VSS.n369 11.5205
R1241 VSS.n391 VSS.n390 11.5205
R1242 VSS.n390 VSS.n389 11.5205
R1243 VSS.n389 VSS.n376 11.5205
R1244 VSS.n385 VSS.n376 11.5205
R1245 VSS.n385 VSS.n384 11.5205
R1246 VSS.n384 VSS.n30 11.5205
R1247 VSS.n407 VSS.n30 11.5205
R1248 VSS.n428 VSS.n427 11.5205
R1249 VSS.n427 VSS.n426 11.5205
R1250 VSS.n426 VSS.n7 11.5205
R1251 VSS.n421 VSS.n7 11.5205
R1252 VSS.n421 VSS.n420 11.5205
R1253 VSS.n420 VSS.n419 11.5205
R1254 VSS.n419 VSS.n12 11.5205
R1255 VSS.n415 VSS.n12 11.5205
R1256 VSS.n415 VSS.n414 11.5205
R1257 VSS.n414 VSS.n413 11.5205
R1258 VSS.n413 VSS.n17 11.5205
R1259 VSS.n333 VSS.n301 11.5205
R1260 VSS.n329 VSS.n301 11.5205
R1261 VSS.n329 VSS.n328 11.5205
R1262 VSS.n328 VSS.n327 11.5205
R1263 VSS.n327 VSS.n306 11.5205
R1264 VSS.n323 VSS.n306 11.5205
R1265 VSS.n323 VSS.n322 11.5205
R1266 VSS.n322 VSS.n321 11.5205
R1267 VSS.n321 VSS.n312 11.5205
R1268 VSS.n317 VSS.n312 11.5205
R1269 VSS.n317 VSS.n316 11.5205
R1270 VSS.n316 VSS.n3 11.5205
R1271 VSS.n139 VSS.n132 9.39327
R1272 VSS.n119 VSS.n112 9.39327
R1273 VSS.n97 VSS.n90 9.39327
R1274 VSS.n246 VSS.n239 9.39327
R1275 VSS.n137 VSS.n136 9.3005
R1276 VSS.n132 VSS.n131 9.3005
R1277 VSS.n117 VSS.n116 9.3005
R1278 VSS.n112 VSS.n111 9.3005
R1279 VSS.n95 VSS.n94 9.3005
R1280 VSS.n90 VSS.n89 9.3005
R1281 VSS.n244 VSS.n243 9.3005
R1282 VSS.n239 VSS.n238 9.3005
R1283 VSS.n24 VSS.n23 9.3005
R1284 VSS.n19 VSS.n18 9.3005
R1285 VSS.n268 VSS.n76 9.3005
R1286 VSS.n269 VSS.n75 9.3005
R1287 VSS.n272 VSS.n74 9.3005
R1288 VSS.n273 VSS.n73 9.3005
R1289 VSS.n276 VSS.n72 9.3005
R1290 VSS.n277 VSS.n71 9.3005
R1291 VSS.n280 VSS.n70 9.3005
R1292 VSS.n281 VSS.n69 9.3005
R1293 VSS.n284 VSS.n68 9.3005
R1294 VSS.n285 VSS.n67 9.3005
R1295 VSS.n288 VSS.n66 9.3005
R1296 VSS.n289 VSS.n65 9.3005
R1297 VSS.n290 VSS.n64 9.3005
R1298 VSS.n193 VSS.n192 9.3005
R1299 VSS.n148 VSS.n147 9.3005
R1300 VSS.n187 VSS.n156 9.3005
R1301 VSS.n186 VSS.n157 9.3005
R1302 VSS.n185 VSS.n158 9.3005
R1303 VSS.n182 VSS.n159 9.3005
R1304 VSS.n181 VSS.n160 9.3005
R1305 VSS.n178 VSS.n161 9.3005
R1306 VSS.n177 VSS.n162 9.3005
R1307 VSS.n174 VSS.n163 9.3005
R1308 VSS.n173 VSS.n164 9.3005
R1309 VSS.n170 VSS.n165 9.3005
R1310 VSS.n169 VSS.n167 9.3005
R1311 VSS.n194 VSS.n146 9.3005
R1312 VSS.n196 VSS.n195 9.3005
R1313 VSS.n127 VSS.n126 9.3005
R1314 VSS.n210 VSS.n209 9.3005
R1315 VSS.n211 VSS.n125 9.3005
R1316 VSS.n213 VSS.n212 9.3005
R1317 VSS.n106 VSS.n105 9.3005
R1318 VSS.n228 VSS.n227 9.3005
R1319 VSS.n229 VSS.n104 9.3005
R1320 VSS.n231 VSS.n230 9.3005
R1321 VSS.n83 VSS.n82 9.3005
R1322 VSS.n258 VSS.n257 9.3005
R1323 VSS.n259 VSS.n81 9.3005
R1324 VSS.n262 VSS.n261 9.3005
R1325 VSS.n260 VSS.n63 9.3005
R1326 VSS.n408 VSS.n407 9.3005
R1327 VSS.n30 VSS.n29 9.3005
R1328 VSS.n384 VSS.n377 9.3005
R1329 VSS.n386 VSS.n385 9.3005
R1330 VSS.n387 VSS.n376 9.3005
R1331 VSS.n389 VSS.n388 9.3005
R1332 VSS.n390 VSS.n28 9.3005
R1333 VSS.n392 VSS.n391 9.3005
R1334 VSS.n393 VSS.n369 9.3005
R1335 VSS.n395 VSS.n394 9.3005
R1336 VSS.n396 VSS.n364 9.3005
R1337 VSS.n398 VSS.n397 9.3005
R1338 VSS.n399 VSS.n37 9.3005
R1339 VSS.n333 VSS.n332 9.3005
R1340 VSS.n331 VSS.n301 9.3005
R1341 VSS.n330 VSS.n329 9.3005
R1342 VSS.n328 VSS.n302 9.3005
R1343 VSS.n327 VSS.n326 9.3005
R1344 VSS.n325 VSS.n306 9.3005
R1345 VSS.n324 VSS.n323 9.3005
R1346 VSS.n322 VSS.n307 9.3005
R1347 VSS.n321 VSS.n320 9.3005
R1348 VSS.n319 VSS.n312 9.3005
R1349 VSS.n318 VSS.n317 9.3005
R1350 VSS.n316 VSS.n313 9.3005
R1351 VSS.n3 VSS.n1 9.3005
R1352 VSS.n52 VSS.n51 9.3005
R1353 VSS.n342 VSS.n341 9.3005
R1354 VSS.n343 VSS.n50 9.3005
R1355 VSS.n345 VSS.n344 9.3005
R1356 VSS.n46 VSS.n45 9.3005
R1357 VSS.n352 VSS.n351 9.3005
R1358 VSS.n353 VSS.n44 9.3005
R1359 VSS.n355 VSS.n354 9.3005
R1360 VSS.n39 VSS.n38 9.3005
R1361 VSS.n362 VSS.n361 9.3005
R1362 VSS.n363 VSS.n36 9.3005
R1363 VSS.n402 VSS.n401 9.3005
R1364 VSS.n201 VSS.n200 9.3005
R1365 VSS.n202 VSS.n130 9.3005
R1366 VSS.n204 VSS.n203 9.3005
R1367 VSS.n122 VSS.n121 9.3005
R1368 VSS.n218 VSS.n217 9.3005
R1369 VSS.n220 VSS.n110 9.3005
R1370 VSS.n223 VSS.n222 9.3005
R1371 VSS.n221 VSS.n100 9.3005
R1372 VSS.n236 VSS.n235 9.3005
R1373 VSS.n237 VSS.n87 9.3005
R1374 VSS.n253 VSS.n252 9.3005
R1375 VSS.n251 VSS.n88 9.3005
R1376 VSS.n250 VSS.n79 9.3005
R1377 VSS.n248 VSS.n77 9.3005
R1378 VSS.n166 VSS.n142 9.3005
R1379 VSS.n410 VSS.n17 9.3005
R1380 VSS.n413 VSS.n412 9.3005
R1381 VSS.n414 VSS.n13 9.3005
R1382 VSS.n416 VSS.n415 9.3005
R1383 VSS.n417 VSS.n12 9.3005
R1384 VSS.n419 VSS.n418 9.3005
R1385 VSS.n420 VSS.n8 9.3005
R1386 VSS.n422 VSS.n421 9.3005
R1387 VSS.n424 VSS.n7 9.3005
R1388 VSS.n426 VSS.n425 9.3005
R1389 VSS.n427 VSS.n2 9.3005
R1390 VSS.n429 VSS.n428 9.3005
R1391 VSS.n26 VSS.n19 9.2683
R1392 VSS.n135 VSS.n134 6.33109
R1393 VSS.n115 VSS.n114 6.33109
R1394 VSS.n93 VSS.n92 6.33109
R1395 VSS.n242 VSS.n241 6.33109
R1396 VSS.n22 VSS.n21 6.30777
R1397 VSS.n400 VSS.n28 2.1255
R1398 VSS.n409 VSS.n28 2.1255
R1399 VSS.n23 VSS.n22 1.18676
R1400 VSS.n136 VSS.n135 1.09351
R1401 VSS.n116 VSS.n115 1.09351
R1402 VSS.n94 VSS.n93 1.09351
R1403 VSS.n243 VSS.n242 1.09351
R1404 VSS.n411 VSS.n27 0.329204
R1405 VSS.n400 VSS.n399 0.318937
R1406 VSS.n409 VSS.n408 0.300188
R1407 VSS.n332 VSS.n51 0.292688
R1408 VSS.n194 VSS.n193 0.272375
R1409 VSS.n260 VSS.n64 0.272375
R1410 VSS VSS.n431 0.210312
R1411 VSS.n141 VSS.n140 0.206056
R1412 VSS.n219 VSS.n120 0.206056
R1413 VSS.n99 VSS.n98 0.206056
R1414 VSS.n249 VSS.n247 0.206056
R1415 VSS.n399 VSS.n398 0.1805
R1416 VSS.n398 VSS.n364 0.1805
R1417 VSS.n394 VSS.n364 0.1805
R1418 VSS.n394 VSS.n393 0.1805
R1419 VSS.n393 VSS.n392 0.1805
R1420 VSS.n392 VSS.n28 0.1805
R1421 VSS.n388 VSS.n28 0.1805
R1422 VSS.n388 VSS.n387 0.1805
R1423 VSS.n387 VSS.n386 0.1805
R1424 VSS.n386 VSS.n377 0.1805
R1425 VSS.n377 VSS.n29 0.1805
R1426 VSS.n408 VSS.n29 0.1805
R1427 VSS.n23 VSS.n18 0.167167
R1428 VSS.n27 VSS.n18 0.167167
R1429 VSS.n431 VSS.n430 0.153625
R1430 VSS.n167 VSS.n166 0.152375
R1431 VSS.n401 VSS.n400 0.13175
R1432 VSS.n76 VSS.n0 0.122375
R1433 VSS.n430 VSS.n1 0.122375
R1434 VSS.n193 VSS.n147 0.113
R1435 VSS.n156 VSS.n147 0.113
R1436 VSS.n157 VSS.n156 0.113
R1437 VSS.n158 VSS.n157 0.113
R1438 VSS.n159 VSS.n158 0.113
R1439 VSS.n160 VSS.n159 0.113
R1440 VSS.n161 VSS.n160 0.113
R1441 VSS.n162 VSS.n161 0.113
R1442 VSS.n163 VSS.n162 0.113
R1443 VSS.n164 VSS.n163 0.113
R1444 VSS.n165 VSS.n164 0.113
R1445 VSS.n167 VSS.n165 0.113
R1446 VSS.n195 VSS.n194 0.113
R1447 VSS.n195 VSS.n126 0.113
R1448 VSS.n210 VSS.n126 0.113
R1449 VSS.n211 VSS.n210 0.113
R1450 VSS.n212 VSS.n211 0.113
R1451 VSS.n212 VSS.n105 0.113
R1452 VSS.n228 VSS.n105 0.113
R1453 VSS.n229 VSS.n228 0.113
R1454 VSS.n230 VSS.n229 0.113
R1455 VSS.n230 VSS.n82 0.113
R1456 VSS.n258 VSS.n82 0.113
R1457 VSS.n259 VSS.n258 0.113
R1458 VSS.n261 VSS.n259 0.113
R1459 VSS.n261 VSS.n260 0.113
R1460 VSS.n65 VSS.n64 0.113
R1461 VSS.n66 VSS.n65 0.113
R1462 VSS.n67 VSS.n66 0.113
R1463 VSS.n68 VSS.n67 0.113
R1464 VSS.n69 VSS.n68 0.113
R1465 VSS.n70 VSS.n69 0.113
R1466 VSS.n71 VSS.n70 0.113
R1467 VSS.n72 VSS.n71 0.113
R1468 VSS.n73 VSS.n72 0.113
R1469 VSS.n74 VSS.n73 0.113
R1470 VSS.n75 VSS.n74 0.113
R1471 VSS.n76 VSS.n75 0.113
R1472 VSS.n332 VSS.n331 0.113
R1473 VSS.n331 VSS.n330 0.113
R1474 VSS.n330 VSS.n302 0.113
R1475 VSS.n326 VSS.n302 0.113
R1476 VSS.n326 VSS.n325 0.113
R1477 VSS.n325 VSS.n324 0.113
R1478 VSS.n324 VSS.n307 0.113
R1479 VSS.n320 VSS.n307 0.113
R1480 VSS.n320 VSS.n319 0.113
R1481 VSS.n319 VSS.n318 0.113
R1482 VSS.n318 VSS.n313 0.113
R1483 VSS.n313 VSS.n1 0.113
R1484 VSS.n342 VSS.n51 0.113
R1485 VSS.n343 VSS.n342 0.113
R1486 VSS.n344 VSS.n343 0.113
R1487 VSS.n344 VSS.n45 0.113
R1488 VSS.n352 VSS.n45 0.113
R1489 VSS.n353 VSS.n352 0.113
R1490 VSS.n354 VSS.n353 0.113
R1491 VSS.n354 VSS.n38 0.113
R1492 VSS.n362 VSS.n38 0.113
R1493 VSS.n363 VSS.n362 0.113
R1494 VSS.n401 VSS.n363 0.113
R1495 VSS.n136 VSS.n131 0.1005
R1496 VSS.n140 VSS.n131 0.1005
R1497 VSS.n116 VSS.n111 0.1005
R1498 VSS.n120 VSS.n111 0.1005
R1499 VSS.n94 VSS.n89 0.1005
R1500 VSS.n98 VSS.n89 0.1005
R1501 VSS.n243 VSS.n238 0.1005
R1502 VSS.n247 VSS.n238 0.1005
R1503 VSS.n431 VSS.n0 0.059875
R1504 VSS.n430 VSS.n429 0.0345625
R1505 VSS.n248 VSS.n0 0.0305
R1506 VSS.n410 VSS.n409 0.02675
R1507 VSS.n202 VSS.n201 0.023
R1508 VSS.n203 VSS.n202 0.023
R1509 VSS.n203 VSS.n121 0.023
R1510 VSS.n218 VSS.n121 0.023
R1511 VSS.n222 VSS.n220 0.023
R1512 VSS.n222 VSS.n221 0.023
R1513 VSS.n237 VSS.n236 0.023
R1514 VSS.n252 VSS.n237 0.023
R1515 VSS.n252 VSS.n251 0.023
R1516 VSS.n251 VSS.n250 0.023
R1517 VSS.n429 VSS.n2 0.023
R1518 VSS.n425 VSS.n2 0.023
R1519 VSS.n425 VSS.n424 0.023
R1520 VSS.n422 VSS.n8 0.023
R1521 VSS.n418 VSS.n8 0.023
R1522 VSS.n418 VSS.n417 0.023
R1523 VSS.n417 VSS.n416 0.023
R1524 VSS.n416 VSS.n13 0.023
R1525 VSS.n412 VSS.n13 0.023
R1526 VSS.n166 VSS.n141 0.0205
R1527 VSS.n249 VSS.n248 0.0205
R1528 VSS.n423 VSS.n422 0.0183125
R1529 VSS.n411 VSS.n410 0.0164375
R1530 VSS.n220 VSS.n219 0.0155
R1531 VSS.n221 VSS.n99 0.0155
R1532 VSS.n219 VSS.n218 0.008
R1533 VSS.n236 VSS.n99 0.008
R1534 VSS.n412 VSS.n411 0.0070625
R1535 VSS.n424 VSS.n423 0.0051875
R1536 VSS.n201 VSS.n141 0.003
R1537 VSS.n250 VSS.n249 0.003
C0 in ctrl 1.08218f
C1 A B 1.89152f
C2 VAPWR VDD 0.53319f
C3 VDD ctrl_n 0.84745f
C4 A VDD 0.00376f
C5 VAPWR in 0.00123f
C6 ctrl_n in 0.00202f
C7 A in 0
C8 VAPWR ctrl 0.06923f
C9 ctrl_n ctrl 1.66393f
C10 A ctrl 0.87133f
C11 VAPWR ctrl_n 0.02059f
C12 A VAPWR 1.56265f
C13 A ctrl_n 0.51938f
C14 B VDD 0.01623f
C15 B in 0.00655f
C16 B ctrl 0.14738f
C17 VDD in 1.09861f
C18 VDD ctrl 3.08428f
C19 B VAPWR 1.86607f
C20 B ctrl_n 0.70117f
C21 A VSS 1.48174f
C22 B VSS 1.46474f
C23 in VSS 0.85029f
C24 VAPWR VSS 8.71401f
C25 VDD VSS 7.85173f
C26 ctrl_n VSS 2.54945f
C27 ctrl VSS 3.18315f
C28 VDD.t7 VSS 0.02743f
C29 VDD.n0 VSS 0.06908f
C30 VDD.n1 VSS 0.03516f
C31 VDD.n2 VSS 0.00703f
C32 VDD.n3 VSS 0.00703f
C33 VDD.n4 VSS 0.00703f
C34 VDD.n5 VSS 0.00703f
C35 VDD.n6 VSS 0.00703f
C36 VDD.t5 VSS 0.01099f
C37 VDD.t3 VSS 0.01099f
C38 VDD.n7 VSS 0.02291f
C39 VDD.n8 VSS 0.03516f
C40 VDD.n9 VSS 0.00703f
C41 VDD.n10 VSS 0.00703f
C42 VDD.n11 VSS 0.00703f
C43 VDD.n12 VSS 0.01428f
C44 VDD.n13 VSS 0.00475f
C45 VDD.n14 VSS 0.00299f
C46 VDD.n15 VSS 0.00396f
C47 VDD.n16 VSS 0.00335f
C48 VDD.t1 VSS 0.00979f
C49 VDD.n17 VSS 0.01605f
C50 VDD.n18 VSS 0.03694f
C51 VDD.n19 VSS 0.00299f
C52 VDD.n20 VSS 0.01094f
C53 VDD.n21 VSS 0.00573f
C54 VDD.n22 VSS 0.00995f
C55 VDD.n23 VSS 0.02307f
C56 VDD.n24 VSS 0.00439f
C57 VDD.n25 VSS 0.01492f
C58 VDD.n26 VSS 0.00703f
C59 VDD.n27 VSS 0.00703f
C60 VDD.n28 VSS 0.00703f
C61 VDD.n29 VSS 0.00439f
C62 VDD.n30 VSS 0.00703f
C63 VDD.n31 VSS 0.00703f
C64 VDD.n32 VSS 0.00703f
C65 VDD.n33 VSS 0.00703f
C66 VDD.n34 VSS 0.00703f
C67 VDD.n35 VSS 0.00439f
C68 VDD.n36 VSS 0.00703f
C69 VDD.n37 VSS 0.00703f
C70 VDD.n38 VSS 0.00703f
C71 VDD.n39 VSS 0.01492f
C72 VDD.n40 VSS 0.00703f
C73 VDD.n41 VSS 0.00703f
C74 VDD.n42 VSS 0.00703f
C75 VDD.n43 VSS 0.01492f
C76 VDD.t2 VSS 0.06065f
C77 VDD.n44 VSS 0.00703f
C78 VDD.n45 VSS 0.00703f
C79 VDD.n46 VSS 0.00703f
C80 VDD.n47 VSS 0.00703f
C81 VDD.n48 VSS 0.00703f
C82 VDD.n49 VSS 0.1213f
C83 VDD.n50 VSS 0.00703f
C84 VDD.n51 VSS 0.00703f
C85 VDD.n52 VSS 0.00703f
C86 VDD.n53 VSS 0.00703f
C87 VDD.n54 VSS 0.00703f
C88 VDD.t6 VSS 0.06065f
C89 VDD.n55 VSS 0.00703f
C90 VDD.n56 VSS 0.00703f
C91 VDD.n57 VSS 0.15247f
C92 VDD.n58 VSS 0.01428f
C93 VDD.n59 VSS 0.01428f
C94 VDD.n60 VSS 0.00703f
C95 VDD.n61 VSS 0.00703f
C96 VDD.n62 VSS 0.00703f
C97 VDD.n67 VSS 0.00703f
C98 VDD.n68 VSS 0.00703f
C99 VDD.n69 VSS 0.01428f
C100 VDD.n70 VSS 0.01428f
C101 VDD.n71 VSS 0.00703f
C102 VDD.t9 VSS 0.02743f
C103 VDD.n72 VSS 0.02124f
C104 VDD.n73 VSS 0.03516f
C105 VDD.n74 VSS 0.00703f
C106 VDD.n75 VSS 0.02271f
C107 VDD.n76 VSS 0.07811f
C108 VDD.n77 VSS 0.16971f
C109 VDD.n78 VSS 0.00703f
C110 VDD.n79 VSS 0.00703f
C111 VDD.n80 VSS 0.00703f
C112 VDD.n81 VSS 0.00703f
C113 VDD.n82 VSS 0.00703f
C114 VDD.n83 VSS 0.00703f
C115 VDD.n84 VSS 0.00703f
C116 VDD.n85 VSS 0.00703f
C117 VDD.n86 VSS 0.00703f
C118 VDD.n87 VSS 0.00703f
C119 VDD.n88 VSS 0.00703f
C120 VDD.n89 VSS 0.00703f
C121 VDD.n90 VSS 0.00703f
C122 VDD.n91 VSS 0.00703f
C123 VDD.n92 VSS 0.00703f
C124 VDD.n93 VSS 0.00703f
C125 VDD.n94 VSS 0.00703f
C126 VDD.n95 VSS 0.00703f
C127 VDD.n96 VSS 0.00703f
C128 VDD.n97 VSS 0.00703f
C129 VDD.n98 VSS 0.00703f
C130 VDD.n99 VSS 0.00703f
C131 VDD.n100 VSS 0.00703f
C132 VDD.n101 VSS 0.00703f
C133 VDD.n102 VSS 0.00703f
C134 VDD.n103 VSS 0.00703f
C135 VDD.n104 VSS 0.00703f
C136 VDD.n105 VSS 0.04384f
C137 VDD.n106 VSS 0.01492f
C138 VDD.n107 VSS 0.01492f
C139 VDD.n109 VSS 0.32768f
C140 VDD.n111 VSS 0.01492f
C141 VDD.n112 VSS 0.01492f
C142 VDD.n113 VSS 0.01492f
C143 VDD.n114 VSS 0.01428f
C144 VDD.n115 VSS 0.00703f
C145 VDD.n116 VSS 0.00703f
C146 VDD.n117 VSS 0.00703f
C147 VDD.n118 VSS 0.08087f
C148 VDD.t8 VSS 0.06065f
C149 VDD.n119 VSS 0.07581f
C150 VDD.n120 VSS 0.00703f
C151 VDD.n121 VSS 0.00703f
C152 VDD.n122 VSS 0.08592f
C153 VDD.n123 VSS 0.00703f
C154 VDD.n124 VSS 0.00703f
C155 VDD.n125 VSS 0.00703f
C156 VDD.n126 VSS 0.00703f
C157 VDD.n127 VSS 0.00703f
C158 VDD.n128 VSS 0.00703f
C159 VDD.n129 VSS 0.00703f
C160 VDD.n130 VSS 0.1213f
C161 VDD.n131 VSS 0.1213f
C162 VDD.n132 VSS 0.07581f
C163 VDD.t4 VSS 0.06065f
C164 VDD.n133 VSS 0.00703f
C165 VDD.n134 VSS 0.07076f
C166 VDD.n135 VSS 0.00703f
C167 VDD.n136 VSS 0.00703f
C168 VDD.n137 VSS 0.00703f
C169 VDD.n138 VSS 0.00703f
C170 VDD.n139 VSS 0.00703f
C171 VDD.n140 VSS 0.00703f
C172 VDD.n141 VSS 0.00703f
C173 VDD.n142 VSS 0.07581f
C174 VDD.t0 VSS 0.06065f
C175 VDD.n143 VSS 0.08087f
C176 VDD.n146 VSS 0.00703f
C177 VDD.n149 VSS 0.00703f
C178 VDD.n152 VSS 0.32768f
C179 VDD.n153 VSS 0.01428f
C180 VDD.n154 VSS 0.15247f
C181 VDD.n155 VSS 0.01428f
C182 VDD.n156 VSS 0.01428f
C183 VDD.n157 VSS 0.00762f
C184 VDD.n158 VSS 0.02045f
C185 VDD.n159 VSS 0.0063f
C186 VDD.n160 VSS 0.00439f
C187 VDD.n161 VSS 0.00703f
C188 VDD.n162 VSS 0.00703f
C189 VDD.n163 VSS 0.00703f
C190 VDD.n164 VSS 0.00439f
C191 VDD.n165 VSS 0.00439f
C192 VDD.n166 VSS 0.00439f
C193 VDD.n167 VSS 0.00703f
C194 VDD.n168 VSS 0.00703f
C195 VDD.n169 VSS 0.00703f
C196 VDD.n170 VSS 0.00703f
C197 VDD.n171 VSS 0.00439f
C198 VDD.n172 VSS 0.00439f
C199 VDD.n173 VSS 0.00439f
C200 VDD.n174 VSS 0.00703f
C201 VDD.n175 VSS 0.00703f
C202 VDD.n176 VSS 0.01492f
C203 VDD.n177 VSS 0.00595f
C204 VDD.n178 VSS 0.04307f
C205 VDD.n179 VSS 0.03296f
C206 VDD.n180 VSS 0.02226f
C207 VDD.n181 VSS 0.02271f
C208 VDD.n182 VSS 0.00703f
C209 VDD.n183 VSS 0.00703f
C210 VDD.n184 VSS 0.00703f
C211 VDD.n185 VSS 0.02124f
C212 VDD.n186 VSS 0.0848f
C213 VDD.n187 VSS 0.0315f
C214 VDD.n188 VSS 0.03516f
C215 VDD.n189 VSS 0.00703f
C216 VDD.n190 VSS 0.00703f
C217 VDD.n191 VSS 0.00703f
C218 VDD.n192 VSS 0.02661f
C219 VDD.n193 VSS 0.71504f
C220 VAPWR.n0 VSS 0.01377f
C221 VAPWR.t7 VSS 0.01035f
C222 VAPWR.n1 VSS 0.02203f
C223 VAPWR.n2 VSS 0.00441f
C224 VAPWR.n3 VSS 0.00441f
C225 VAPWR.n4 VSS 0.00441f
C226 VAPWR.n5 VSS 0.00441f
C227 VAPWR.n6 VSS 0.00441f
C228 VAPWR.t5 VSS 0.01035f
C229 VAPWR.n7 VSS 0.06908f
C230 VAPWR.n8 VSS 0.00441f
C231 VAPWR.n9 VSS 0.00863f
C232 VAPWR.n10 VSS 0.00888f
C233 VAPWR.n11 VSS 0.00441f
C234 VAPWR.n12 VSS 0.00441f
C235 VAPWR.n13 VSS 0.00441f
C236 VAPWR.n14 VSS 0.00441f
C237 VAPWR.n15 VSS 0.00441f
C238 VAPWR.n16 VSS 0.00441f
C239 VAPWR.n17 VSS 0.00441f
C240 VAPWR.n18 VSS 0.00441f
C241 VAPWR.n19 VSS 0.00441f
C242 VAPWR.n20 VSS 0.00441f
C243 VAPWR.n21 VSS 0.00441f
C244 VAPWR.n22 VSS 0.00441f
C245 VAPWR.n23 VSS 0.00441f
C246 VAPWR.n24 VSS 0.00441f
C247 VAPWR.n25 VSS 0.00888f
C248 VAPWR.n26 VSS 0.00441f
C249 VAPWR.n27 VSS 0.00441f
C250 VAPWR.n28 VSS 0.00441f
C251 VAPWR.n29 VSS 0.00888f
C252 VAPWR.n30 VSS 0.07601f
C253 VAPWR.n31 VSS 0.00441f
C254 VAPWR.n32 VSS 0.00441f
C255 VAPWR.n33 VSS 0.00441f
C256 VAPWR.n34 VSS 0.00441f
C257 VAPWR.n35 VSS 0.00441f
C258 VAPWR.n36 VSS 0.07601f
C259 VAPWR.n37 VSS 0.00441f
C260 VAPWR.n38 VSS 0.00441f
C261 VAPWR.n39 VSS 0.00441f
C262 VAPWR.t1 VSS 0.01035f
C263 VAPWR.n40 VSS 0.02203f
C264 VAPWR.n41 VSS 0.00441f
C265 VAPWR.n42 VSS 0.00441f
C266 VAPWR.t0 VSS 0.03801f
C267 VAPWR.n43 VSS 0.00441f
C268 VAPWR.n44 VSS 0.00441f
C269 VAPWR.n45 VSS 0.00441f
C270 VAPWR.n46 VSS 0.00441f
C271 VAPWR.n47 VSS 0.00441f
C272 VAPWR.n48 VSS 0.00441f
C273 VAPWR.n49 VSS 0.00441f
C274 VAPWR.t2 VSS 0.07601f
C275 VAPWR.n50 VSS 0.00441f
C276 VAPWR.n51 VSS 0.00441f
C277 VAPWR.t3 VSS 0.01035f
C278 VAPWR.n52 VSS 0.06908f
C279 VAPWR.n53 VSS 0.00863f
C280 VAPWR.n54 VSS 0.00863f
C281 VAPWR.n55 VSS 0.08868f
C282 VAPWR.n56 VSS 0.00863f
C283 VAPWR.n57 VSS 0.00441f
C284 VAPWR.n58 VSS 0.00863f
C285 VAPWR.n59 VSS 0.00441f
C286 VAPWR.n60 VSS 0.00441f
C287 VAPWR.n61 VSS 0.00441f
C288 VAPWR.n62 VSS 0.00441f
C289 VAPWR.n67 VSS 0.00441f
C290 VAPWR.n68 VSS 0.00441f
C291 VAPWR.n69 VSS 0.00441f
C292 VAPWR.n70 VSS 0.06274f
C293 VAPWR.n71 VSS 0.00441f
C294 VAPWR.n72 VSS 0.00441f
C295 VAPWR.n73 VSS 0.00441f
C296 VAPWR.n74 VSS 0.00441f
C297 VAPWR.n75 VSS 0.00441f
C298 VAPWR.n76 VSS 0.00441f
C299 VAPWR.n77 VSS 0.00441f
C300 VAPWR.n78 VSS 0.00441f
C301 VAPWR.n79 VSS 0.00441f
C302 VAPWR.n80 VSS 0.00441f
C303 VAPWR.n81 VSS 0.00441f
C304 VAPWR.n82 VSS 0.00441f
C305 VAPWR.n83 VSS 0.00441f
C306 VAPWR.n84 VSS 0.00441f
C307 VAPWR.n85 VSS 0.00441f
C308 VAPWR.n86 VSS 0.00441f
C309 VAPWR.n87 VSS 0.00441f
C310 VAPWR.n88 VSS 0.00441f
C311 VAPWR.n89 VSS 0.00441f
C312 VAPWR.n90 VSS 0.00441f
C313 VAPWR.n91 VSS 0.00441f
C314 VAPWR.n92 VSS 0.00441f
C315 VAPWR.n93 VSS 0.00441f
C316 VAPWR.n94 VSS 0.00441f
C317 VAPWR.n95 VSS 0.00441f
C318 VAPWR.n96 VSS 0.00441f
C319 VAPWR.n97 VSS 0.00441f
C320 VAPWR.n98 VSS 0.01401f
C321 VAPWR.n99 VSS 0.00888f
C322 VAPWR.n100 VSS 0.00888f
C323 VAPWR.n102 VSS 0.19848f
C324 VAPWR.n104 VSS 0.00888f
C325 VAPWR.n105 VSS 0.00888f
C326 VAPWR.n106 VSS 0.00888f
C327 VAPWR.n107 VSS 0.00863f
C328 VAPWR.n108 VSS 0.00441f
C329 VAPWR.n109 VSS 0.00441f
C330 VAPWR.n110 VSS 0.00441f
C331 VAPWR.n111 VSS 0.00441f
C332 VAPWR.n112 VSS 0.07601f
C333 VAPWR.n113 VSS 0.00441f
C334 VAPWR.n114 VSS 0.00441f
C335 VAPWR.n115 VSS 0.01224f
C336 VAPWR.n116 VSS 0.02203f
C337 VAPWR.n117 VSS 0.02203f
C338 VAPWR.n118 VSS 0.00441f
C339 VAPWR.n119 VSS 0.00441f
C340 VAPWR.n120 VSS 0.07601f
C341 VAPWR.n121 VSS 0.04645f
C342 VAPWR.n122 VSS 0.00441f
C343 VAPWR.n123 VSS 0.00441f
C344 VAPWR.n124 VSS 0.00441f
C345 VAPWR.n125 VSS 0.00441f
C346 VAPWR.n126 VSS 0.00441f
C347 VAPWR.n127 VSS 0.00441f
C348 VAPWR.n128 VSS 0.00441f
C349 VAPWR.n129 VSS 0.00441f
C350 VAPWR.n130 VSS 0.00441f
C351 VAPWR.n131 VSS 0.00441f
C352 VAPWR.n132 VSS 0.07601f
C353 VAPWR.n133 VSS 0.06757f
C354 VAPWR.n134 VSS 0.00441f
C355 VAPWR.n135 VSS 0.00441f
C356 VAPWR.n136 VSS 0.01469f
C357 VAPWR.n137 VSS 0.06908f
C358 VAPWR.n138 VSS 0.01836f
C359 VAPWR.n139 VSS 0.02203f
C360 VAPWR.n140 VSS 0.00441f
C361 VAPWR.n141 VSS 0.00441f
C362 VAPWR.n142 VSS 0.00441f
C363 VAPWR.n143 VSS 0.07601f
C364 VAPWR.n144 VSS 0.06757f
C365 VAPWR.t6 VSS 0.03801f
C366 VAPWR.n145 VSS 0.04645f
C367 VAPWR.n146 VSS 0.00441f
C368 VAPWR.n147 VSS 0.00441f
C369 VAPWR.n148 VSS 0.00441f
C370 VAPWR.n149 VSS 0.00441f
C371 VAPWR.n150 VSS 0.00441f
C372 VAPWR.n151 VSS 0.00441f
C373 VAPWR.n152 VSS 0.00441f
C374 VAPWR.n153 VSS 0.00441f
C375 VAPWR.t4 VSS 0.07601f
C376 VAPWR.n154 VSS 0.07601f
C377 VAPWR.n157 VSS 0.00441f
C378 VAPWR.n160 VSS 0.00441f
C379 VAPWR.n163 VSS 0.00888f
C380 VAPWR.n164 VSS 0.19848f
C381 VAPWR.n165 VSS 0.08868f
C382 VAPWR.n166 VSS 0.00863f
C383 VAPWR.n167 VSS 0.00863f
C384 VAPWR.n168 VSS 0.00863f
C385 VAPWR.n169 VSS 0.00888f
C386 VAPWR.n170 VSS 0.00441f
C387 VAPWR.n171 VSS 0.00441f
C388 VAPWR.n172 VSS 0.00441f
C389 VAPWR.n173 VSS 0.00441f
C390 VAPWR.n174 VSS 0.00441f
C391 VAPWR.n175 VSS 0.00441f
C392 VAPWR.n176 VSS 0.00441f
C393 VAPWR.n177 VSS 0.00441f
C394 VAPWR.n178 VSS 0.00441f
C395 VAPWR.n179 VSS 0.00441f
C396 VAPWR.n180 VSS 0.00441f
C397 VAPWR.n181 VSS 0.00441f
C398 VAPWR.n182 VSS 0.00441f
C399 VAPWR.n183 VSS 0.00441f
C400 VAPWR.n184 VSS 0.00441f
C401 VAPWR.n185 VSS 0.00441f
C402 VAPWR.n186 VSS 0.00441f
C403 VAPWR.n187 VSS 0.02489f
C404 VAPWR.n188 VSS 0.10694f
C405 VAPWR.n189 VSS 0.00863f
C406 VAPWR.n190 VSS 0.00441f
C407 VAPWR.n191 VSS 0.01224f
C408 VAPWR.n192 VSS 0.02203f
C409 VAPWR.n193 VSS 0.02203f
C410 VAPWR.n194 VSS 0.00441f
C411 VAPWR.n195 VSS 0.00441f
C412 VAPWR.n196 VSS 0.00441f
C413 VAPWR.n197 VSS 0.01469f
C414 VAPWR.n198 VSS 0.06632f
C415 VAPWR.n199 VSS 0.60682f
C416 in.t1 VSS 0.1106f
C417 in.t2 VSS 0.12535f
C418 in.n0 VSS 0.36088f
C419 in.t3 VSS 0.11059f
C420 in.n1 VSS 0.23975f
C421 in.t0 VSS 0.11192f
C422 in.n2 VSS 0.9171f
C423 in.n3 VSS 0.23176f
C424 B.t4 VSS 0.32843f
C425 B.t5 VSS 0.26236f
C426 B.n0 VSS 0.77367f
C427 B.n1 VSS 0.12612f
C428 B.n2 VSS 0.02232f
C429 B.n3 VSS 0.02071f
C430 B.t1 VSS 0.03907f
C431 B.n4 VSS 0.02664f
C432 B.t0 VSS 0.03907f
C433 B.n5 VSS 0.07831f
C434 B.n6 VSS 0.00754f
C435 B.n7 VSS 0.06261f
C436 B.n8 VSS 0.20718f
C437 B.t3 VSS 0.06836f
C438 B.t2 VSS 0.06836f
C439 B.n9 VSS 0.24398f
C440 B.n10 VSS 1.19546f
C441 B.n11 VSS 0.87926f
C442 A.t3 VSS 0.07066f
C443 A.t2 VSS 0.07066f
C444 A.n0 VSS 0.23395f
C445 A.n1 VSS 0.13035f
C446 A.n2 VSS 0.02307f
C447 A.n3 VSS 0.0214f
C448 A.t1 VSS 0.04038f
C449 A.n4 VSS 0.02753f
C450 A.t0 VSS 0.04038f
C451 A.n5 VSS 0.08093f
C452 A.n6 VSS 0.0078f
C453 A.n7 VSS 0.06471f
C454 A.n8 VSS 0.28118f
C455 A.n9 VSS 1.15503f
C456 A.t4 VSS 0.33946f
C457 A.t5 VSS 0.27117f
C458 A.n10 VSS 0.81656f
C459 A.n11 VSS 0.92238f
.ends
