* tx_ls: magic R+C extraction of layout/tx_ls.gds (layout/pex.sh)
.subckt tx_ls in A B VDD VAPWR VSS
X0 ctrl_n ctrl VDD.t7 VDD.t6 sky130_fd_pr__pfet_01v8_hvt ad=0.3 pd=2.3 as=0.6 ps=4.6 w=2 l=0.15
X1 A.t0 B.t2 VAPWR.t3 VAPWR.t2 sky130_fd_pr__pfet_g5v0d10v5 ad=0.504 pd=3.96 as=0.504 ps=3.96 w=1.68 l=0.5
X2 ctrl in.t0 VSS.t1 VSS.t0 sky130_fd_pr__nfet_01v8 ad=0.9 pd=6.6 as=0.9 ps=6.6 w=3 l=0.15
X3 B.t1 ctrl_n VSS.t3 VSS.t2 sky130_fd_pr__nfet_g5v0d10v5 ad=1.26 pd=9 as=1.26 ps=9 w=4.2 l=0.5
X4 ctrl in.t1 VDD.t5 VDD.t4 sky130_fd_pr__pfet_01v8 ad=0.9 pd=6.6 as=0.45 ps=3.3 w=3 l=0.15
X5 B.t0 A.t2 VAPWR.t1 VAPWR.t0 sky130_fd_pr__pfet_g5v0d10v5 ad=0.504 pd=3.96 as=0.504 ps=3.96 w=1.68 l=0.5
X6 ctrl_n ctrl VSS.t7 VSS.t6 sky130_fd_pr__nfet_01v8 ad=0.504 pd=3.96 as=0.504 ps=3.96 w=1.68 l=0.15
X7 VDD.t3 in.t2 ctrl VDD.t2 sky130_fd_pr__pfet_01v8 ad=0.45 pd=3.3 as=0.45 ps=3.3 w=3 l=0.15
X8 ctrl in.t3 VDD.t1 VDD.t0 sky130_fd_pr__pfet_01v8 ad=0.45 pd=3.3 as=0.9 ps=6.6 w=3 l=0.15
X9 A.t1 ctrl VSS.t5 VSS.t4 sky130_fd_pr__nfet_g5v0d10v5 ad=1.26 pd=9 as=1.26 ps=9 w=4.2 l=0.5
X10 VDD.t9 ctrl ctrl_n VDD.t8 sky130_fd_pr__pfet_01v8_hvt ad=0.6 pd=4.6 as=0.3 ps=2.3 w=2 l=0.15
R0 A.n1 A.t2 286.959
R1 A.n0 A.t0 236.319
R2 A.n0 A.t1 27.7823
R3 A.n1 A.n0 3.55667
R4 A A.n1 0.11659
R5 B.n1 B.t2 286.522
R6 B.n0 B.t0 235.651
R7 B.n0 B.t1 28.449
R8 B.n1 B.n0 3.4105
R9 B B.n1 0.07476
R10 in.n0 in.t2 961.957
R11 in.n2 in.t0 743.15
R12 in.n0 in.t1 737.083
R13 in.n1 in.t3 737.023
R14 in in.n2 3.49886
R15 in.n2 in.n1 2.99947
R16 in.n1 in.n0 0.0609839
R17 VAPWR.n7 VAPWR.t3 230.542
R18 VAPWR.n114 VAPWR.t1 230.542
R19 VAPWR.n141 VAPWR.n9 225.15
R20 VAPWR.n143 VAPWR.n24 225.15
R21 VAPWR.n74 VAPWR.n73 225.15
R22 VAPWR.n48 VAPWR.n45 225.15
R23 VAPWR.n46 VAPWR.n45 185
R24 VAPWR.n45 VAPWR.n44 185
R25 VAPWR.n99 VAPWR.n98 185
R26 VAPWR.n100 VAPWR.n99 185
R27 VAPWR.n38 VAPWR.n37 185
R28 VAPWR.n101 VAPWR.n38 185
R29 VAPWR.n112 VAPWR.n111 185
R30 VAPWR.n111 VAPWR.n110 185
R31 VAPWR.n35 VAPWR.n34 185
R32 VAPWR.n109 VAPWR.n34 185
R33 VAPWR.n118 VAPWR.n117 185
R34 VAPWR.n118 VAPWR.n32 185
R35 VAPWR.n119 VAPWR.n2 185
R36 VAPWR.n120 VAPWR.n119 185
R37 VAPWR.n169 VAPWR.n3 185
R38 VAPWR.n33 VAPWR.n3 185
R39 VAPWR.n168 VAPWR.n4 185
R40 VAPWR.n129 VAPWR.n4 185
R41 VAPWR.n167 VAPWR.n5 185
R42 VAPWR.n130 VAPWR.n5 185
R43 VAPWR.n141 VAPWR.n6 185
R44 VAPWR.n142 VAPWR.n141 185
R45 VAPWR.n94 VAPWR.n48 185
R46 VAPWR.n93 VAPWR.n49 185
R47 VAPWR.n92 VAPWR.n50 185
R48 VAPWR.n71 VAPWR.n50 185
R49 VAPWR.n64 VAPWR.n51 185
R50 VAPWR.n88 VAPWR.n53 185
R51 VAPWR.n87 VAPWR.n54 185
R52 VAPWR.n86 VAPWR.n55 185
R53 VAPWR.n67 VAPWR.n56 185
R54 VAPWR.n82 VAPWR.n58 185
R55 VAPWR.n81 VAPWR.n59 185
R56 VAPWR.n80 VAPWR.n60 185
R57 VAPWR.n63 VAPWR.n61 185
R58 VAPWR.n76 VAPWR.n73 185
R59 VAPWR.n144 VAPWR.n143 185
R60 VAPWR.n143 VAPWR.n142 185
R61 VAPWR.n26 VAPWR.n25 185
R62 VAPWR.n130 VAPWR.n26 185
R63 VAPWR.n128 VAPWR.n127 185
R64 VAPWR.n129 VAPWR.n128 185
R65 VAPWR.n28 VAPWR.n27 185
R66 VAPWR.n33 VAPWR.n27 185
R67 VAPWR.n122 VAPWR.n121 185
R68 VAPWR.n121 VAPWR.n120 185
R69 VAPWR.n31 VAPWR.n30 185
R70 VAPWR.n32 VAPWR.n31 185
R71 VAPWR.n108 VAPWR.n107 185
R72 VAPWR.n109 VAPWR.n108 185
R73 VAPWR.n40 VAPWR.n39 185
R74 VAPWR.n110 VAPWR.n39 185
R75 VAPWR.n103 VAPWR.n102 185
R76 VAPWR.n102 VAPWR.n101 185
R77 VAPWR.n43 VAPWR.n42 185
R78 VAPWR.n100 VAPWR.n43 185
R79 VAPWR.n75 VAPWR.n74 185
R80 VAPWR.n74 VAPWR.n44 185
R81 VAPWR.n145 VAPWR.n24 185
R82 VAPWR.n131 VAPWR.n22 185
R83 VAPWR.n149 VAPWR.n21 185
R84 VAPWR.n150 VAPWR.n20 185
R85 VAPWR.n151 VAPWR.n19 185
R86 VAPWR.n134 VAPWR.n17 185
R87 VAPWR.n155 VAPWR.n16 185
R88 VAPWR.n156 VAPWR.n15 185
R89 VAPWR.n157 VAPWR.n14 185
R90 VAPWR.n137 VAPWR.n12 185
R91 VAPWR.n161 VAPWR.n11 185
R92 VAPWR.n162 VAPWR.n10 185
R93 VAPWR.n163 VAPWR.n9 185
R94 VAPWR.n140 VAPWR.n9 185
R95 VAPWR.n10 VAPWR.n9 102.6
R96 VAPWR.n137 VAPWR.n11 102.6
R97 VAPWR.n15 VAPWR.n14 102.6
R98 VAPWR.n134 VAPWR.n16 102.6
R99 VAPWR.n20 VAPWR.n19 102.6
R100 VAPWR.n131 VAPWR.n21 102.6
R101 VAPWR.n74 VAPWR.n43 102.6
R102 VAPWR.n102 VAPWR.n43 102.6
R103 VAPWR.n102 VAPWR.n39 102.6
R104 VAPWR.n108 VAPWR.n39 102.6
R105 VAPWR.n108 VAPWR.n31 102.6
R106 VAPWR.n121 VAPWR.n31 102.6
R107 VAPWR.n121 VAPWR.n27 102.6
R108 VAPWR.n128 VAPWR.n27 102.6
R109 VAPWR.n128 VAPWR.n26 102.6
R110 VAPWR.n143 VAPWR.n26 102.6
R111 VAPWR.n50 VAPWR.n49 102.6
R112 VAPWR.n64 VAPWR.n50 102.6
R113 VAPWR.n54 VAPWR.n53 102.6
R114 VAPWR.n67 VAPWR.n55 102.6
R115 VAPWR.n59 VAPWR.n58 102.6
R116 VAPWR.n63 VAPWR.n60 102.6
R117 VAPWR.n99 VAPWR.n45 102.6
R118 VAPWR.n99 VAPWR.n38 102.6
R119 VAPWR.n111 VAPWR.n38 102.6
R120 VAPWR.n111 VAPWR.n34 102.6
R121 VAPWR.n118 VAPWR.n34 102.6
R122 VAPWR.n119 VAPWR.n118 102.6
R123 VAPWR.n119 VAPWR.n3 102.6
R124 VAPWR.n4 VAPWR.n3 102.6
R125 VAPWR.n5 VAPWR.n4 102.6
R126 VAPWR.n141 VAPWR.n5 102.6
R127 VAPWR.n71 VAPWR.n70 72.4195
R128 VAPWR.n71 VAPWR.n65 72.4195
R129 VAPWR.n71 VAPWR.n66 72.4195
R130 VAPWR.n71 VAPWR.n68 72.4195
R131 VAPWR.n71 VAPWR.n69 72.4195
R132 VAPWR.n72 VAPWR.n71 72.4195
R133 VAPWR.n140 VAPWR.n132 72.4195
R134 VAPWR.n140 VAPWR.n133 72.4195
R135 VAPWR.n140 VAPWR.n135 72.4195
R136 VAPWR.n140 VAPWR.n136 72.4195
R137 VAPWR.n140 VAPWR.n138 72.4195
R138 VAPWR.n140 VAPWR.n139 72.4195
R139 VAPWR.n71 VAPWR.n44 55.073
R140 VAPWR.n142 VAPWR.n140 55.073
R141 VAPWR.n100 VAPWR.n44 49.5657
R142 VAPWR.n101 VAPWR.n100 49.5657
R143 VAPWR.n110 VAPWR.n109 49.5657
R144 VAPWR.n109 VAPWR.n32 49.5657
R145 VAPWR.n120 VAPWR.n32 49.5657
R146 VAPWR.n120 VAPWR.n33 49.5657
R147 VAPWR.n130 VAPWR.n129 49.5657
R148 VAPWR.n142 VAPWR.n130 49.5657
R149 VAPWR.n139 VAPWR.n11 40.1639
R150 VAPWR.n138 VAPWR.n14 40.1639
R151 VAPWR.n136 VAPWR.n16 40.1639
R152 VAPWR.n135 VAPWR.n19 40.1639
R153 VAPWR.n133 VAPWR.n21 40.1639
R154 VAPWR.n132 VAPWR.n24 40.1639
R155 VAPWR.n70 VAPWR.n48 40.1639
R156 VAPWR.n65 VAPWR.n64 40.1639
R157 VAPWR.n66 VAPWR.n54 40.1639
R158 VAPWR.n68 VAPWR.n67 40.1639
R159 VAPWR.n69 VAPWR.n59 40.1639
R160 VAPWR.n72 VAPWR.n63 40.1639
R161 VAPWR.n70 VAPWR.n49 40.1639
R162 VAPWR.n65 VAPWR.n53 40.1639
R163 VAPWR.n66 VAPWR.n55 40.1639
R164 VAPWR.n68 VAPWR.n58 40.1639
R165 VAPWR.n69 VAPWR.n60 40.1639
R166 VAPWR.n73 VAPWR.n72 40.1639
R167 VAPWR.n132 VAPWR.n131 40.1639
R168 VAPWR.n133 VAPWR.n20 40.1639
R169 VAPWR.n135 VAPWR.n134 40.1639
R170 VAPWR.n136 VAPWR.n15 40.1639
R171 VAPWR.n138 VAPWR.n137 40.1639
R172 VAPWR.n139 VAPWR.n10 40.1639
R173 VAPWR.n110 VAPWR.t0 38.5512
R174 VAPWR.n33 VAPWR.t2 38.5512
R175 VAPWR.n94 VAPWR.n46 25.2805
R176 VAPWR.n163 VAPWR.n6 25.2805
R177 VAPWR.n76 VAPWR.n75 25.2805
R178 VAPWR.n145 VAPWR.n144 25.2805
R179 VAPWR.n98 VAPWR.n46 11.5205
R180 VAPWR.n98 VAPWR.n37 11.5205
R181 VAPWR.n112 VAPWR.n37 11.5205
R182 VAPWR.n112 VAPWR.n35 11.5205
R183 VAPWR.n117 VAPWR.n35 11.5205
R184 VAPWR.n117 VAPWR.n2 11.5205
R185 VAPWR.n169 VAPWR.n2 11.5205
R186 VAPWR.n169 VAPWR.n168 11.5205
R187 VAPWR.n168 VAPWR.n167 11.5205
R188 VAPWR.n167 VAPWR.n6 11.5205
R189 VAPWR.n94 VAPWR.n93 11.5205
R190 VAPWR.n93 VAPWR.n92 11.5205
R191 VAPWR.n92 VAPWR.n51 11.5205
R192 VAPWR.n88 VAPWR.n51 11.5205
R193 VAPWR.n88 VAPWR.n87 11.5205
R194 VAPWR.n87 VAPWR.n86 11.5205
R195 VAPWR.n86 VAPWR.n56 11.5205
R196 VAPWR.n82 VAPWR.n56 11.5205
R197 VAPWR.n82 VAPWR.n81 11.5205
R198 VAPWR.n81 VAPWR.n80 11.5205
R199 VAPWR.n80 VAPWR.n61 11.5205
R200 VAPWR.n76 VAPWR.n61 11.5205
R201 VAPWR.n75 VAPWR.n42 11.5205
R202 VAPWR.n103 VAPWR.n42 11.5205
R203 VAPWR.n103 VAPWR.n40 11.5205
R204 VAPWR.n107 VAPWR.n40 11.5205
R205 VAPWR.n107 VAPWR.n30 11.5205
R206 VAPWR.n122 VAPWR.n30 11.5205
R207 VAPWR.n122 VAPWR.n28 11.5205
R208 VAPWR.n127 VAPWR.n28 11.5205
R209 VAPWR.n127 VAPWR.n25 11.5205
R210 VAPWR.n144 VAPWR.n25 11.5205
R211 VAPWR.n163 VAPWR.n162 11.5205
R212 VAPWR.n162 VAPWR.n161 11.5205
R213 VAPWR.n161 VAPWR.n12 11.5205
R214 VAPWR.n157 VAPWR.n12 11.5205
R215 VAPWR.n157 VAPWR.n156 11.5205
R216 VAPWR.n156 VAPWR.n155 11.5205
R217 VAPWR.n155 VAPWR.n17 11.5205
R218 VAPWR.n151 VAPWR.n17 11.5205
R219 VAPWR.n151 VAPWR.n150 11.5205
R220 VAPWR.n150 VAPWR.n149 11.5205
R221 VAPWR.n149 VAPWR.n22 11.5205
R222 VAPWR.n145 VAPWR.n22 11.5205
R223 VAPWR.n101 VAPWR.t0 11.015
R224 VAPWR.n129 VAPWR.t2 11.015
R225 VAPWR.n146 VAPWR.n145 9.3005
R226 VAPWR.n147 VAPWR.n22 9.3005
R227 VAPWR.n149 VAPWR.n148 9.3005
R228 VAPWR.n150 VAPWR.n18 9.3005
R229 VAPWR.n152 VAPWR.n151 9.3005
R230 VAPWR.n153 VAPWR.n17 9.3005
R231 VAPWR.n155 VAPWR.n154 9.3005
R232 VAPWR.n156 VAPWR.n13 9.3005
R233 VAPWR.n158 VAPWR.n157 9.3005
R234 VAPWR.n159 VAPWR.n12 9.3005
R235 VAPWR.n161 VAPWR.n160 9.3005
R236 VAPWR.n162 VAPWR.n8 9.3005
R237 VAPWR.n164 VAPWR.n163 9.3005
R238 VAPWR.n144 VAPWR.n23 9.3005
R239 VAPWR.n125 VAPWR.n25 9.3005
R240 VAPWR.n127 VAPWR.n126 9.3005
R241 VAPWR.n124 VAPWR.n28 9.3005
R242 VAPWR.n123 VAPWR.n122 9.3005
R243 VAPWR.n30 VAPWR.n29 9.3005
R244 VAPWR.n107 VAPWR.n106 9.3005
R245 VAPWR.n105 VAPWR.n40 9.3005
R246 VAPWR.n104 VAPWR.n103 9.3005
R247 VAPWR.n42 VAPWR.n41 9.3005
R248 VAPWR.n75 VAPWR.n62 9.3005
R249 VAPWR.n95 VAPWR.n94 9.3005
R250 VAPWR.n93 VAPWR.n47 9.3005
R251 VAPWR.n92 VAPWR.n91 9.3005
R252 VAPWR.n90 VAPWR.n51 9.3005
R253 VAPWR.n89 VAPWR.n88 9.3005
R254 VAPWR.n87 VAPWR.n52 9.3005
R255 VAPWR.n86 VAPWR.n85 9.3005
R256 VAPWR.n84 VAPWR.n56 9.3005
R257 VAPWR.n83 VAPWR.n82 9.3005
R258 VAPWR.n81 VAPWR.n57 9.3005
R259 VAPWR.n80 VAPWR.n79 9.3005
R260 VAPWR.n78 VAPWR.n61 9.3005
R261 VAPWR.n77 VAPWR.n76 9.3005
R262 VAPWR.n96 VAPWR.n46 9.3005
R263 VAPWR.n98 VAPWR.n97 9.3005
R264 VAPWR.n37 VAPWR.n36 9.3005
R265 VAPWR.n113 VAPWR.n112 9.3005
R266 VAPWR.n115 VAPWR.n35 9.3005
R267 VAPWR.n117 VAPWR.n116 9.3005
R268 VAPWR.n2 VAPWR.n0 9.3005
R269 VAPWR.n170 VAPWR.n169 9.3005
R270 VAPWR.n168 VAPWR.n1 9.3005
R271 VAPWR.n167 VAPWR.n166 9.3005
R272 VAPWR.n165 VAPWR.n6 9.3005
R273 VAPWR.n146 VAPWR.n23 0.247375
R274 VAPWR.n77 VAPWR.n62 0.247375
R275 VAPWR VAPWR.n171 0.159465
R276 VAPWR.n165 VAPWR.n164 0.147375
R277 VAPWR.n96 VAPWR.n95 0.147375
R278 VAPWR.n164 VAPWR.n8 0.113
R279 VAPWR.n160 VAPWR.n8 0.113
R280 VAPWR.n160 VAPWR.n159 0.113
R281 VAPWR.n159 VAPWR.n158 0.113
R282 VAPWR.n158 VAPWR.n13 0.113
R283 VAPWR.n154 VAPWR.n13 0.113
R284 VAPWR.n154 VAPWR.n153 0.113
R285 VAPWR.n153 VAPWR.n152 0.113
R286 VAPWR.n152 VAPWR.n18 0.113
R287 VAPWR.n148 VAPWR.n18 0.113
R288 VAPWR.n148 VAPWR.n147 0.113
R289 VAPWR.n147 VAPWR.n146 0.113
R290 VAPWR.n62 VAPWR.n41 0.113
R291 VAPWR.n104 VAPWR.n41 0.113
R292 VAPWR.n105 VAPWR.n104 0.113
R293 VAPWR.n106 VAPWR.n105 0.113
R294 VAPWR.n106 VAPWR.n29 0.113
R295 VAPWR.n123 VAPWR.n29 0.113
R296 VAPWR.n124 VAPWR.n123 0.113
R297 VAPWR.n126 VAPWR.n124 0.113
R298 VAPWR.n126 VAPWR.n125 0.113
R299 VAPWR.n125 VAPWR.n23 0.113
R300 VAPWR.n95 VAPWR.n47 0.113
R301 VAPWR.n91 VAPWR.n47 0.113
R302 VAPWR.n91 VAPWR.n90 0.113
R303 VAPWR.n90 VAPWR.n89 0.113
R304 VAPWR.n89 VAPWR.n52 0.113
R305 VAPWR.n85 VAPWR.n52 0.113
R306 VAPWR.n85 VAPWR.n84 0.113
R307 VAPWR.n84 VAPWR.n83 0.113
R308 VAPWR.n83 VAPWR.n57 0.113
R309 VAPWR.n79 VAPWR.n57 0.113
R310 VAPWR.n79 VAPWR.n78 0.113
R311 VAPWR.n78 VAPWR.n77 0.113
R312 VAPWR.n97 VAPWR.n96 0.023
R313 VAPWR.n97 VAPWR.n36 0.023
R314 VAPWR.n113 VAPWR.n36 0.023
R315 VAPWR.n116 VAPWR.n115 0.023
R316 VAPWR.n116 VAPWR.n0 0.023
R317 VAPWR.n170 VAPWR.n1 0.023
R318 VAPWR.n166 VAPWR.n165 0.023
R319 VAPWR.n7 VAPWR.n1 0.0205
R320 VAPWR.n171 VAPWR.n170 0.017375
R321 VAPWR.n115 VAPWR.n114 0.0155
R322 VAPWR.n114 VAPWR.n113 0.008
R323 VAPWR.n171 VAPWR.n0 0.006125
R324 VAPWR.n166 VAPWR.n7 0.003
R325 VDD.n20 VDD.n19 585
R326 VDD.n16 VDD.n15 585
R327 VDD.n21 VDD.n20 571.606
R328 VDD.n17 VDD.t1 397.385
R329 VDD.n153 VDD.n25 280.5
R330 VDD.n155 VDD.n43 280.5
R331 VDD.n111 VDD.n58 280.5
R332 VDD.n107 VDD.n69 280.5
R333 VDD.n20 VDD.n15 236.4
R334 VDD.n70 VDD.n69 185
R335 VDD.n69 VDD.n57 185
R336 VDD.n74 VDD.n55 185
R337 VDD.n118 VDD.n55 185
R338 VDD.n120 VDD.n56 185
R339 VDD.n120 VDD.n119 185
R340 VDD.n121 VDD.n2 185
R341 VDD.n122 VDD.n121 185
R342 VDD.n191 VDD.n3 185
R343 VDD.n49 VDD.n3 185
R344 VDD.n190 VDD.n4 185
R345 VDD.n130 VDD.n4 185
R346 VDD.n189 VDD.n5 185
R347 VDD.n131 VDD.n5 185
R348 VDD.n133 VDD.n6 185
R349 VDD.n134 VDD.n133 185
R350 VDD.n184 VDD.n9 185
R351 VDD.n132 VDD.n9 185
R352 VDD.n183 VDD.n10 185
R353 VDD.n142 VDD.n10 185
R354 VDD.n182 VDD.n11 185
R355 VDD.n143 VDD.n11 185
R356 VDD.n153 VDD.n12 185
R357 VDD.n154 VDD.n153 185
R358 VDD.n107 VDD.n106 185
R359 VDD.n71 VDD.n68 185
R360 VDD.n102 VDD.n67 185
R361 VDD.n109 VDD.n67 185
R362 VDD.n101 VDD.n79 185
R363 VDD.n100 VDD.n80 185
R364 VDD.n82 VDD.n81 185
R365 VDD.n96 VDD.n84 185
R366 VDD.n95 VDD.n85 185
R367 VDD.n94 VDD.n86 185
R368 VDD.n88 VDD.n87 185
R369 VDD.n90 VDD.n89 185
R370 VDD.n62 VDD.n61 185
R371 VDD.n112 VDD.n111 185
R372 VDD.n156 VDD.n155 185
R373 VDD.n155 VDD.n154 185
R374 VDD.n42 VDD.n41 185
R375 VDD.n143 VDD.n42 185
R376 VDD.n141 VDD.n140 185
R377 VDD.n142 VDD.n141 185
R378 VDD.n45 VDD.n44 185
R379 VDD.n132 VDD.n44 185
R380 VDD.n136 VDD.n135 185
R381 VDD.n135 VDD.n134 185
R382 VDD.n48 VDD.n47 185
R383 VDD.n131 VDD.n48 185
R384 VDD.n129 VDD.n128 185
R385 VDD.n130 VDD.n129 185
R386 VDD.n51 VDD.n50 185
R387 VDD.n50 VDD.n49 185
R388 VDD.n124 VDD.n123 185
R389 VDD.n123 VDD.n122 185
R390 VDD.n54 VDD.n53 185
R391 VDD.n119 VDD.n54 185
R392 VDD.n117 VDD.n116 185
R393 VDD.n118 VDD.n117 185
R394 VDD.n59 VDD.n58 185
R395 VDD.n58 VDD.n57 185
R396 VDD.n43 VDD.n39 185
R397 VDD.n161 VDD.n38 185
R398 VDD.n162 VDD.n37 185
R399 VDD.n163 VDD.n36 185
R400 VDD.n146 VDD.n34 185
R401 VDD.n167 VDD.n33 185
R402 VDD.n168 VDD.n32 185
R403 VDD.n169 VDD.n31 185
R404 VDD.n170 VDD.n30 185
R405 VDD.n149 VDD.n28 185
R406 VDD.n174 VDD.n27 185
R407 VDD.n175 VDD.n26 185
R408 VDD.n176 VDD.n25 185
R409 VDD.n152 VDD.n25 185
R410 VDD.n0 VDD.t7 134.649
R411 VDD.n76 VDD.t9 134.649
R412 VDD.t1 VDD.n15 118.201
R413 VDD.n26 VDD.n25 108.001
R414 VDD.n149 VDD.n27 108.001
R415 VDD.n31 VDD.n30 108.001
R416 VDD.n33 VDD.n32 108.001
R417 VDD.n146 VDD.n36 108.001
R418 VDD.n38 VDD.n37 108.001
R419 VDD.n117 VDD.n58 108.001
R420 VDD.n117 VDD.n54 108.001
R421 VDD.n123 VDD.n54 108.001
R422 VDD.n123 VDD.n50 108.001
R423 VDD.n129 VDD.n50 108.001
R424 VDD.n129 VDD.n48 108.001
R425 VDD.n135 VDD.n48 108.001
R426 VDD.n135 VDD.n44 108.001
R427 VDD.n141 VDD.n44 108.001
R428 VDD.n141 VDD.n42 108.001
R429 VDD.n155 VDD.n42 108.001
R430 VDD.n68 VDD.n67 108.001
R431 VDD.n79 VDD.n67 108.001
R432 VDD.n81 VDD.n80 108.001
R433 VDD.n85 VDD.n84 108.001
R434 VDD.n87 VDD.n86 108.001
R435 VDD.n89 VDD.n62 108.001
R436 VDD.n69 VDD.n55 108.001
R437 VDD.n120 VDD.n55 108.001
R438 VDD.n121 VDD.n120 108.001
R439 VDD.n121 VDD.n3 108.001
R440 VDD.n4 VDD.n3 108.001
R441 VDD.n5 VDD.n4 108.001
R442 VDD.n133 VDD.n5 108.001
R443 VDD.n133 VDD.n9 108.001
R444 VDD.n10 VDD.n9 108.001
R445 VDD.n11 VDD.n10 108.001
R446 VDD.n153 VDD.n11 108.001
R447 VDD.n109 VDD.n57 75.0367
R448 VDD.n154 VDD.n152 75.0367
R449 VDD.n186 VDD.n7 74.9836
R450 VDD.n109 VDD.n108 71.6014
R451 VDD.n109 VDD.n63 71.6014
R452 VDD.n109 VDD.n64 71.6014
R453 VDD.n109 VDD.n65 71.6014
R454 VDD.n109 VDD.n66 71.6014
R455 VDD.n110 VDD.n109 71.6014
R456 VDD.n152 VDD.n144 71.6014
R457 VDD.n152 VDD.n145 71.6014
R458 VDD.n152 VDD.n147 71.6014
R459 VDD.n152 VDD.n148 71.6014
R460 VDD.n152 VDD.n150 71.6014
R461 VDD.n152 VDD.n151 71.6014
R462 VDD.n118 VDD.n57 49.5657
R463 VDD.n122 VDD.n49 49.5657
R464 VDD.n130 VDD.n49 49.5657
R465 VDD.n131 VDD.n130 49.5657
R466 VDD.n134 VDD.n131 49.5657
R467 VDD.n154 VDD.n143 49.5657
R468 VDD.n151 VDD.n27 41.8002
R469 VDD.n150 VDD.n30 41.8002
R470 VDD.n148 VDD.n32 41.8002
R471 VDD.n147 VDD.n146 41.8002
R472 VDD.n145 VDD.n37 41.8002
R473 VDD.n144 VDD.n43 41.8002
R474 VDD.n108 VDD.n107 41.8002
R475 VDD.n79 VDD.n63 41.8002
R476 VDD.n81 VDD.n64 41.8002
R477 VDD.n85 VDD.n65 41.8002
R478 VDD.n87 VDD.n66 41.8002
R479 VDD.n110 VDD.n62 41.8002
R480 VDD.n108 VDD.n68 41.8002
R481 VDD.n80 VDD.n63 41.8002
R482 VDD.n84 VDD.n64 41.8002
R483 VDD.n86 VDD.n65 41.8002
R484 VDD.n89 VDD.n66 41.8002
R485 VDD.n111 VDD.n110 41.8002
R486 VDD.n144 VDD.n38 41.8002
R487 VDD.n145 VDD.n36 41.8002
R488 VDD.n147 VDD.n33 41.8002
R489 VDD.n148 VDD.n31 41.8002
R490 VDD.n150 VDD.n149 41.8002
R491 VDD.n151 VDD.n26 41.8002
R492 VDD.t4 VDD.n132 41.3048
R493 VDD.n119 VDD.t8 33.044
R494 VDD.t0 VDD.n142 33.044
R495 VDD.n106 VDD.n70 29.9205
R496 VDD.n176 VDD.n12 29.9205
R497 VDD.n112 VDD.n59 29.9205
R498 VDD.n156 VDD.n39 29.9205
R499 VDD.n119 VDD.t6 28.9135
R500 VDD.n142 VDD.t2 28.9135
R501 VDD.n19 VDD.n14 27.1064
R502 VDD.n19 VDD.n16 27.1064
R503 VDD.n22 VDD.n21 24.8327
R504 VDD.n122 VDD.t6 20.6527
R505 VDD.n132 VDD.t2 20.6527
R506 VDD.t8 VDD.n118 16.5222
R507 VDD.n143 VDD.t0 16.5222
R508 VDD.n74 VDD.n70 11.5205
R509 VDD.n74 VDD.n56 11.5205
R510 VDD.n56 VDD.n2 11.5205
R511 VDD.n191 VDD.n2 11.5205
R512 VDD.n191 VDD.n190 11.5205
R513 VDD.n190 VDD.n189 11.5205
R514 VDD.n189 VDD.n6 11.5205
R515 VDD.n184 VDD.n6 11.5205
R516 VDD.n184 VDD.n183 11.5205
R517 VDD.n183 VDD.n182 11.5205
R518 VDD.n182 VDD.n12 11.5205
R519 VDD.n106 VDD.n71 11.5205
R520 VDD.n102 VDD.n71 11.5205
R521 VDD.n102 VDD.n101 11.5205
R522 VDD.n101 VDD.n100 11.5205
R523 VDD.n100 VDD.n82 11.5205
R524 VDD.n96 VDD.n82 11.5205
R525 VDD.n96 VDD.n95 11.5205
R526 VDD.n95 VDD.n94 11.5205
R527 VDD.n94 VDD.n88 11.5205
R528 VDD.n90 VDD.n88 11.5205
R529 VDD.n90 VDD.n61 11.5205
R530 VDD.n112 VDD.n61 11.5205
R531 VDD.n116 VDD.n59 11.5205
R532 VDD.n116 VDD.n53 11.5205
R533 VDD.n124 VDD.n53 11.5205
R534 VDD.n124 VDD.n51 11.5205
R535 VDD.n128 VDD.n51 11.5205
R536 VDD.n128 VDD.n47 11.5205
R537 VDD.n136 VDD.n47 11.5205
R538 VDD.n136 VDD.n45 11.5205
R539 VDD.n140 VDD.n45 11.5205
R540 VDD.n140 VDD.n41 11.5205
R541 VDD.n156 VDD.n41 11.5205
R542 VDD.n176 VDD.n175 11.5205
R543 VDD.n175 VDD.n174 11.5205
R544 VDD.n174 VDD.n28 11.5205
R545 VDD.n170 VDD.n28 11.5205
R546 VDD.n170 VDD.n169 11.5205
R547 VDD.n169 VDD.n168 11.5205
R548 VDD.n168 VDD.n167 11.5205
R549 VDD.n167 VDD.n34 11.5205
R550 VDD.n163 VDD.n34 11.5205
R551 VDD.n163 VDD.n162 11.5205
R552 VDD.n162 VDD.n161 11.5205
R553 VDD.n161 VDD.n39 11.5205
R554 VDD.n21 VDD.n14 11.0627
R555 VDD.n7 VDD.t5 9.8505
R556 VDD.n7 VDD.t3 9.8505
R557 VDD.n14 VDD.n13 9.3005
R558 VDD.n19 VDD.n18 9.3005
R559 VDD.n159 VDD.n39 9.3005
R560 VDD.n161 VDD.n160 9.3005
R561 VDD.n162 VDD.n35 9.3005
R562 VDD.n164 VDD.n163 9.3005
R563 VDD.n165 VDD.n34 9.3005
R564 VDD.n167 VDD.n166 9.3005
R565 VDD.n168 VDD.n23 9.3005
R566 VDD.n169 VDD.n29 9.3005
R567 VDD.n171 VDD.n170 9.3005
R568 VDD.n172 VDD.n28 9.3005
R569 VDD.n174 VDD.n173 9.3005
R570 VDD.n175 VDD.n24 9.3005
R571 VDD.n177 VDD.n176 9.3005
R572 VDD.n157 VDD.n156 9.3005
R573 VDD.n41 VDD.n40 9.3005
R574 VDD.n140 VDD.n139 9.3005
R575 VDD.n138 VDD.n45 9.3005
R576 VDD.n137 VDD.n136 9.3005
R577 VDD.n47 VDD.n46 9.3005
R578 VDD.n128 VDD.n127 9.3005
R579 VDD.n126 VDD.n51 9.3005
R580 VDD.n125 VDD.n124 9.3005
R581 VDD.n53 VDD.n52 9.3005
R582 VDD.n116 VDD.n115 9.3005
R583 VDD.n114 VDD.n59 9.3005
R584 VDD.n106 VDD.n105 9.3005
R585 VDD.n104 VDD.n71 9.3005
R586 VDD.n103 VDD.n102 9.3005
R587 VDD.n101 VDD.n78 9.3005
R588 VDD.n100 VDD.n99 9.3005
R589 VDD.n98 VDD.n82 9.3005
R590 VDD.n97 VDD.n96 9.3005
R591 VDD.n95 VDD.n83 9.3005
R592 VDD.n94 VDD.n93 9.3005
R593 VDD.n92 VDD.n88 9.3005
R594 VDD.n91 VDD.n90 9.3005
R595 VDD.n61 VDD.n60 9.3005
R596 VDD.n113 VDD.n112 9.3005
R597 VDD.n77 VDD.n70 9.3005
R598 VDD.n75 VDD.n74 9.3005
R599 VDD.n73 VDD.n56 9.3005
R600 VDD.n72 VDD.n2 9.3005
R601 VDD.n192 VDD.n191 9.3005
R602 VDD.n190 VDD.n1 9.3005
R603 VDD.n189 VDD.n188 9.3005
R604 VDD.n187 VDD.n6 9.3005
R605 VDD.n185 VDD.n184 9.3005
R606 VDD.n183 VDD.n8 9.3005
R607 VDD.n182 VDD.n181 9.3005
R608 VDD.n179 VDD.n12 9.3005
R609 VDD.n134 VDD.t4 8.26137
R610 VDD.n17 VDD.n16 6.45639
R611 VDD.n178 VDD.n23 2.1255
R612 VDD.n158 VDD.n23 2.1255
R613 VDD.n18 VDD.n17 1.04058
R614 VDD.n180 VDD.n22 0.329204
R615 VDD.n159 VDD.n158 0.318937
R616 VDD.n178 VDD.n177 0.300188
R617 VDD.n114 VDD.n113 0.292688
R618 VDD.n177 VDD.n24 0.1805
R619 VDD.n173 VDD.n24 0.1805
R620 VDD.n173 VDD.n172 0.1805
R621 VDD.n172 VDD.n171 0.1805
R622 VDD.n171 VDD.n29 0.1805
R623 VDD.n29 VDD.n23 0.1805
R624 VDD.n166 VDD.n23 0.1805
R625 VDD.n166 VDD.n165 0.1805
R626 VDD.n165 VDD.n164 0.1805
R627 VDD.n164 VDD.n35 0.1805
R628 VDD.n160 VDD.n35 0.1805
R629 VDD.n160 VDD.n159 0.1805
R630 VDD.n22 VDD.n13 0.167167
R631 VDD.n18 VDD.n13 0.167167
R632 VDD.n105 VDD.n77 0.156437
R633 VDD VDD.n193 0.155825
R634 VDD.n158 VDD.n157 0.13175
R635 VDD.n115 VDD.n114 0.113
R636 VDD.n115 VDD.n52 0.113
R637 VDD.n125 VDD.n52 0.113
R638 VDD.n126 VDD.n125 0.113
R639 VDD.n127 VDD.n126 0.113
R640 VDD.n127 VDD.n46 0.113
R641 VDD.n137 VDD.n46 0.113
R642 VDD.n138 VDD.n137 0.113
R643 VDD.n139 VDD.n138 0.113
R644 VDD.n139 VDD.n40 0.113
R645 VDD.n157 VDD.n40 0.113
R646 VDD.n105 VDD.n104 0.113
R647 VDD.n104 VDD.n103 0.113
R648 VDD.n103 VDD.n78 0.113
R649 VDD.n99 VDD.n78 0.113
R650 VDD.n99 VDD.n98 0.113
R651 VDD.n98 VDD.n97 0.113
R652 VDD.n97 VDD.n83 0.113
R653 VDD.n93 VDD.n83 0.113
R654 VDD.n93 VDD.n92 0.113
R655 VDD.n92 VDD.n91 0.113
R656 VDD.n91 VDD.n60 0.113
R657 VDD.n113 VDD.n60 0.113
R658 VDD.n179 VDD.n178 0.02675
R659 VDD.n75 VDD.n73 0.023
R660 VDD.n73 VDD.n72 0.023
R661 VDD.n192 VDD.n1 0.023
R662 VDD.n188 VDD.n1 0.023
R663 VDD.n188 VDD.n187 0.023
R664 VDD.n185 VDD.n8 0.023
R665 VDD.n181 VDD.n8 0.023
R666 VDD.n187 VDD.n186 0.0183125
R667 VDD.n77 VDD.n76 0.0164375
R668 VDD.n180 VDD.n179 0.0164375
R669 VDD.n193 VDD.n192 0.0120625
R670 VDD.n76 VDD.n75 0.0070625
R671 VDD.n181 VDD.n180 0.0070625
R672 VDD.n193 VDD.n0 0.00675
R673 VDD.n72 VDD.n0 0.0051875
R674 VDD.n186 VDD.n185 0.0051875
R675 VSS.n278 VSS.n231 1360
R676 VSS.n216 VSS.n215 585
R677 VSS.n215 VSS.n54 585
R678 VSS.n217 VSS.n72 585
R679 VSS.n72 VSS.n70 585
R680 VSS.n219 VSS.n218 585
R681 VSS.n220 VSS.n219 585
R682 VSS.n73 VSS.n71 585
R683 VSS.n169 VSS.n71 585
R684 VSS.n172 VSS.n171 585
R685 VSS.n171 VSS.n170 585
R686 VSS.n76 VSS.n75 585
R687 VSS.n77 VSS.n76 585
R688 VSS.n160 VSS.n159 585
R689 VSS.n161 VSS.n160 585
R690 VSS.n85 VSS.n84 585
R691 VSS.n84 VSS.n83 585
R692 VSS.n155 VSS.n154 585
R693 VSS.n154 VSS.n153 585
R694 VSS.n88 VSS.n87 585
R695 VSS.n89 VSS.n88 585
R696 VSS.n143 VSS.n142 585
R697 VSS.n144 VSS.n143 585
R698 VSS.n97 VSS.n96 585
R699 VSS.n138 VSS.n137 585
R700 VSS.n135 VSS.n99 585
R701 VSS.n135 VSS.n95 585
R702 VSS.n134 VSS.n133 585
R703 VSS.n132 VSS.n131 585
R704 VSS.n130 VSS.n103 585
R705 VSS.n128 VSS.n127 585
R706 VSS.n126 VSS.n104 585
R707 VSS.n125 VSS.n124 585
R708 VSS.n122 VSS.n109 585
R709 VSS.n120 VSS.n119 585
R710 VSS.n118 VSS.n110 585
R711 VSS.n117 VSS.n116 585
R712 VSS.n94 VSS.n93 585
R713 VSS.n95 VSS.n94 585
R714 VSS.n229 VSS.n228 585
R715 VSS.n63 VSS.n61 585
R716 VSS.n192 VSS.n191 585
R717 VSS.n194 VSS.n193 585
R718 VSS.n196 VSS.n195 585
R719 VSS.n198 VSS.n197 585
R720 VSS.n200 VSS.n199 585
R721 VSS.n202 VSS.n201 585
R722 VSS.n204 VSS.n203 585
R723 VSS.n206 VSS.n205 585
R724 VSS.n208 VSS.n207 585
R725 VSS.n210 VSS.n209 585
R726 VSS.n212 VSS.n211 585
R727 VSS.n214 VSS.n213 585
R728 VSS.n227 VSS.n62 585
R729 VSS.n62 VSS.n54 585
R730 VSS.n69 VSS.n65 585
R731 VSS.n70 VSS.n69 585
R732 VSS.n222 VSS.n221 585
R733 VSS.n221 VSS.n220 585
R734 VSS.n68 VSS.n67 585
R735 VSS.n169 VSS.n68 585
R736 VSS.n168 VSS.n167 585
R737 VSS.n170 VSS.n168 585
R738 VSS.n79 VSS.n78 585
R739 VSS.n78 VSS.n77 585
R740 VSS.n163 VSS.n162 585
R741 VSS.n162 VSS.n161 585
R742 VSS.n82 VSS.n81 585
R743 VSS.n83 VSS.n82 585
R744 VSS.n152 VSS.n151 585
R745 VSS.n153 VSS.n152 585
R746 VSS.n91 VSS.n90 585
R747 VSS.n90 VSS.n89 585
R748 VSS.n146 VSS.n145 585
R749 VSS.n145 VSS.n144 585
R750 VSS.n53 VSS.n52 585
R751 VSS.n279 VSS.n53 585
R752 VSS.n283 VSS.n282 585
R753 VSS.n282 VSS.n281 585
R754 VSS.n50 VSS.n49 585
R755 VSS.n280 VSS.n49 585
R756 VSS.n288 VSS.n287 585
R757 VSS.n289 VSS.n288 585
R758 VSS.n47 VSS.n46 585
R759 VSS.n290 VSS.n47 585
R760 VSS.n293 VSS.n292 585
R761 VSS.n292 VSS.n291 585
R762 VSS.n44 VSS.n43 585
R763 VSS.n43 VSS.n41 585
R764 VSS.n298 VSS.n297 585
R765 VSS.n299 VSS.n298 585
R766 VSS.n40 VSS.n39 585
R767 VSS.n300 VSS.n40 585
R768 VSS.n303 VSS.n302 585
R769 VSS.n302 VSS.n301 585
R770 VSS.n36 VSS.n34 585
R771 VSS.n34 VSS.n32 585
R772 VSS.n350 VSS.n349 585
R773 VSS.n351 VSS.n350 585
R774 VSS.n354 VSS.n353 585
R775 VSS.n327 VSS.n30 585
R776 VSS.n330 VSS.n328 585
R777 VSS.n331 VSS.n325 585
R778 VSS.n332 VSS.n324 585
R779 VSS.n322 VSS.n320 585
R780 VSS.n336 VSS.n319 585
R781 VSS.n337 VSS.n317 585
R782 VSS.n338 VSS.n316 585
R783 VSS.n314 VSS.n312 585
R784 VSS.n342 VSS.n311 585
R785 VSS.n343 VSS.n309 585
R786 VSS.n344 VSS.n308 585
R787 VSS.n37 VSS.n35 585
R788 VSS.n352 VSS.n17 585
R789 VSS.n352 VSS.n351 585
R790 VSS.n360 VSS.n16 585
R791 VSS.n32 VSS.n16 585
R792 VSS.n361 VSS.n15 585
R793 VSS.n301 VSS.n15 585
R794 VSS.n362 VSS.n14 585
R795 VSS.n300 VSS.n14 585
R796 VSS.n42 VSS.n12 585
R797 VSS.n299 VSS.n42 585
R798 VSS.n366 VSS.n11 585
R799 VSS.n41 VSS.n11 585
R800 VSS.n367 VSS.n10 585
R801 VSS.n291 VSS.n10 585
R802 VSS.n368 VSS.n9 585
R803 VSS.n290 VSS.n9 585
R804 VSS.n48 VSS.n7 585
R805 VSS.n289 VSS.n48 585
R806 VSS.n373 VSS.n6 585
R807 VSS.n280 VSS.n6 585
R808 VSS.n374 VSS.n5 585
R809 VSS.n281 VSS.n5 585
R810 VSS.n375 VSS.n4 585
R811 VSS.n279 VSS.n4 585
R812 VSS.n276 VSS.n275 585
R813 VSS.n240 VSS.n239 585
R814 VSS.n271 VSS.n238 585
R815 VSS.n278 VSS.n238 585
R816 VSS.n270 VSS.n242 585
R817 VSS.n269 VSS.n243 585
R818 VSS.n245 VSS.n244 585
R819 VSS.n265 VSS.n247 585
R820 VSS.n264 VSS.n248 585
R821 VSS.n263 VSS.n249 585
R822 VSS.n251 VSS.n250 585
R823 VSS.n259 VSS.n253 585
R824 VSS.n258 VSS.n254 585
R825 VSS.n257 VSS.n255 585
R826 VSS.n237 VSS.n3 585
R827 VSS.n278 VSS.n237 585
R828 VSS.n350 VSS.n35 494.962
R829 VSS.n353 VSS.n352 494.962
R830 VSS.n237 VSS.n4 494.962
R831 VSS.n276 VSS.n53 494.962
R832 VSS.n215 VSS.n214 410.651
R833 VSS.n229 VSS.n62 410.651
R834 VSS.n145 VSS.n94 410.651
R835 VSS.n143 VSS.n96 410.651
R836 VSS.n26 VSS.n25 256.483
R837 VSS.n136 VSS.n95 255.031
R838 VSS.n100 VSS.n95 255.031
R839 VSS.n129 VSS.n95 255.031
R840 VSS.n123 VSS.n95 255.031
R841 VSS.n121 VSS.n95 255.031
R842 VSS.n115 VSS.n95 255.031
R843 VSS.n231 VSS.n230 255.031
R844 VSS.n231 VSS.n60 255.031
R845 VSS.n231 VSS.n59 255.031
R846 VSS.n231 VSS.n58 255.031
R847 VSS.n231 VSS.n57 255.031
R848 VSS.n231 VSS.n56 255.031
R849 VSS.n231 VSS.n55 255.031
R850 VSS.n33 VSS.n31 254.01
R851 VSS.n326 VSS.n33 254.01
R852 VSS.n323 VSS.n33 254.01
R853 VSS.n318 VSS.n33 254.01
R854 VSS.n315 VSS.n33 254.01
R855 VSS.n310 VSS.n33 254.01
R856 VSS.n307 VSS.n33 254.01
R857 VSS.n278 VSS.n277 254.01
R858 VSS.n278 VSS.n232 254.01
R859 VSS.n278 VSS.n233 254.01
R860 VSS.n278 VSS.n234 254.01
R861 VSS.n278 VSS.n235 254.01
R862 VSS.n278 VSS.n236 254.01
R863 VSS.n279 VSS.n278 218
R864 VSS.n351 VSS.n33 218
R865 VSS.n21 VSS.n20 185
R866 VSS.n25 VSS.n24 185
R867 VSS.n22 VSS.t1 180.947
R868 VSS.n309 VSS.n308 177.3
R869 VSS.n314 VSS.n311 177.3
R870 VSS.n317 VSS.n316 177.3
R871 VSS.n322 VSS.n319 177.3
R872 VSS.n325 VSS.n324 177.3
R873 VSS.n328 VSS.n327 177.3
R874 VSS.n5 VSS.n4 177.3
R875 VSS.n6 VSS.n5 177.3
R876 VSS.n48 VSS.n6 177.3
R877 VSS.n48 VSS.n9 177.3
R878 VSS.n10 VSS.n9 177.3
R879 VSS.n11 VSS.n10 177.3
R880 VSS.n42 VSS.n11 177.3
R881 VSS.n42 VSS.n14 177.3
R882 VSS.n15 VSS.n14 177.3
R883 VSS.n16 VSS.n15 177.3
R884 VSS.n352 VSS.n16 177.3
R885 VSS.n239 VSS.n238 177.3
R886 VSS.n242 VSS.n238 177.3
R887 VSS.n244 VSS.n243 177.3
R888 VSS.n248 VSS.n247 177.3
R889 VSS.n250 VSS.n249 177.3
R890 VSS.n254 VSS.n253 177.3
R891 VSS.n255 VSS.n237 177.3
R892 VSS.n282 VSS.n53 177.3
R893 VSS.n282 VSS.n49 177.3
R894 VSS.n288 VSS.n49 177.3
R895 VSS.n288 VSS.n47 177.3
R896 VSS.n292 VSS.n47 177.3
R897 VSS.n292 VSS.n43 177.3
R898 VSS.n298 VSS.n43 177.3
R899 VSS.n298 VSS.n40 177.3
R900 VSS.n302 VSS.n40 177.3
R901 VSS.n302 VSS.n34 177.3
R902 VSS.n350 VSS.n34 177.3
R903 VSS.n211 VSS.n210 171.9
R904 VSS.n207 VSS.n206 171.9
R905 VSS.n203 VSS.n202 171.9
R906 VSS.n199 VSS.n198 171.9
R907 VSS.n195 VSS.n194 171.9
R908 VSS.n191 VSS.n61 171.9
R909 VSS.n145 VSS.n90 171.9
R910 VSS.n152 VSS.n90 171.9
R911 VSS.n152 VSS.n82 171.9
R912 VSS.n162 VSS.n82 171.9
R913 VSS.n162 VSS.n78 171.9
R914 VSS.n168 VSS.n78 171.9
R915 VSS.n168 VSS.n68 171.9
R916 VSS.n221 VSS.n68 171.9
R917 VSS.n221 VSS.n69 171.9
R918 VSS.n69 VSS.n62 171.9
R919 VSS.n137 VSS.n135 171.9
R920 VSS.n135 VSS.n134 171.9
R921 VSS.n131 VSS.n130 171.9
R922 VSS.n128 VSS.n104 171.9
R923 VSS.n124 VSS.n122 171.9
R924 VSS.n120 VSS.n110 171.9
R925 VSS.n116 VSS.n94 171.9
R926 VSS.n143 VSS.n88 171.9
R927 VSS.n154 VSS.n88 171.9
R928 VSS.n154 VSS.n84 171.9
R929 VSS.n160 VSS.n84 171.9
R930 VSS.n160 VSS.n76 171.9
R931 VSS.n171 VSS.n76 171.9
R932 VSS.n171 VSS.n71 171.9
R933 VSS.n219 VSS.n71 171.9
R934 VSS.n219 VSS.n72 171.9
R935 VSS.n215 VSS.n72 171.9
R936 VSS.n144 VSS.n95 160
R937 VSS.n231 VSS.n54 160
R938 VSS.n25 VSS.n20 144
R939 VSS.n144 VSS.n89 144
R940 VSS.n153 VSS.n89 144
R941 VSS.n161 VSS.n83 144
R942 VSS.n161 VSS.n77 144
R943 VSS.n170 VSS.n77 144
R944 VSS.n170 VSS.n169 144
R945 VSS.n220 VSS.n70 144
R946 VSS.n70 VSS.n54 144
R947 VSS.n281 VSS.n279 144
R948 VSS.n281 VSS.n280 144
R949 VSS.n290 VSS.n289 144
R950 VSS.n291 VSS.n290 144
R951 VSS.n291 VSS.n41 144
R952 VSS.n299 VSS.n41 144
R953 VSS.n300 VSS.n299 144
R954 VSS.n301 VSS.n300 144
R955 VSS.n351 VSS.n32 144
R956 VSS.t2 VSS.n83 112.001
R957 VSS.n169 VSS.t4 112.001
R958 VSS.n370 VSS.t7 99.3171
R959 VSS.n301 VSS.t0 96.0005
R960 VSS.n280 VSS.t6 84.0005
R961 VSS.n308 VSS.n307 76.985
R962 VSS.n311 VSS.n310 76.985
R963 VSS.n316 VSS.n315 76.985
R964 VSS.n319 VSS.n318 76.985
R965 VSS.n324 VSS.n323 76.985
R966 VSS.n328 VSS.n326 76.985
R967 VSS.n353 VSS.n31 76.985
R968 VSS.n277 VSS.n276 76.985
R969 VSS.n242 VSS.n232 76.985
R970 VSS.n244 VSS.n233 76.985
R971 VSS.n248 VSS.n234 76.985
R972 VSS.n250 VSS.n235 76.985
R973 VSS.n254 VSS.n236 76.985
R974 VSS.n327 VSS.n31 76.985
R975 VSS.n326 VSS.n325 76.985
R976 VSS.n323 VSS.n322 76.985
R977 VSS.n318 VSS.n317 76.985
R978 VSS.n315 VSS.n314 76.985
R979 VSS.n310 VSS.n309 76.985
R980 VSS.n307 VSS.n35 76.985
R981 VSS.n277 VSS.n239 76.985
R982 VSS.n243 VSS.n232 76.985
R983 VSS.n247 VSS.n233 76.985
R984 VSS.n249 VSS.n234 76.985
R985 VSS.n253 VSS.n235 76.985
R986 VSS.n255 VSS.n236 76.985
R987 VSS.n211 VSS.n55 74.9406
R988 VSS.n207 VSS.n56 74.9406
R989 VSS.n203 VSS.n57 74.9406
R990 VSS.n199 VSS.n58 74.9406
R991 VSS.n195 VSS.n59 74.9406
R992 VSS.n191 VSS.n60 74.9406
R993 VSS.n230 VSS.n229 74.9406
R994 VSS.n136 VSS.n96 74.9406
R995 VSS.n134 VSS.n100 74.9406
R996 VSS.n130 VSS.n129 74.9406
R997 VSS.n123 VSS.n104 74.9406
R998 VSS.n122 VSS.n121 74.9406
R999 VSS.n115 VSS.n110 74.9406
R1000 VSS.n137 VSS.n136 74.9406
R1001 VSS.n131 VSS.n100 74.9406
R1002 VSS.n129 VSS.n128 74.9406
R1003 VSS.n124 VSS.n123 74.9406
R1004 VSS.n121 VSS.n120 74.9406
R1005 VSS.n116 VSS.n115 74.9406
R1006 VSS.n230 VSS.n61 74.9406
R1007 VSS.n194 VSS.n60 74.9406
R1008 VSS.n198 VSS.n59 74.9406
R1009 VSS.n202 VSS.n58 74.9406
R1010 VSS.n206 VSS.n57 74.9406
R1011 VSS.n210 VSS.n56 74.9406
R1012 VSS.n214 VSS.n55 74.9406
R1013 VSS.t1 VSS.n20 72.0005
R1014 VSS.n289 VSS.t6 60.0005
R1015 VSS.t0 VSS.n32 48.0005
R1016 VSS.n275 VSS.n52 32.1605
R1017 VSS.n349 VSS.n37 32.1605
R1018 VSS.n354 VSS.n17 32.1605
R1019 VSS.n375 VSS.n3 32.1605
R1020 VSS.n153 VSS.t2 32.0005
R1021 VSS.n220 VSS.t4 32.0005
R1022 VSS.n216 VSS.n213 27.5205
R1023 VSS.n228 VSS.n227 27.5205
R1024 VSS.n146 VSS.n93 27.5205
R1025 VSS.n142 VSS.n97 27.5205
R1026 VSS.n24 VSS.n21 27.1064
R1027 VSS.n24 VSS.n19 27.1064
R1028 VSS.n27 VSS.n26 25.7818
R1029 VSS.n80 VSS.t3 22.2713
R1030 VSS.n224 VSS.t5 22.2713
R1031 VSS.n213 VSS.n212 11.5205
R1032 VSS.n212 VSS.n209 11.5205
R1033 VSS.n209 VSS.n208 11.5205
R1034 VSS.n208 VSS.n205 11.5205
R1035 VSS.n205 VSS.n204 11.5205
R1036 VSS.n204 VSS.n201 11.5205
R1037 VSS.n201 VSS.n200 11.5205
R1038 VSS.n200 VSS.n197 11.5205
R1039 VSS.n197 VSS.n196 11.5205
R1040 VSS.n196 VSS.n193 11.5205
R1041 VSS.n193 VSS.n192 11.5205
R1042 VSS.n192 VSS.n63 11.5205
R1043 VSS.n228 VSS.n63 11.5205
R1044 VSS.n146 VSS.n91 11.5205
R1045 VSS.n151 VSS.n91 11.5205
R1046 VSS.n151 VSS.n81 11.5205
R1047 VSS.n163 VSS.n81 11.5205
R1048 VSS.n163 VSS.n79 11.5205
R1049 VSS.n167 VSS.n79 11.5205
R1050 VSS.n167 VSS.n67 11.5205
R1051 VSS.n222 VSS.n67 11.5205
R1052 VSS.n222 VSS.n65 11.5205
R1053 VSS.n227 VSS.n65 11.5205
R1054 VSS.n138 VSS.n97 11.5205
R1055 VSS.n138 VSS.n99 11.5205
R1056 VSS.n133 VSS.n99 11.5205
R1057 VSS.n133 VSS.n132 11.5205
R1058 VSS.n132 VSS.n103 11.5205
R1059 VSS.n127 VSS.n103 11.5205
R1060 VSS.n127 VSS.n126 11.5205
R1061 VSS.n126 VSS.n125 11.5205
R1062 VSS.n125 VSS.n109 11.5205
R1063 VSS.n119 VSS.n109 11.5205
R1064 VSS.n119 VSS.n118 11.5205
R1065 VSS.n118 VSS.n117 11.5205
R1066 VSS.n117 VSS.n93 11.5205
R1067 VSS.n142 VSS.n87 11.5205
R1068 VSS.n155 VSS.n87 11.5205
R1069 VSS.n155 VSS.n85 11.5205
R1070 VSS.n159 VSS.n85 11.5205
R1071 VSS.n159 VSS.n75 11.5205
R1072 VSS.n172 VSS.n75 11.5205
R1073 VSS.n172 VSS.n73 11.5205
R1074 VSS.n218 VSS.n73 11.5205
R1075 VSS.n218 VSS.n217 11.5205
R1076 VSS.n217 VSS.n216 11.5205
R1077 VSS.n283 VSS.n52 11.5205
R1078 VSS.n283 VSS.n50 11.5205
R1079 VSS.n287 VSS.n50 11.5205
R1080 VSS.n287 VSS.n46 11.5205
R1081 VSS.n293 VSS.n46 11.5205
R1082 VSS.n293 VSS.n44 11.5205
R1083 VSS.n297 VSS.n44 11.5205
R1084 VSS.n297 VSS.n39 11.5205
R1085 VSS.n303 VSS.n39 11.5205
R1086 VSS.n303 VSS.n36 11.5205
R1087 VSS.n349 VSS.n36 11.5205
R1088 VSS.n344 VSS.n37 11.5205
R1089 VSS.n344 VSS.n343 11.5205
R1090 VSS.n343 VSS.n342 11.5205
R1091 VSS.n342 VSS.n312 11.5205
R1092 VSS.n338 VSS.n312 11.5205
R1093 VSS.n338 VSS.n337 11.5205
R1094 VSS.n337 VSS.n336 11.5205
R1095 VSS.n336 VSS.n320 11.5205
R1096 VSS.n332 VSS.n320 11.5205
R1097 VSS.n332 VSS.n331 11.5205
R1098 VSS.n331 VSS.n330 11.5205
R1099 VSS.n330 VSS.n30 11.5205
R1100 VSS.n354 VSS.n30 11.5205
R1101 VSS.n375 VSS.n374 11.5205
R1102 VSS.n374 VSS.n373 11.5205
R1103 VSS.n373 VSS.n7 11.5205
R1104 VSS.n368 VSS.n7 11.5205
R1105 VSS.n368 VSS.n367 11.5205
R1106 VSS.n367 VSS.n366 11.5205
R1107 VSS.n366 VSS.n12 11.5205
R1108 VSS.n362 VSS.n12 11.5205
R1109 VSS.n362 VSS.n361 11.5205
R1110 VSS.n361 VSS.n360 11.5205
R1111 VSS.n360 VSS.n17 11.5205
R1112 VSS.n275 VSS.n240 11.5205
R1113 VSS.n271 VSS.n240 11.5205
R1114 VSS.n271 VSS.n270 11.5205
R1115 VSS.n270 VSS.n269 11.5205
R1116 VSS.n269 VSS.n245 11.5205
R1117 VSS.n265 VSS.n245 11.5205
R1118 VSS.n265 VSS.n264 11.5205
R1119 VSS.n264 VSS.n263 11.5205
R1120 VSS.n263 VSS.n251 11.5205
R1121 VSS.n259 VSS.n251 11.5205
R1122 VSS.n259 VSS.n258 11.5205
R1123 VSS.n258 VSS.n257 11.5205
R1124 VSS.n257 VSS.n3 11.5205
R1125 VSS.n24 VSS.n23 9.3005
R1126 VSS.n19 VSS.n18 9.3005
R1127 VSS.n228 VSS.n64 9.3005
R1128 VSS.n189 VSS.n63 9.3005
R1129 VSS.n192 VSS.n190 9.3005
R1130 VSS.n193 VSS.n188 9.3005
R1131 VSS.n196 VSS.n187 9.3005
R1132 VSS.n197 VSS.n186 9.3005
R1133 VSS.n200 VSS.n185 9.3005
R1134 VSS.n201 VSS.n184 9.3005
R1135 VSS.n204 VSS.n183 9.3005
R1136 VSS.n205 VSS.n182 9.3005
R1137 VSS.n208 VSS.n181 9.3005
R1138 VSS.n209 VSS.n180 9.3005
R1139 VSS.n212 VSS.n179 9.3005
R1140 VSS.n213 VSS.n178 9.3005
R1141 VSS.n140 VSS.n97 9.3005
R1142 VSS.n139 VSS.n138 9.3005
R1143 VSS.n99 VSS.n98 9.3005
R1144 VSS.n133 VSS.n101 9.3005
R1145 VSS.n132 VSS.n102 9.3005
R1146 VSS.n105 VSS.n103 9.3005
R1147 VSS.n127 VSS.n106 9.3005
R1148 VSS.n126 VSS.n107 9.3005
R1149 VSS.n125 VSS.n108 9.3005
R1150 VSS.n111 VSS.n109 9.3005
R1151 VSS.n119 VSS.n112 9.3005
R1152 VSS.n118 VSS.n113 9.3005
R1153 VSS.n117 VSS.n114 9.3005
R1154 VSS.n93 VSS.n92 9.3005
R1155 VSS.n142 VSS.n141 9.3005
R1156 VSS.n87 VSS.n86 9.3005
R1157 VSS.n156 VSS.n155 9.3005
R1158 VSS.n157 VSS.n85 9.3005
R1159 VSS.n159 VSS.n158 9.3005
R1160 VSS.n75 VSS.n74 9.3005
R1161 VSS.n173 VSS.n172 9.3005
R1162 VSS.n174 VSS.n73 9.3005
R1163 VSS.n218 VSS.n175 9.3005
R1164 VSS.n217 VSS.n176 9.3005
R1165 VSS.n216 VSS.n177 9.3005
R1166 VSS.n355 VSS.n354 9.3005
R1167 VSS.n30 VSS.n29 9.3005
R1168 VSS.n330 VSS.n329 9.3005
R1169 VSS.n331 VSS.n321 9.3005
R1170 VSS.n333 VSS.n332 9.3005
R1171 VSS.n334 VSS.n320 9.3005
R1172 VSS.n336 VSS.n335 9.3005
R1173 VSS.n337 VSS.n313 9.3005
R1174 VSS.n339 VSS.n338 9.3005
R1175 VSS.n340 VSS.n312 9.3005
R1176 VSS.n342 VSS.n341 9.3005
R1177 VSS.n343 VSS.n306 9.3005
R1178 VSS.n345 VSS.n344 9.3005
R1179 VSS.n346 VSS.n37 9.3005
R1180 VSS.n275 VSS.n274 9.3005
R1181 VSS.n273 VSS.n240 9.3005
R1182 VSS.n272 VSS.n271 9.3005
R1183 VSS.n270 VSS.n241 9.3005
R1184 VSS.n269 VSS.n268 9.3005
R1185 VSS.n267 VSS.n245 9.3005
R1186 VSS.n266 VSS.n265 9.3005
R1187 VSS.n264 VSS.n246 9.3005
R1188 VSS.n263 VSS.n262 9.3005
R1189 VSS.n261 VSS.n251 9.3005
R1190 VSS.n260 VSS.n259 9.3005
R1191 VSS.n258 VSS.n252 9.3005
R1192 VSS.n257 VSS.n256 9.3005
R1193 VSS.n3 VSS.n1 9.3005
R1194 VSS.n52 VSS.n51 9.3005
R1195 VSS.n284 VSS.n283 9.3005
R1196 VSS.n285 VSS.n50 9.3005
R1197 VSS.n287 VSS.n286 9.3005
R1198 VSS.n46 VSS.n45 9.3005
R1199 VSS.n294 VSS.n293 9.3005
R1200 VSS.n295 VSS.n44 9.3005
R1201 VSS.n297 VSS.n296 9.3005
R1202 VSS.n39 VSS.n38 9.3005
R1203 VSS.n304 VSS.n303 9.3005
R1204 VSS.n305 VSS.n36 9.3005
R1205 VSS.n349 VSS.n348 9.3005
R1206 VSS.n148 VSS.n91 9.3005
R1207 VSS.n151 VSS.n150 9.3005
R1208 VSS.n149 VSS.n81 9.3005
R1209 VSS.n164 VSS.n163 9.3005
R1210 VSS.n165 VSS.n79 9.3005
R1211 VSS.n167 VSS.n166 9.3005
R1212 VSS.n67 VSS.n66 9.3005
R1213 VSS.n223 VSS.n222 9.3005
R1214 VSS.n225 VSS.n65 9.3005
R1215 VSS.n227 VSS.n226 9.3005
R1216 VSS.n147 VSS.n146 9.3005
R1217 VSS.n357 VSS.n17 9.3005
R1218 VSS.n360 VSS.n359 9.3005
R1219 VSS.n361 VSS.n13 9.3005
R1220 VSS.n363 VSS.n362 9.3005
R1221 VSS.n364 VSS.n12 9.3005
R1222 VSS.n366 VSS.n365 9.3005
R1223 VSS.n367 VSS.n8 9.3005
R1224 VSS.n369 VSS.n368 9.3005
R1225 VSS.n371 VSS.n7 9.3005
R1226 VSS.n373 VSS.n372 9.3005
R1227 VSS.n374 VSS.n2 9.3005
R1228 VSS.n376 VSS.n375 9.3005
R1229 VSS.n26 VSS.n19 9.2683
R1230 VSS.n22 VSS.n21 6.30777
R1231 VSS.n347 VSS.n28 2.33383
R1232 VSS.n356 VSS.n28 2.33383
R1233 VSS.n23 VSS.n22 1.18676
R1234 VSS.n358 VSS.n27 0.884759
R1235 VSS.n347 VSS.n346 0.353938
R1236 VSS.n356 VSS.n355 0.335188
R1237 VSS.n274 VSS.n51 0.314563
R1238 VSS.n141 VSS.n140 0.26925
R1239 VSS.n178 VSS.n177 0.26925
R1240 VSS VSS.n378 0.195734
R1241 VSS.n346 VSS.n345 0.1805
R1242 VSS.n345 VSS.n306 0.1805
R1243 VSS.n341 VSS.n306 0.1805
R1244 VSS.n341 VSS.n340 0.1805
R1245 VSS.n340 VSS.n339 0.1805
R1246 VSS.n339 VSS.n313 0.1805
R1247 VSS.n335 VSS.n334 0.1805
R1248 VSS.n334 VSS.n333 0.1805
R1249 VSS.n333 VSS.n321 0.1805
R1250 VSS.n329 VSS.n321 0.1805
R1251 VSS.n329 VSS.n29 0.1805
R1252 VSS.n355 VSS.n29 0.1805
R1253 VSS.n147 VSS.n92 0.16925
R1254 VSS.n23 VSS.n18 0.167167
R1255 VSS.n27 VSS.n18 0.167167
R1256 VSS.n64 VSS.n0 0.14425
R1257 VSS.n377 VSS.n1 0.14425
R1258 VSS.n348 VSS.n347 0.13175
R1259 VSS.n140 VSS.n139 0.113
R1260 VSS.n139 VSS.n98 0.113
R1261 VSS.n101 VSS.n98 0.113
R1262 VSS.n102 VSS.n101 0.113
R1263 VSS.n105 VSS.n102 0.113
R1264 VSS.n106 VSS.n105 0.113
R1265 VSS.n107 VSS.n106 0.113
R1266 VSS.n108 VSS.n107 0.113
R1267 VSS.n111 VSS.n108 0.113
R1268 VSS.n112 VSS.n111 0.113
R1269 VSS.n113 VSS.n112 0.113
R1270 VSS.n114 VSS.n113 0.113
R1271 VSS.n114 VSS.n92 0.113
R1272 VSS.n141 VSS.n86 0.113
R1273 VSS.n156 VSS.n86 0.113
R1274 VSS.n157 VSS.n156 0.113
R1275 VSS.n158 VSS.n157 0.113
R1276 VSS.n158 VSS.n74 0.113
R1277 VSS.n173 VSS.n74 0.113
R1278 VSS.n174 VSS.n173 0.113
R1279 VSS.n175 VSS.n174 0.113
R1280 VSS.n176 VSS.n175 0.113
R1281 VSS.n177 VSS.n176 0.113
R1282 VSS.n179 VSS.n178 0.113
R1283 VSS.n180 VSS.n179 0.113
R1284 VSS.n181 VSS.n180 0.113
R1285 VSS.n182 VSS.n181 0.113
R1286 VSS.n183 VSS.n182 0.113
R1287 VSS.n184 VSS.n183 0.113
R1288 VSS.n185 VSS.n184 0.113
R1289 VSS.n186 VSS.n185 0.113
R1290 VSS.n187 VSS.n186 0.113
R1291 VSS.n188 VSS.n187 0.113
R1292 VSS.n190 VSS.n188 0.113
R1293 VSS.n190 VSS.n189 0.113
R1294 VSS.n189 VSS.n64 0.113
R1295 VSS.n274 VSS.n273 0.113
R1296 VSS.n273 VSS.n272 0.113
R1297 VSS.n272 VSS.n241 0.113
R1298 VSS.n268 VSS.n241 0.113
R1299 VSS.n268 VSS.n267 0.113
R1300 VSS.n267 VSS.n266 0.113
R1301 VSS.n266 VSS.n246 0.113
R1302 VSS.n262 VSS.n246 0.113
R1303 VSS.n262 VSS.n261 0.113
R1304 VSS.n261 VSS.n260 0.113
R1305 VSS.n260 VSS.n252 0.113
R1306 VSS.n256 VSS.n252 0.113
R1307 VSS.n256 VSS.n1 0.113
R1308 VSS.n284 VSS.n51 0.113
R1309 VSS.n285 VSS.n284 0.113
R1310 VSS.n286 VSS.n285 0.113
R1311 VSS.n286 VSS.n45 0.113
R1312 VSS.n294 VSS.n45 0.113
R1313 VSS.n295 VSS.n294 0.113
R1314 VSS.n296 VSS.n295 0.113
R1315 VSS.n296 VSS.n38 0.113
R1316 VSS.n304 VSS.n38 0.113
R1317 VSS.n305 VSS.n304 0.113
R1318 VSS.n348 VSS.n305 0.113
R1319 VSS.n378 VSS.n0 0.109875
R1320 VSS.n378 VSS.n377 0.103625
R1321 VSS.n313 VSS.n28 0.0905
R1322 VSS.n335 VSS.n28 0.0905
R1323 VSS.n377 VSS.n376 0.0345625
R1324 VSS.n357 VSS.n356 0.02675
R1325 VSS.n226 VSS.n0 0.0255
R1326 VSS.n148 VSS.n147 0.023
R1327 VSS.n150 VSS.n148 0.023
R1328 VSS.n150 VSS.n149 0.023
R1329 VSS.n165 VSS.n164 0.023
R1330 VSS.n166 VSS.n165 0.023
R1331 VSS.n166 VSS.n66 0.023
R1332 VSS.n223 VSS.n66 0.023
R1333 VSS.n226 VSS.n225 0.023
R1334 VSS.n376 VSS.n2 0.023
R1335 VSS.n372 VSS.n2 0.023
R1336 VSS.n372 VSS.n371 0.023
R1337 VSS.n369 VSS.n8 0.023
R1338 VSS.n365 VSS.n8 0.023
R1339 VSS.n365 VSS.n364 0.023
R1340 VSS.n364 VSS.n363 0.023
R1341 VSS.n363 VSS.n13 0.023
R1342 VSS.n359 VSS.n13 0.023
R1343 VSS.n224 VSS.n223 0.0205
R1344 VSS.n370 VSS.n369 0.0183125
R1345 VSS.n358 VSS.n357 0.0164375
R1346 VSS.n164 VSS.n80 0.0155
R1347 VSS.n149 VSS.n80 0.008
R1348 VSS.n359 VSS.n358 0.0070625
R1349 VSS.n371 VSS.n370 0.0051875
R1350 VSS.n225 VSS.n224 0.003
C0 A VAPWR 0.97059f
C1 VDD VAPWR 0.53319f
C2 VDD in 1.0439f
C3 A ctrl_n 0.38985f
C4 A B 1.34506f
C5 A ctrl 0.57936f
C6 VDD ctrl_n 0.82353f
C7 VDD B 0.01021f
C8 VDD ctrl 2.91903f
C9 in VAPWR 0
C10 VAPWR ctrl_n 0.01756f
C11 in ctrl_n 0
C12 VAPWR ctrl 0.07994f
C13 VAPWR B 1.21011f
C14 in ctrl 0.94077f
C15 B ctrl_n 0.40418f
C16 ctrl ctrl_n 1.48683f
C17 B ctrl 0.0831f
C18 VDD A 0.00239f
C19 A VSS 1.4316f
C20 B VSS 1.66951f
C21 in VSS 0.8774f
C22 VAPWR VSS 7.13082f
C23 VDD VSS 7.83674f
C24 ctrl_n VSS 1.71435f
C25 ctrl VSS 2.33056f
C26 VDD.t7 VSS 0.0262f
C27 VDD.n0 VSS 0.06597f
C28 VDD.n1 VSS 0.03358f
C29 VDD.n2 VSS 0.00672f
C30 VDD.n3 VSS 0.00672f
C31 VDD.n4 VSS 0.00672f
C32 VDD.n5 VSS 0.00672f
C33 VDD.n6 VSS 0.00672f
C34 VDD.t5 VSS 0.01049f
C35 VDD.t3 VSS 0.01049f
C36 VDD.n7 VSS 0.02188f
C37 VDD.n8 VSS 0.03358f
C38 VDD.n9 VSS 0.00672f
C39 VDD.n10 VSS 0.00672f
C40 VDD.n11 VSS 0.00672f
C41 VDD.n12 VSS 0.01363f
C42 VDD.n13 VSS 0.00453f
C43 VDD.n14 VSS 0.00285f
C44 VDD.n15 VSS 0.00378f
C45 VDD.n16 VSS 0.0032f
C46 VDD.t1 VSS 0.00935f
C47 VDD.n17 VSS 0.01533f
C48 VDD.n18 VSS 0.03528f
C49 VDD.n19 VSS 0.00285f
C50 VDD.n20 VSS 0.01044f
C51 VDD.n21 VSS 0.00547f
C52 VDD.n22 VSS 0.00951f
C53 VDD.n23 VSS 0.02204f
C54 VDD.n24 VSS 0.0042f
C55 VDD.n25 VSS 0.01425f
C56 VDD.n26 VSS 0.00672f
C57 VDD.n27 VSS 0.00672f
C58 VDD.n28 VSS 0.00672f
C59 VDD.n29 VSS 0.0042f
C60 VDD.n30 VSS 0.00672f
C61 VDD.n31 VSS 0.00672f
C62 VDD.n32 VSS 0.00672f
C63 VDD.n33 VSS 0.00672f
C64 VDD.n34 VSS 0.00672f
C65 VDD.n35 VSS 0.0042f
C66 VDD.n36 VSS 0.00672f
C67 VDD.n37 VSS 0.00672f
C68 VDD.n38 VSS 0.00672f
C69 VDD.n39 VSS 0.01425f
C70 VDD.n40 VSS 0.00672f
C71 VDD.n41 VSS 0.00672f
C72 VDD.n42 VSS 0.00672f
C73 VDD.n43 VSS 0.01425f
C74 VDD.t2 VSS 0.05792f
C75 VDD.n44 VSS 0.00672f
C76 VDD.n45 VSS 0.00672f
C77 VDD.n46 VSS 0.00672f
C78 VDD.n47 VSS 0.00672f
C79 VDD.n48 VSS 0.00672f
C80 VDD.n49 VSS 0.11584f
C81 VDD.n50 VSS 0.00672f
C82 VDD.n51 VSS 0.00672f
C83 VDD.n52 VSS 0.00672f
C84 VDD.n53 VSS 0.00672f
C85 VDD.n54 VSS 0.00672f
C86 VDD.t6 VSS 0.05792f
C87 VDD.n55 VSS 0.00672f
C88 VDD.n56 VSS 0.00672f
C89 VDD.n57 VSS 0.14561f
C90 VDD.n58 VSS 0.01363f
C91 VDD.n59 VSS 0.01363f
C92 VDD.n60 VSS 0.00672f
C93 VDD.n61 VSS 0.00672f
C94 VDD.n62 VSS 0.00672f
C95 VDD.n67 VSS 0.00672f
C96 VDD.n68 VSS 0.00672f
C97 VDD.n69 VSS 0.01363f
C98 VDD.n70 VSS 0.01363f
C99 VDD.n71 VSS 0.00672f
C100 VDD.t9 VSS 0.0262f
C101 VDD.n72 VSS 0.02029f
C102 VDD.n73 VSS 0.03358f
C103 VDD.n74 VSS 0.00672f
C104 VDD.n75 VSS 0.02169f
C105 VDD.n76 VSS 0.0746f
C106 VDD.n77 VSS 0.16207f
C107 VDD.n78 VSS 0.00672f
C108 VDD.n79 VSS 0.00672f
C109 VDD.n80 VSS 0.00672f
C110 VDD.n81 VSS 0.00672f
C111 VDD.n82 VSS 0.00672f
C112 VDD.n83 VSS 0.00672f
C113 VDD.n84 VSS 0.00672f
C114 VDD.n85 VSS 0.00672f
C115 VDD.n86 VSS 0.00672f
C116 VDD.n87 VSS 0.00672f
C117 VDD.n88 VSS 0.00672f
C118 VDD.n89 VSS 0.00672f
C119 VDD.n90 VSS 0.00672f
C120 VDD.n91 VSS 0.00672f
C121 VDD.n92 VSS 0.00672f
C122 VDD.n93 VSS 0.00672f
C123 VDD.n94 VSS 0.00672f
C124 VDD.n95 VSS 0.00672f
C125 VDD.n96 VSS 0.00672f
C126 VDD.n97 VSS 0.00672f
C127 VDD.n98 VSS 0.00672f
C128 VDD.n99 VSS 0.00672f
C129 VDD.n100 VSS 0.00672f
C130 VDD.n101 VSS 0.00672f
C131 VDD.n102 VSS 0.00672f
C132 VDD.n103 VSS 0.00672f
C133 VDD.n104 VSS 0.00672f
C134 VDD.n105 VSS 0.04187f
C135 VDD.n106 VSS 0.01425f
C136 VDD.n107 VSS 0.01425f
C137 VDD.n109 VSS 0.31293f
C138 VDD.n111 VSS 0.01425f
C139 VDD.n112 VSS 0.01425f
C140 VDD.n113 VSS 0.01425f
C141 VDD.n114 VSS 0.01363f
C142 VDD.n115 VSS 0.00672f
C143 VDD.n116 VSS 0.00672f
C144 VDD.n117 VSS 0.00672f
C145 VDD.n118 VSS 0.07723f
C146 VDD.t8 VSS 0.05792f
C147 VDD.n119 VSS 0.0724f
C148 VDD.n120 VSS 0.00672f
C149 VDD.n121 VSS 0.00672f
C150 VDD.n122 VSS 0.08206f
C151 VDD.n123 VSS 0.00672f
C152 VDD.n124 VSS 0.00672f
C153 VDD.n125 VSS 0.00672f
C154 VDD.n126 VSS 0.00672f
C155 VDD.n127 VSS 0.00672f
C156 VDD.n128 VSS 0.00672f
C157 VDD.n129 VSS 0.00672f
C158 VDD.n130 VSS 0.11584f
C159 VDD.n131 VSS 0.11584f
C160 VDD.n132 VSS 0.0724f
C161 VDD.t4 VSS 0.05792f
C162 VDD.n133 VSS 0.00672f
C163 VDD.n134 VSS 0.06757f
C164 VDD.n135 VSS 0.00672f
C165 VDD.n136 VSS 0.00672f
C166 VDD.n137 VSS 0.00672f
C167 VDD.n138 VSS 0.00672f
C168 VDD.n139 VSS 0.00672f
C169 VDD.n140 VSS 0.00672f
C170 VDD.n141 VSS 0.00672f
C171 VDD.n142 VSS 0.0724f
C172 VDD.t0 VSS 0.05792f
C173 VDD.n143 VSS 0.07723f
C174 VDD.n146 VSS 0.00672f
C175 VDD.n149 VSS 0.00672f
C176 VDD.n152 VSS 0.31293f
C177 VDD.n153 VSS 0.01363f
C178 VDD.n154 VSS 0.14561f
C179 VDD.n155 VSS 0.01363f
C180 VDD.n156 VSS 0.01363f
C181 VDD.n157 VSS 0.00728f
C182 VDD.n158 VSS 0.01953f
C183 VDD.n159 VSS 0.00601f
C184 VDD.n160 VSS 0.0042f
C185 VDD.n161 VSS 0.00672f
C186 VDD.n162 VSS 0.00672f
C187 VDD.n163 VSS 0.00672f
C188 VDD.n164 VSS 0.0042f
C189 VDD.n165 VSS 0.0042f
C190 VDD.n166 VSS 0.0042f
C191 VDD.n167 VSS 0.00672f
C192 VDD.n168 VSS 0.00672f
C193 VDD.n169 VSS 0.00672f
C194 VDD.n170 VSS 0.00672f
C195 VDD.n171 VSS 0.0042f
C196 VDD.n172 VSS 0.0042f
C197 VDD.n173 VSS 0.0042f
C198 VDD.n174 VSS 0.00672f
C199 VDD.n175 VSS 0.00672f
C200 VDD.n176 VSS 0.01425f
C201 VDD.n177 VSS 0.00568f
C202 VDD.n178 VSS 0.04113f
C203 VDD.n179 VSS 0.03148f
C204 VDD.n180 VSS 0.02126f
C205 VDD.n181 VSS 0.02169f
C206 VDD.n182 VSS 0.00672f
C207 VDD.n183 VSS 0.00672f
C208 VDD.n184 VSS 0.00672f
C209 VDD.n185 VSS 0.02029f
C210 VDD.n186 VSS 0.08098f
C211 VDD.n187 VSS 0.03008f
C212 VDD.n188 VSS 0.03358f
C213 VDD.n189 VSS 0.00672f
C214 VDD.n190 VSS 0.00672f
C215 VDD.n191 VSS 0.00672f
C216 VDD.n192 VSS 0.02542f
C217 VDD.n193 VSS 0.68286f
C218 VAPWR.n0 VSS 0.01215f
C219 VAPWR.n1 VSS 0.01836f
C220 VAPWR.n2 VSS 0.00389f
C221 VAPWR.n3 VSS 0.00389f
C222 VAPWR.n4 VSS 0.00389f
C223 VAPWR.n5 VSS 0.00389f
C224 VAPWR.n6 VSS 0.00728f
C225 VAPWR.t3 VSS 0.00913f
C226 VAPWR.n7 VSS 0.06096f
C227 VAPWR.n8 VSS 0.00389f
C228 VAPWR.n9 VSS 0.0073f
C229 VAPWR.n10 VSS 0.00389f
C230 VAPWR.n11 VSS 0.00389f
C231 VAPWR.n12 VSS 0.00389f
C232 VAPWR.n13 VSS 0.00389f
C233 VAPWR.n14 VSS 0.00389f
C234 VAPWR.n15 VSS 0.00389f
C235 VAPWR.n16 VSS 0.00389f
C236 VAPWR.n17 VSS 0.00389f
C237 VAPWR.n18 VSS 0.00389f
C238 VAPWR.n19 VSS 0.00389f
C239 VAPWR.n20 VSS 0.00389f
C240 VAPWR.n21 VSS 0.00389f
C241 VAPWR.n22 VSS 0.00389f
C242 VAPWR.n23 VSS 0.00728f
C243 VAPWR.n24 VSS 0.0073f
C244 VAPWR.n25 VSS 0.00389f
C245 VAPWR.n26 VSS 0.00389f
C246 VAPWR.t2 VSS 0.03354f
C247 VAPWR.n27 VSS 0.00389f
C248 VAPWR.n28 VSS 0.00389f
C249 VAPWR.n29 VSS 0.00389f
C250 VAPWR.n30 VSS 0.00389f
C251 VAPWR.n31 VSS 0.00389f
C252 VAPWR.n32 VSS 0.06708f
C253 VAPWR.n33 VSS 0.05963f
C254 VAPWR.n34 VSS 0.00389f
C255 VAPWR.n35 VSS 0.00389f
C256 VAPWR.t1 VSS 0.00913f
C257 VAPWR.n36 VSS 0.01944f
C258 VAPWR.n37 VSS 0.00389f
C259 VAPWR.n38 VSS 0.00389f
C260 VAPWR.t0 VSS 0.03354f
C261 VAPWR.n39 VSS 0.00389f
C262 VAPWR.n40 VSS 0.00389f
C263 VAPWR.n41 VSS 0.00389f
C264 VAPWR.n42 VSS 0.00389f
C265 VAPWR.n43 VSS 0.00389f
C266 VAPWR.n44 VSS 0.07081f
C267 VAPWR.n45 VSS 0.00728f
C268 VAPWR.n46 VSS 0.00728f
C269 VAPWR.n47 VSS 0.00389f
C270 VAPWR.n48 VSS 0.0073f
C271 VAPWR.n49 VSS 0.00389f
C272 VAPWR.n50 VSS 0.00389f
C273 VAPWR.n51 VSS 0.00389f
C274 VAPWR.n52 VSS 0.00389f
C275 VAPWR.n53 VSS 0.00389f
C276 VAPWR.n54 VSS 0.00389f
C277 VAPWR.n55 VSS 0.00389f
C278 VAPWR.n56 VSS 0.00389f
C279 VAPWR.n57 VSS 0.00389f
C280 VAPWR.n58 VSS 0.00389f
C281 VAPWR.n59 VSS 0.00389f
C282 VAPWR.n60 VSS 0.00389f
C283 VAPWR.n61 VSS 0.00389f
C284 VAPWR.n62 VSS 0.00728f
C285 VAPWR.n63 VSS 0.00389f
C286 VAPWR.n64 VSS 0.00389f
C287 VAPWR.n67 VSS 0.00389f
C288 VAPWR.n71 VSS 0.1677f
C289 VAPWR.n73 VSS 0.0073f
C290 VAPWR.n74 VSS 0.00728f
C291 VAPWR.n75 VSS 0.00728f
C292 VAPWR.n76 VSS 0.0073f
C293 VAPWR.n77 VSS 0.0073f
C294 VAPWR.n78 VSS 0.00389f
C295 VAPWR.n79 VSS 0.00389f
C296 VAPWR.n80 VSS 0.00389f
C297 VAPWR.n81 VSS 0.00389f
C298 VAPWR.n82 VSS 0.00389f
C299 VAPWR.n83 VSS 0.00389f
C300 VAPWR.n84 VSS 0.00389f
C301 VAPWR.n85 VSS 0.00389f
C302 VAPWR.n86 VSS 0.00389f
C303 VAPWR.n87 VSS 0.00389f
C304 VAPWR.n88 VSS 0.00389f
C305 VAPWR.n89 VSS 0.00389f
C306 VAPWR.n90 VSS 0.00389f
C307 VAPWR.n91 VSS 0.00389f
C308 VAPWR.n92 VSS 0.00389f
C309 VAPWR.n93 VSS 0.00389f
C310 VAPWR.n94 VSS 0.0073f
C311 VAPWR.n95 VSS 0.01084f
C312 VAPWR.n96 VSS 0.05364f
C313 VAPWR.n97 VSS 0.01944f
C314 VAPWR.n98 VSS 0.00389f
C315 VAPWR.n99 VSS 0.00389f
C316 VAPWR.n100 VSS 0.06708f
C317 VAPWR.n101 VSS 0.04099f
C318 VAPWR.n102 VSS 0.00389f
C319 VAPWR.n103 VSS 0.00389f
C320 VAPWR.n104 VSS 0.00389f
C321 VAPWR.n105 VSS 0.00389f
C322 VAPWR.n106 VSS 0.00389f
C323 VAPWR.n107 VSS 0.00389f
C324 VAPWR.n108 VSS 0.00389f
C325 VAPWR.n109 VSS 0.06708f
C326 VAPWR.n110 VSS 0.05963f
C327 VAPWR.n111 VSS 0.00389f
C328 VAPWR.n112 VSS 0.00389f
C329 VAPWR.n113 VSS 0.01296f
C330 VAPWR.n114 VSS 0.06096f
C331 VAPWR.n115 VSS 0.0162f
C332 VAPWR.n116 VSS 0.01944f
C333 VAPWR.n117 VSS 0.00389f
C334 VAPWR.n118 VSS 0.00389f
C335 VAPWR.n119 VSS 0.00389f
C336 VAPWR.n120 VSS 0.06708f
C337 VAPWR.n121 VSS 0.00389f
C338 VAPWR.n122 VSS 0.00389f
C339 VAPWR.n123 VSS 0.00389f
C340 VAPWR.n124 VSS 0.00389f
C341 VAPWR.n125 VSS 0.00389f
C342 VAPWR.n126 VSS 0.00389f
C343 VAPWR.n127 VSS 0.00389f
C344 VAPWR.n128 VSS 0.00389f
C345 VAPWR.n129 VSS 0.04099f
C346 VAPWR.n130 VSS 0.06708f
C347 VAPWR.n131 VSS 0.00389f
C348 VAPWR.n134 VSS 0.00389f
C349 VAPWR.n137 VSS 0.00389f
C350 VAPWR.n140 VSS 0.1677f
C351 VAPWR.n141 VSS 0.00728f
C352 VAPWR.n142 VSS 0.07081f
C353 VAPWR.n143 VSS 0.00728f
C354 VAPWR.n144 VSS 0.00728f
C355 VAPWR.n145 VSS 0.0073f
C356 VAPWR.n146 VSS 0.0073f
C357 VAPWR.n147 VSS 0.00389f
C358 VAPWR.n148 VSS 0.00389f
C359 VAPWR.n149 VSS 0.00389f
C360 VAPWR.n150 VSS 0.00389f
C361 VAPWR.n151 VSS 0.00389f
C362 VAPWR.n152 VSS 0.00389f
C363 VAPWR.n153 VSS 0.00389f
C364 VAPWR.n154 VSS 0.00389f
C365 VAPWR.n155 VSS 0.00389f
C366 VAPWR.n156 VSS 0.00389f
C367 VAPWR.n157 VSS 0.00389f
C368 VAPWR.n158 VSS 0.00389f
C369 VAPWR.n159 VSS 0.00389f
C370 VAPWR.n160 VSS 0.00389f
C371 VAPWR.n161 VSS 0.00389f
C372 VAPWR.n162 VSS 0.00389f
C373 VAPWR.n163 VSS 0.0073f
C374 VAPWR.n164 VSS 0.01912f
C375 VAPWR.n165 VSS 0.09398f
C376 VAPWR.n166 VSS 0.0108f
C377 VAPWR.n167 VSS 0.00389f
C378 VAPWR.n168 VSS 0.00389f
C379 VAPWR.n169 VSS 0.00389f
C380 VAPWR.n170 VSS 0.01701f
C381 VAPWR.n171 VSS 0.38433f
C382 in.t1 VSS 0.11906f
C383 in.t2 VSS 0.13493f
C384 in.n0 VSS 0.40685f
C385 in.t3 VSS 0.11905f
C386 in.n1 VSS 0.22372f
C387 in.t0 VSS 0.12036f
C388 in.n2 VSS 0.67714f
C389 B.t2 VSS 0.22897f
C390 B.t0 VSS 0.09556f
C391 B.t1 VSS 0.46746f
C392 B.n0 VSS 1.44914f
C393 B.n1 VSS 0.69354f
C394 A.t0 VSS 0.10245f
C395 A.t1 VSS 0.47098f
C396 A.n0 VSS 1.55206f
C397 A.t2 VSS 0.24319f
C398 A.n1 VSS 0.76335f
.ends
