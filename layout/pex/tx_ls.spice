* tx_ls: magic R+C extraction of layout/tx_ls.gds (layout/pex.sh)
.subckt tx_ls in A B VDD VAPWR VSS
X0 ctrl_n ctrl VDD.t7 VDD.t6 sky130_fd_pr__pfet_01v8_hvt ad=0.3 pd=2.3 as=0.6 ps=4.6 w=2 l=0.15
X1 B.t2 ctrl_n VSS.t3 VSS.t2 sky130_fd_pr__nfet_g5v0d10v5 ad=0.441 pd=3.24 as=0.882 ps=6.48 w=2.94 l=0.5
X2 B.t0 A.t5 VAPWR.t1 VAPWR.t0 sky130_fd_pr__pfet_g5v0d10v5 ad=0.252 pd=1.98 as=0.504 ps=3.96 w=1.68 l=0.5
X3 A.t1 B.t5 VAPWR.t5 VAPWR.t4 sky130_fd_pr__pfet_g5v0d10v5 ad=0.252 pd=1.98 as=0.504 ps=3.96 w=1.68 l=0.5
X4 VAPWR.t3 A.t4 B.t1 VAPWR.t2 sky130_fd_pr__pfet_g5v0d10v5 ad=0.504 pd=3.96 as=0.252 ps=1.98 w=1.68 l=0.5
X5 VAPWR.t7 B.t4 A.t0 VAPWR.t6 sky130_fd_pr__pfet_g5v0d10v5 ad=0.504 pd=3.96 as=0.252 ps=1.98 w=1.68 l=0.5
X6 ctrl_n ctrl VSS.t9 VSS.t8 sky130_fd_pr__nfet_01v8 ad=0.504 pd=3.96 as=0.504 ps=3.96 w=1.68 l=0.15
X7 VSS.t7 ctrl A.t3 VSS.t6 sky130_fd_pr__nfet_g5v0d10v5 ad=0.882 pd=6.48 as=0.441 ps=3.24 w=2.94 l=0.5
X8 VSS.t5 ctrl_n B.t3 VSS.t4 sky130_fd_pr__nfet_g5v0d10v5 ad=0.882 pd=6.48 as=0.441 ps=3.24 w=2.94 l=0.5
X9 ctrl in.t1 VDD.t5 VDD.t4 sky130_fd_pr__pfet_01v8 ad=0.9 pd=6.6 as=0.45 ps=3.3 w=3 l=0.15
X10 ctrl in.t0 VSS.t1 VSS.t0 sky130_fd_pr__nfet_01v8 ad=0.9 pd=6.6 as=0.9 ps=6.6 w=3 l=0.15
X11 VDD.t3 in.t2 ctrl VDD.t2 sky130_fd_pr__pfet_01v8 ad=0.45 pd=3.3 as=0.45 ps=3.3 w=3 l=0.15
X12 ctrl in.t3 VDD.t1 VDD.t0 sky130_fd_pr__pfet_01v8 ad=0.45 pd=3.3 as=0.9 ps=6.6 w=3 l=0.15
X13 A.t2 ctrl VSS.t11 VSS.t10 sky130_fd_pr__nfet_g5v0d10v5 ad=0.441 pd=3.24 as=0.882 ps=6.48 w=2.94 l=0.5
X14 VDD.t9 ctrl ctrl_n VDD.t8 sky130_fd_pr__pfet_01v8_hvt ad=0.6 pd=4.6 as=0.3 ps=2.3 w=2 l=0.15
R0 A.n3 A.t4 345.05
R1 A.n3 A.t5 277.462
R2 A.n2 A.n0 155.024
R3 A.n2 A.n1 30.5091
R4 A.n0 A.t0 17.0541
R5 A.n0 A.t1 17.0541
R6 A.n4 A.n3 7.07613
R7 A.n1 A.t3 5.81683
R8 A.n1 A.t2 5.81683
R9 A.n4 A.n2 3.63187
R10 A A.n4 0.19179
R11 B.n0 B.t4 345.05
R12 B.n0 B.t5 277.462
R13 B.n3 B.n1 154.357
R14 B.n3 B.n2 31.1758
R15 B.n1 B.t1 17.0541
R16 B.n1 B.t0 17.0541
R17 B.n4 B.n0 6.7145
R18 B.n2 B.t3 5.81683
R19 B.n2 B.t2 5.81683
R20 B.n4 B.n3 3.4105
R21 B B.n4 0.14996
R22 in.n0 in.t2 961.957
R23 in.n2 in.t0 743.442
R24 in.n0 in.t1 737.083
R25 in.n1 in.t3 737.023
R26 in in.n2 3.49886
R27 in.n2 in.n1 2.99947
R28 in.n1 in.n0 0.0609839
R29 VAPWR.n163 VAPWR.n9 247.951
R30 VAPWR.n166 VAPWR.n29 247.951
R31 VAPWR.n104 VAPWR.n56 247.951
R32 VAPWR.n100 VAPWR.n54 247.951
R33 VAPWR.n7 VAPWR.t5 230.542
R34 VAPWR.n198 VAPWR.t7 230.542
R35 VAPWR.n137 VAPWR.t1 230.542
R36 VAPWR.n52 VAPWR.t3 230.542
R37 VAPWR.n54 VAPWR.n53 185
R38 VAPWR.n55 VAPWR.n54 185
R39 VAPWR.n114 VAPWR.n113 185
R40 VAPWR.n113 VAPWR.n112 185
R41 VAPWR.n51 VAPWR.n50 185
R42 VAPWR.n50 VAPWR.t2 185
R43 VAPWR.n119 VAPWR.n118 185
R44 VAPWR.n120 VAPWR.n119 185
R45 VAPWR.n42 VAPWR.n41 185
R46 VAPWR.n121 VAPWR.n42 185
R47 VAPWR.n135 VAPWR.n134 185
R48 VAPWR.n134 VAPWR.n133 185
R49 VAPWR.n39 VAPWR.n38 185
R50 VAPWR.n132 VAPWR.n38 185
R51 VAPWR.n141 VAPWR.n140 185
R52 VAPWR.n141 VAPWR.n36 185
R53 VAPWR.n142 VAPWR.n2 185
R54 VAPWR.n143 VAPWR.n142 185
R55 VAPWR.n196 VAPWR.n3 185
R56 VAPWR.n144 VAPWR.n3 185
R57 VAPWR.n195 VAPWR.n4 185
R58 VAPWR.n145 VAPWR.n4 185
R59 VAPWR.n194 VAPWR.n5 185
R60 VAPWR.n30 VAPWR.n5 185
R61 VAPWR.n153 VAPWR.n6 185
R62 VAPWR.t4 VAPWR.n153 185
R63 VAPWR.n190 VAPWR.n8 185
R64 VAPWR.n154 VAPWR.n8 185
R65 VAPWR.n189 VAPWR.n9 185
R66 VAPWR.n165 VAPWR.n9 185
R67 VAPWR.n100 VAPWR.n99 185
R68 VAPWR.n69 VAPWR.n68 185
R69 VAPWR.n95 VAPWR.n67 185
R70 VAPWR.n102 VAPWR.n67 185
R71 VAPWR.n94 VAPWR.n72 185
R72 VAPWR.n93 VAPWR.n73 185
R73 VAPWR.n75 VAPWR.n74 185
R74 VAPWR.n89 VAPWR.n77 185
R75 VAPWR.n88 VAPWR.n78 185
R76 VAPWR.n87 VAPWR.n79 185
R77 VAPWR.n81 VAPWR.n80 185
R78 VAPWR.n83 VAPWR.n82 185
R79 VAPWR.n62 VAPWR.n61 185
R80 VAPWR.n105 VAPWR.n104 185
R81 VAPWR.n167 VAPWR.n166 185
R82 VAPWR.n166 VAPWR.n165 185
R83 VAPWR.n28 VAPWR.n27 185
R84 VAPWR.n154 VAPWR.n28 185
R85 VAPWR.n152 VAPWR.n151 185
R86 VAPWR.t4 VAPWR.n152 185
R87 VAPWR.n32 VAPWR.n31 185
R88 VAPWR.n31 VAPWR.n30 185
R89 VAPWR.n147 VAPWR.n146 185
R90 VAPWR.n146 VAPWR.n145 185
R91 VAPWR.n35 VAPWR.n34 185
R92 VAPWR.n144 VAPWR.n35 185
R93 VAPWR.n126 VAPWR.n37 185
R94 VAPWR.n143 VAPWR.n37 185
R95 VAPWR.n46 VAPWR.n44 185
R96 VAPWR.n44 VAPWR.n36 185
R97 VAPWR.n131 VAPWR.n130 185
R98 VAPWR.n132 VAPWR.n131 185
R99 VAPWR.n45 VAPWR.n43 185
R100 VAPWR.n133 VAPWR.n43 185
R101 VAPWR.n123 VAPWR.n122 185
R102 VAPWR.n122 VAPWR.n121 185
R103 VAPWR.n49 VAPWR.n48 185
R104 VAPWR.n120 VAPWR.n49 185
R105 VAPWR.n59 VAPWR.n57 185
R106 VAPWR.n57 VAPWR.t2 185
R107 VAPWR.n111 VAPWR.n110 185
R108 VAPWR.n112 VAPWR.n111 185
R109 VAPWR.n58 VAPWR.n56 185
R110 VAPWR.n56 VAPWR.n55 185
R111 VAPWR.n29 VAPWR.n25 185
R112 VAPWR.n171 VAPWR.n24 185
R113 VAPWR.n172 VAPWR.n23 185
R114 VAPWR.n173 VAPWR.n22 185
R115 VAPWR.n157 VAPWR.n20 185
R116 VAPWR.n177 VAPWR.n19 185
R117 VAPWR.n178 VAPWR.n18 185
R118 VAPWR.n179 VAPWR.n17 185
R119 VAPWR.n160 VAPWR.n15 185
R120 VAPWR.n183 VAPWR.n14 185
R121 VAPWR.n184 VAPWR.n13 185
R122 VAPWR.n185 VAPWR.n12 185
R123 VAPWR.n163 VAPWR.n10 185
R124 VAPWR.n164 VAPWR.n163 185
R125 VAPWR.n163 VAPWR.n12 102.6
R126 VAPWR.n14 VAPWR.n13 102.6
R127 VAPWR.n160 VAPWR.n17 102.6
R128 VAPWR.n19 VAPWR.n18 102.6
R129 VAPWR.n157 VAPWR.n22 102.6
R130 VAPWR.n24 VAPWR.n23 102.6
R131 VAPWR.n111 VAPWR.n56 102.6
R132 VAPWR.n111 VAPWR.n57 102.6
R133 VAPWR.n57 VAPWR.n49 102.6
R134 VAPWR.n122 VAPWR.n49 102.6
R135 VAPWR.n122 VAPWR.n43 102.6
R136 VAPWR.n131 VAPWR.n43 102.6
R137 VAPWR.n131 VAPWR.n44 102.6
R138 VAPWR.n44 VAPWR.n37 102.6
R139 VAPWR.n37 VAPWR.n35 102.6
R140 VAPWR.n146 VAPWR.n35 102.6
R141 VAPWR.n146 VAPWR.n31 102.6
R142 VAPWR.n152 VAPWR.n31 102.6
R143 VAPWR.n152 VAPWR.n28 102.6
R144 VAPWR.n166 VAPWR.n28 102.6
R145 VAPWR.n68 VAPWR.n67 102.6
R146 VAPWR.n72 VAPWR.n67 102.6
R147 VAPWR.n74 VAPWR.n73 102.6
R148 VAPWR.n78 VAPWR.n77 102.6
R149 VAPWR.n80 VAPWR.n79 102.6
R150 VAPWR.n82 VAPWR.n62 102.6
R151 VAPWR.n113 VAPWR.n54 102.6
R152 VAPWR.n113 VAPWR.n50 102.6
R153 VAPWR.n119 VAPWR.n50 102.6
R154 VAPWR.n119 VAPWR.n42 102.6
R155 VAPWR.n134 VAPWR.n42 102.6
R156 VAPWR.n134 VAPWR.n38 102.6
R157 VAPWR.n141 VAPWR.n38 102.6
R158 VAPWR.n142 VAPWR.n141 102.6
R159 VAPWR.n142 VAPWR.n3 102.6
R160 VAPWR.n4 VAPWR.n3 102.6
R161 VAPWR.n5 VAPWR.n4 102.6
R162 VAPWR.n153 VAPWR.n5 102.6
R163 VAPWR.n153 VAPWR.n8 102.6
R164 VAPWR.n9 VAPWR.n8 102.6
R165 VAPWR.n102 VAPWR.n101 72.4195
R166 VAPWR.n102 VAPWR.n63 72.4195
R167 VAPWR.n102 VAPWR.n64 72.4195
R168 VAPWR.n102 VAPWR.n65 72.4195
R169 VAPWR.n102 VAPWR.n66 72.4195
R170 VAPWR.n103 VAPWR.n102 72.4195
R171 VAPWR.n164 VAPWR.n155 72.4195
R172 VAPWR.n164 VAPWR.n156 72.4195
R173 VAPWR.n164 VAPWR.n158 72.4195
R174 VAPWR.n164 VAPWR.n159 72.4195
R175 VAPWR.n164 VAPWR.n161 72.4195
R176 VAPWR.n164 VAPWR.n162 72.4195
R177 VAPWR.n102 VAPWR.n55 66.0875
R178 VAPWR.n165 VAPWR.n164 66.0875
R179 VAPWR.n112 VAPWR.n55 49.5657
R180 VAPWR.n112 VAPWR.t2 49.5657
R181 VAPWR.n120 VAPWR.t2 49.5657
R182 VAPWR.n121 VAPWR.n120 49.5657
R183 VAPWR.n133 VAPWR.n132 49.5657
R184 VAPWR.n132 VAPWR.n36 49.5657
R185 VAPWR.n143 VAPWR.n36 49.5657
R186 VAPWR.n144 VAPWR.n143 49.5657
R187 VAPWR.n145 VAPWR.n30 49.5657
R188 VAPWR.t4 VAPWR.n30 49.5657
R189 VAPWR.n154 VAPWR.t4 49.5657
R190 VAPWR.n165 VAPWR.n154 49.5657
R191 VAPWR.n162 VAPWR.n13 40.1639
R192 VAPWR.n161 VAPWR.n160 40.1639
R193 VAPWR.n159 VAPWR.n18 40.1639
R194 VAPWR.n158 VAPWR.n157 40.1639
R195 VAPWR.n156 VAPWR.n23 40.1639
R196 VAPWR.n155 VAPWR.n29 40.1639
R197 VAPWR.n101 VAPWR.n100 40.1639
R198 VAPWR.n72 VAPWR.n63 40.1639
R199 VAPWR.n74 VAPWR.n64 40.1639
R200 VAPWR.n78 VAPWR.n65 40.1639
R201 VAPWR.n80 VAPWR.n66 40.1639
R202 VAPWR.n103 VAPWR.n62 40.1639
R203 VAPWR.n101 VAPWR.n68 40.1639
R204 VAPWR.n73 VAPWR.n63 40.1639
R205 VAPWR.n77 VAPWR.n64 40.1639
R206 VAPWR.n79 VAPWR.n65 40.1639
R207 VAPWR.n82 VAPWR.n66 40.1639
R208 VAPWR.n104 VAPWR.n103 40.1639
R209 VAPWR.n155 VAPWR.n24 40.1639
R210 VAPWR.n156 VAPWR.n22 40.1639
R211 VAPWR.n158 VAPWR.n19 40.1639
R212 VAPWR.n159 VAPWR.n17 40.1639
R213 VAPWR.n161 VAPWR.n14 40.1639
R214 VAPWR.n162 VAPWR.n12 40.1639
R215 VAPWR.n133 VAPWR.t0 38.5512
R216 VAPWR.t6 VAPWR.n144 38.5512
R217 VAPWR.n99 VAPWR.n53 27.8405
R218 VAPWR.n189 VAPWR.n10 27.8405
R219 VAPWR.n105 VAPWR.n58 27.8405
R220 VAPWR.n167 VAPWR.n25 27.8405
R221 VAPWR.n114 VAPWR.n53 11.5205
R222 VAPWR.n114 VAPWR.n51 11.5205
R223 VAPWR.n118 VAPWR.n51 11.5205
R224 VAPWR.n118 VAPWR.n41 11.5205
R225 VAPWR.n135 VAPWR.n41 11.5205
R226 VAPWR.n135 VAPWR.n39 11.5205
R227 VAPWR.n140 VAPWR.n39 11.5205
R228 VAPWR.n140 VAPWR.n2 11.5205
R229 VAPWR.n196 VAPWR.n2 11.5205
R230 VAPWR.n196 VAPWR.n195 11.5205
R231 VAPWR.n195 VAPWR.n194 11.5205
R232 VAPWR.n194 VAPWR.n6 11.5205
R233 VAPWR.n190 VAPWR.n6 11.5205
R234 VAPWR.n190 VAPWR.n189 11.5205
R235 VAPWR.n99 VAPWR.n69 11.5205
R236 VAPWR.n95 VAPWR.n69 11.5205
R237 VAPWR.n95 VAPWR.n94 11.5205
R238 VAPWR.n94 VAPWR.n93 11.5205
R239 VAPWR.n93 VAPWR.n75 11.5205
R240 VAPWR.n89 VAPWR.n75 11.5205
R241 VAPWR.n89 VAPWR.n88 11.5205
R242 VAPWR.n88 VAPWR.n87 11.5205
R243 VAPWR.n87 VAPWR.n81 11.5205
R244 VAPWR.n83 VAPWR.n81 11.5205
R245 VAPWR.n83 VAPWR.n61 11.5205
R246 VAPWR.n105 VAPWR.n61 11.5205
R247 VAPWR.n110 VAPWR.n58 11.5205
R248 VAPWR.n110 VAPWR.n59 11.5205
R249 VAPWR.n59 VAPWR.n48 11.5205
R250 VAPWR.n123 VAPWR.n48 11.5205
R251 VAPWR.n123 VAPWR.n45 11.5205
R252 VAPWR.n130 VAPWR.n45 11.5205
R253 VAPWR.n130 VAPWR.n46 11.5205
R254 VAPWR.n126 VAPWR.n46 11.5205
R255 VAPWR.n126 VAPWR.n34 11.5205
R256 VAPWR.n147 VAPWR.n34 11.5205
R257 VAPWR.n147 VAPWR.n32 11.5205
R258 VAPWR.n151 VAPWR.n32 11.5205
R259 VAPWR.n151 VAPWR.n27 11.5205
R260 VAPWR.n167 VAPWR.n27 11.5205
R261 VAPWR.n185 VAPWR.n10 11.5205
R262 VAPWR.n185 VAPWR.n184 11.5205
R263 VAPWR.n184 VAPWR.n183 11.5205
R264 VAPWR.n183 VAPWR.n15 11.5205
R265 VAPWR.n179 VAPWR.n15 11.5205
R266 VAPWR.n179 VAPWR.n178 11.5205
R267 VAPWR.n178 VAPWR.n177 11.5205
R268 VAPWR.n177 VAPWR.n20 11.5205
R269 VAPWR.n173 VAPWR.n20 11.5205
R270 VAPWR.n173 VAPWR.n172 11.5205
R271 VAPWR.n172 VAPWR.n171 11.5205
R272 VAPWR.n171 VAPWR.n25 11.5205
R273 VAPWR.n121 VAPWR.t0 11.015
R274 VAPWR.n145 VAPWR.t6 11.015
R275 VAPWR.n169 VAPWR.n25 9.3005
R276 VAPWR.n171 VAPWR.n170 9.3005
R277 VAPWR.n172 VAPWR.n21 9.3005
R278 VAPWR.n174 VAPWR.n173 9.3005
R279 VAPWR.n175 VAPWR.n20 9.3005
R280 VAPWR.n177 VAPWR.n176 9.3005
R281 VAPWR.n178 VAPWR.n16 9.3005
R282 VAPWR.n180 VAPWR.n179 9.3005
R283 VAPWR.n181 VAPWR.n15 9.3005
R284 VAPWR.n183 VAPWR.n182 9.3005
R285 VAPWR.n184 VAPWR.n11 9.3005
R286 VAPWR.n186 VAPWR.n185 9.3005
R287 VAPWR.n187 VAPWR.n10 9.3005
R288 VAPWR.n168 VAPWR.n167 9.3005
R289 VAPWR.n27 VAPWR.n26 9.3005
R290 VAPWR.n151 VAPWR.n150 9.3005
R291 VAPWR.n149 VAPWR.n32 9.3005
R292 VAPWR.n148 VAPWR.n147 9.3005
R293 VAPWR.n34 VAPWR.n33 9.3005
R294 VAPWR.n127 VAPWR.n126 9.3005
R295 VAPWR.n128 VAPWR.n46 9.3005
R296 VAPWR.n130 VAPWR.n129 9.3005
R297 VAPWR.n125 VAPWR.n45 9.3005
R298 VAPWR.n124 VAPWR.n123 9.3005
R299 VAPWR.n48 VAPWR.n47 9.3005
R300 VAPWR.n108 VAPWR.n59 9.3005
R301 VAPWR.n110 VAPWR.n109 9.3005
R302 VAPWR.n107 VAPWR.n58 9.3005
R303 VAPWR.n99 VAPWR.n98 9.3005
R304 VAPWR.n97 VAPWR.n69 9.3005
R305 VAPWR.n96 VAPWR.n95 9.3005
R306 VAPWR.n94 VAPWR.n71 9.3005
R307 VAPWR.n93 VAPWR.n92 9.3005
R308 VAPWR.n91 VAPWR.n75 9.3005
R309 VAPWR.n90 VAPWR.n89 9.3005
R310 VAPWR.n88 VAPWR.n76 9.3005
R311 VAPWR.n87 VAPWR.n86 9.3005
R312 VAPWR.n85 VAPWR.n81 9.3005
R313 VAPWR.n84 VAPWR.n83 9.3005
R314 VAPWR.n61 VAPWR.n60 9.3005
R315 VAPWR.n106 VAPWR.n105 9.3005
R316 VAPWR.n70 VAPWR.n53 9.3005
R317 VAPWR.n115 VAPWR.n114 9.3005
R318 VAPWR.n116 VAPWR.n51 9.3005
R319 VAPWR.n118 VAPWR.n117 9.3005
R320 VAPWR.n41 VAPWR.n40 9.3005
R321 VAPWR.n136 VAPWR.n135 9.3005
R322 VAPWR.n138 VAPWR.n39 9.3005
R323 VAPWR.n140 VAPWR.n139 9.3005
R324 VAPWR.n2 VAPWR.n0 9.3005
R325 VAPWR.n197 VAPWR.n196 9.3005
R326 VAPWR.n195 VAPWR.n1 9.3005
R327 VAPWR.n194 VAPWR.n193 9.3005
R328 VAPWR.n192 VAPWR.n6 9.3005
R329 VAPWR.n191 VAPWR.n190 9.3005
R330 VAPWR.n189 VAPWR.n188 9.3005
R331 VAPWR.n169 VAPWR.n168 0.272375
R332 VAPWR.n107 VAPWR.n106 0.272375
R333 VAPWR VAPWR.n199 0.16047
R334 VAPWR.n188 VAPWR.n187 0.152375
R335 VAPWR.n98 VAPWR.n70 0.152375
R336 VAPWR.n187 VAPWR.n186 0.113
R337 VAPWR.n186 VAPWR.n11 0.113
R338 VAPWR.n182 VAPWR.n11 0.113
R339 VAPWR.n182 VAPWR.n181 0.113
R340 VAPWR.n181 VAPWR.n180 0.113
R341 VAPWR.n180 VAPWR.n16 0.113
R342 VAPWR.n176 VAPWR.n16 0.113
R343 VAPWR.n176 VAPWR.n175 0.113
R344 VAPWR.n175 VAPWR.n174 0.113
R345 VAPWR.n174 VAPWR.n21 0.113
R346 VAPWR.n170 VAPWR.n21 0.113
R347 VAPWR.n170 VAPWR.n169 0.113
R348 VAPWR.n109 VAPWR.n107 0.113
R349 VAPWR.n109 VAPWR.n108 0.113
R350 VAPWR.n108 VAPWR.n47 0.113
R351 VAPWR.n124 VAPWR.n47 0.113
R352 VAPWR.n125 VAPWR.n124 0.113
R353 VAPWR.n129 VAPWR.n125 0.113
R354 VAPWR.n129 VAPWR.n128 0.113
R355 VAPWR.n128 VAPWR.n127 0.113
R356 VAPWR.n127 VAPWR.n33 0.113
R357 VAPWR.n148 VAPWR.n33 0.113
R358 VAPWR.n149 VAPWR.n148 0.113
R359 VAPWR.n150 VAPWR.n149 0.113
R360 VAPWR.n150 VAPWR.n26 0.113
R361 VAPWR.n168 VAPWR.n26 0.113
R362 VAPWR.n98 VAPWR.n97 0.113
R363 VAPWR.n97 VAPWR.n96 0.113
R364 VAPWR.n96 VAPWR.n71 0.113
R365 VAPWR.n92 VAPWR.n71 0.113
R366 VAPWR.n92 VAPWR.n91 0.113
R367 VAPWR.n91 VAPWR.n90 0.113
R368 VAPWR.n90 VAPWR.n76 0.113
R369 VAPWR.n86 VAPWR.n76 0.113
R370 VAPWR.n86 VAPWR.n85 0.113
R371 VAPWR.n85 VAPWR.n84 0.113
R372 VAPWR.n84 VAPWR.n60 0.113
R373 VAPWR.n106 VAPWR.n60 0.113
R374 VAPWR.n116 VAPWR.n115 0.023
R375 VAPWR.n117 VAPWR.n116 0.023
R376 VAPWR.n117 VAPWR.n40 0.023
R377 VAPWR.n136 VAPWR.n40 0.023
R378 VAPWR.n139 VAPWR.n138 0.023
R379 VAPWR.n139 VAPWR.n0 0.023
R380 VAPWR.n197 VAPWR.n1 0.023
R381 VAPWR.n193 VAPWR.n1 0.023
R382 VAPWR.n193 VAPWR.n192 0.023
R383 VAPWR.n192 VAPWR.n191 0.023
R384 VAPWR.n70 VAPWR.n52 0.0205
R385 VAPWR.n188 VAPWR.n7 0.0205
R386 VAPWR.n138 VAPWR.n137 0.0155
R387 VAPWR.n199 VAPWR.n198 0.009875
R388 VAPWR.n137 VAPWR.n136 0.008
R389 VAPWR.n198 VAPWR.n197 0.008
R390 VAPWR.n199 VAPWR.n0 0.006125
R391 VAPWR.n115 VAPWR.n52 0.003
R392 VAPWR.n191 VAPWR.n7 0.003
R393 VDD.n20 VDD.n19 585
R394 VDD.n16 VDD.n15 585
R395 VDD.n21 VDD.n20 571.606
R396 VDD.n17 VDD.t1 397.385
R397 VDD.n153 VDD.n25 280.5
R398 VDD.n155 VDD.n43 280.5
R399 VDD.n111 VDD.n58 280.5
R400 VDD.n107 VDD.n69 280.5
R401 VDD.n20 VDD.n15 236.4
R402 VDD.n70 VDD.n69 185
R403 VDD.n69 VDD.n57 185
R404 VDD.n74 VDD.n55 185
R405 VDD.n118 VDD.n55 185
R406 VDD.n120 VDD.n56 185
R407 VDD.n120 VDD.n119 185
R408 VDD.n121 VDD.n2 185
R409 VDD.n122 VDD.n121 185
R410 VDD.n191 VDD.n3 185
R411 VDD.n49 VDD.n3 185
R412 VDD.n190 VDD.n4 185
R413 VDD.n130 VDD.n4 185
R414 VDD.n189 VDD.n5 185
R415 VDD.n131 VDD.n5 185
R416 VDD.n133 VDD.n6 185
R417 VDD.n134 VDD.n133 185
R418 VDD.n184 VDD.n9 185
R419 VDD.n132 VDD.n9 185
R420 VDD.n183 VDD.n10 185
R421 VDD.n142 VDD.n10 185
R422 VDD.n182 VDD.n11 185
R423 VDD.n143 VDD.n11 185
R424 VDD.n153 VDD.n12 185
R425 VDD.n154 VDD.n153 185
R426 VDD.n107 VDD.n106 185
R427 VDD.n71 VDD.n68 185
R428 VDD.n102 VDD.n67 185
R429 VDD.n109 VDD.n67 185
R430 VDD.n101 VDD.n79 185
R431 VDD.n100 VDD.n80 185
R432 VDD.n82 VDD.n81 185
R433 VDD.n96 VDD.n84 185
R434 VDD.n95 VDD.n85 185
R435 VDD.n94 VDD.n86 185
R436 VDD.n88 VDD.n87 185
R437 VDD.n90 VDD.n89 185
R438 VDD.n62 VDD.n61 185
R439 VDD.n112 VDD.n111 185
R440 VDD.n156 VDD.n155 185
R441 VDD.n155 VDD.n154 185
R442 VDD.n42 VDD.n41 185
R443 VDD.n143 VDD.n42 185
R444 VDD.n141 VDD.n140 185
R445 VDD.n142 VDD.n141 185
R446 VDD.n45 VDD.n44 185
R447 VDD.n132 VDD.n44 185
R448 VDD.n136 VDD.n135 185
R449 VDD.n135 VDD.n134 185
R450 VDD.n48 VDD.n47 185
R451 VDD.n131 VDD.n48 185
R452 VDD.n129 VDD.n128 185
R453 VDD.n130 VDD.n129 185
R454 VDD.n51 VDD.n50 185
R455 VDD.n50 VDD.n49 185
R456 VDD.n124 VDD.n123 185
R457 VDD.n123 VDD.n122 185
R458 VDD.n54 VDD.n53 185
R459 VDD.n119 VDD.n54 185
R460 VDD.n117 VDD.n116 185
R461 VDD.n118 VDD.n117 185
R462 VDD.n59 VDD.n58 185
R463 VDD.n58 VDD.n57 185
R464 VDD.n43 VDD.n39 185
R465 VDD.n161 VDD.n38 185
R466 VDD.n162 VDD.n37 185
R467 VDD.n163 VDD.n36 185
R468 VDD.n146 VDD.n34 185
R469 VDD.n167 VDD.n33 185
R470 VDD.n168 VDD.n32 185
R471 VDD.n169 VDD.n31 185
R472 VDD.n170 VDD.n30 185
R473 VDD.n149 VDD.n28 185
R474 VDD.n174 VDD.n27 185
R475 VDD.n175 VDD.n26 185
R476 VDD.n176 VDD.n25 185
R477 VDD.n152 VDD.n25 185
R478 VDD.n0 VDD.t7 134.649
R479 VDD.n76 VDD.t9 134.649
R480 VDD.t1 VDD.n15 118.201
R481 VDD.n26 VDD.n25 108.001
R482 VDD.n149 VDD.n27 108.001
R483 VDD.n31 VDD.n30 108.001
R484 VDD.n33 VDD.n32 108.001
R485 VDD.n146 VDD.n36 108.001
R486 VDD.n38 VDD.n37 108.001
R487 VDD.n117 VDD.n58 108.001
R488 VDD.n117 VDD.n54 108.001
R489 VDD.n123 VDD.n54 108.001
R490 VDD.n123 VDD.n50 108.001
R491 VDD.n129 VDD.n50 108.001
R492 VDD.n129 VDD.n48 108.001
R493 VDD.n135 VDD.n48 108.001
R494 VDD.n135 VDD.n44 108.001
R495 VDD.n141 VDD.n44 108.001
R496 VDD.n141 VDD.n42 108.001
R497 VDD.n155 VDD.n42 108.001
R498 VDD.n68 VDD.n67 108.001
R499 VDD.n79 VDD.n67 108.001
R500 VDD.n81 VDD.n80 108.001
R501 VDD.n85 VDD.n84 108.001
R502 VDD.n87 VDD.n86 108.001
R503 VDD.n89 VDD.n62 108.001
R504 VDD.n69 VDD.n55 108.001
R505 VDD.n120 VDD.n55 108.001
R506 VDD.n121 VDD.n120 108.001
R507 VDD.n121 VDD.n3 108.001
R508 VDD.n4 VDD.n3 108.001
R509 VDD.n5 VDD.n4 108.001
R510 VDD.n133 VDD.n5 108.001
R511 VDD.n133 VDD.n9 108.001
R512 VDD.n10 VDD.n9 108.001
R513 VDD.n11 VDD.n10 108.001
R514 VDD.n153 VDD.n11 108.001
R515 VDD.n109 VDD.n57 75.0367
R516 VDD.n154 VDD.n152 75.0367
R517 VDD.n186 VDD.n7 74.9836
R518 VDD.n109 VDD.n108 71.6014
R519 VDD.n109 VDD.n63 71.6014
R520 VDD.n109 VDD.n64 71.6014
R521 VDD.n109 VDD.n65 71.6014
R522 VDD.n109 VDD.n66 71.6014
R523 VDD.n110 VDD.n109 71.6014
R524 VDD.n152 VDD.n144 71.6014
R525 VDD.n152 VDD.n145 71.6014
R526 VDD.n152 VDD.n147 71.6014
R527 VDD.n152 VDD.n148 71.6014
R528 VDD.n152 VDD.n150 71.6014
R529 VDD.n152 VDD.n151 71.6014
R530 VDD.n118 VDD.n57 49.5657
R531 VDD.n122 VDD.n49 49.5657
R532 VDD.n130 VDD.n49 49.5657
R533 VDD.n131 VDD.n130 49.5657
R534 VDD.n134 VDD.n131 49.5657
R535 VDD.n154 VDD.n143 49.5657
R536 VDD.n151 VDD.n27 41.8002
R537 VDD.n150 VDD.n30 41.8002
R538 VDD.n148 VDD.n32 41.8002
R539 VDD.n147 VDD.n146 41.8002
R540 VDD.n145 VDD.n37 41.8002
R541 VDD.n144 VDD.n43 41.8002
R542 VDD.n108 VDD.n107 41.8002
R543 VDD.n79 VDD.n63 41.8002
R544 VDD.n81 VDD.n64 41.8002
R545 VDD.n85 VDD.n65 41.8002
R546 VDD.n87 VDD.n66 41.8002
R547 VDD.n110 VDD.n62 41.8002
R548 VDD.n108 VDD.n68 41.8002
R549 VDD.n80 VDD.n63 41.8002
R550 VDD.n84 VDD.n64 41.8002
R551 VDD.n86 VDD.n65 41.8002
R552 VDD.n89 VDD.n66 41.8002
R553 VDD.n111 VDD.n110 41.8002
R554 VDD.n144 VDD.n38 41.8002
R555 VDD.n145 VDD.n36 41.8002
R556 VDD.n147 VDD.n33 41.8002
R557 VDD.n148 VDD.n31 41.8002
R558 VDD.n150 VDD.n149 41.8002
R559 VDD.n151 VDD.n26 41.8002
R560 VDD.t4 VDD.n132 41.3048
R561 VDD.n119 VDD.t8 33.044
R562 VDD.t0 VDD.n142 33.044
R563 VDD.n106 VDD.n70 29.9205
R564 VDD.n176 VDD.n12 29.9205
R565 VDD.n112 VDD.n59 29.9205
R566 VDD.n156 VDD.n39 29.9205
R567 VDD.n119 VDD.t6 28.9135
R568 VDD.n142 VDD.t2 28.9135
R569 VDD.n19 VDD.n14 27.1064
R570 VDD.n19 VDD.n16 27.1064
R571 VDD.n22 VDD.n21 24.8327
R572 VDD.n122 VDD.t6 20.6527
R573 VDD.n132 VDD.t2 20.6527
R574 VDD.t8 VDD.n118 16.5222
R575 VDD.n143 VDD.t0 16.5222
R576 VDD.n74 VDD.n70 11.5205
R577 VDD.n74 VDD.n56 11.5205
R578 VDD.n56 VDD.n2 11.5205
R579 VDD.n191 VDD.n2 11.5205
R580 VDD.n191 VDD.n190 11.5205
R581 VDD.n190 VDD.n189 11.5205
R582 VDD.n189 VDD.n6 11.5205
R583 VDD.n184 VDD.n6 11.5205
R584 VDD.n184 VDD.n183 11.5205
R585 VDD.n183 VDD.n182 11.5205
R586 VDD.n182 VDD.n12 11.5205
R587 VDD.n106 VDD.n71 11.5205
R588 VDD.n102 VDD.n71 11.5205
R589 VDD.n102 VDD.n101 11.5205
R590 VDD.n101 VDD.n100 11.5205
R591 VDD.n100 VDD.n82 11.5205
R592 VDD.n96 VDD.n82 11.5205
R593 VDD.n96 VDD.n95 11.5205
R594 VDD.n95 VDD.n94 11.5205
R595 VDD.n94 VDD.n88 11.5205
R596 VDD.n90 VDD.n88 11.5205
R597 VDD.n90 VDD.n61 11.5205
R598 VDD.n112 VDD.n61 11.5205
R599 VDD.n116 VDD.n59 11.5205
R600 VDD.n116 VDD.n53 11.5205
R601 VDD.n124 VDD.n53 11.5205
R602 VDD.n124 VDD.n51 11.5205
R603 VDD.n128 VDD.n51 11.5205
R604 VDD.n128 VDD.n47 11.5205
R605 VDD.n136 VDD.n47 11.5205
R606 VDD.n136 VDD.n45 11.5205
R607 VDD.n140 VDD.n45 11.5205
R608 VDD.n140 VDD.n41 11.5205
R609 VDD.n156 VDD.n41 11.5205
R610 VDD.n176 VDD.n175 11.5205
R611 VDD.n175 VDD.n174 11.5205
R612 VDD.n174 VDD.n28 11.5205
R613 VDD.n170 VDD.n28 11.5205
R614 VDD.n170 VDD.n169 11.5205
R615 VDD.n169 VDD.n168 11.5205
R616 VDD.n168 VDD.n167 11.5205
R617 VDD.n167 VDD.n34 11.5205
R618 VDD.n163 VDD.n34 11.5205
R619 VDD.n163 VDD.n162 11.5205
R620 VDD.n162 VDD.n161 11.5205
R621 VDD.n161 VDD.n39 11.5205
R622 VDD.n21 VDD.n14 11.0627
R623 VDD.n7 VDD.t5 9.8505
R624 VDD.n7 VDD.t3 9.8505
R625 VDD.n14 VDD.n13 9.3005
R626 VDD.n19 VDD.n18 9.3005
R627 VDD.n159 VDD.n39 9.3005
R628 VDD.n161 VDD.n160 9.3005
R629 VDD.n162 VDD.n35 9.3005
R630 VDD.n164 VDD.n163 9.3005
R631 VDD.n165 VDD.n34 9.3005
R632 VDD.n167 VDD.n166 9.3005
R633 VDD.n168 VDD.n23 9.3005
R634 VDD.n169 VDD.n29 9.3005
R635 VDD.n171 VDD.n170 9.3005
R636 VDD.n172 VDD.n28 9.3005
R637 VDD.n174 VDD.n173 9.3005
R638 VDD.n175 VDD.n24 9.3005
R639 VDD.n177 VDD.n176 9.3005
R640 VDD.n157 VDD.n156 9.3005
R641 VDD.n41 VDD.n40 9.3005
R642 VDD.n140 VDD.n139 9.3005
R643 VDD.n138 VDD.n45 9.3005
R644 VDD.n137 VDD.n136 9.3005
R645 VDD.n47 VDD.n46 9.3005
R646 VDD.n128 VDD.n127 9.3005
R647 VDD.n126 VDD.n51 9.3005
R648 VDD.n125 VDD.n124 9.3005
R649 VDD.n53 VDD.n52 9.3005
R650 VDD.n116 VDD.n115 9.3005
R651 VDD.n114 VDD.n59 9.3005
R652 VDD.n106 VDD.n105 9.3005
R653 VDD.n104 VDD.n71 9.3005
R654 VDD.n103 VDD.n102 9.3005
R655 VDD.n101 VDD.n78 9.3005
R656 VDD.n100 VDD.n99 9.3005
R657 VDD.n98 VDD.n82 9.3005
R658 VDD.n97 VDD.n96 9.3005
R659 VDD.n95 VDD.n83 9.3005
R660 VDD.n94 VDD.n93 9.3005
R661 VDD.n92 VDD.n88 9.3005
R662 VDD.n91 VDD.n90 9.3005
R663 VDD.n61 VDD.n60 9.3005
R664 VDD.n113 VDD.n112 9.3005
R665 VDD.n77 VDD.n70 9.3005
R666 VDD.n75 VDD.n74 9.3005
R667 VDD.n73 VDD.n56 9.3005
R668 VDD.n72 VDD.n2 9.3005
R669 VDD.n192 VDD.n191 9.3005
R670 VDD.n190 VDD.n1 9.3005
R671 VDD.n189 VDD.n188 9.3005
R672 VDD.n187 VDD.n6 9.3005
R673 VDD.n185 VDD.n184 9.3005
R674 VDD.n183 VDD.n8 9.3005
R675 VDD.n182 VDD.n181 9.3005
R676 VDD.n179 VDD.n12 9.3005
R677 VDD.n134 VDD.t4 8.26137
R678 VDD.n17 VDD.n16 6.45639
R679 VDD.n178 VDD.n23 2.1255
R680 VDD.n158 VDD.n23 2.1255
R681 VDD.n18 VDD.n17 1.04058
R682 VDD.n180 VDD.n22 0.329204
R683 VDD.n159 VDD.n158 0.318937
R684 VDD.n178 VDD.n177 0.300188
R685 VDD.n114 VDD.n113 0.292688
R686 VDD.n177 VDD.n24 0.1805
R687 VDD.n173 VDD.n24 0.1805
R688 VDD.n173 VDD.n172 0.1805
R689 VDD.n172 VDD.n171 0.1805
R690 VDD.n171 VDD.n29 0.1805
R691 VDD.n29 VDD.n23 0.1805
R692 VDD.n166 VDD.n23 0.1805
R693 VDD.n166 VDD.n165 0.1805
R694 VDD.n165 VDD.n164 0.1805
R695 VDD.n164 VDD.n35 0.1805
R696 VDD.n160 VDD.n35 0.1805
R697 VDD.n160 VDD.n159 0.1805
R698 VDD.n22 VDD.n13 0.167167
R699 VDD.n18 VDD.n13 0.167167
R700 VDD.n105 VDD.n77 0.156437
R701 VDD VDD.n193 0.155825
R702 VDD.n158 VDD.n157 0.13175
R703 VDD.n115 VDD.n114 0.113
R704 VDD.n115 VDD.n52 0.113
R705 VDD.n125 VDD.n52 0.113
R706 VDD.n126 VDD.n125 0.113
R707 VDD.n127 VDD.n126 0.113
R708 VDD.n127 VDD.n46 0.113
R709 VDD.n137 VDD.n46 0.113
R710 VDD.n138 VDD.n137 0.113
R711 VDD.n139 VDD.n138 0.113
R712 VDD.n139 VDD.n40 0.113
R713 VDD.n157 VDD.n40 0.113
R714 VDD.n105 VDD.n104 0.113
R715 VDD.n104 VDD.n103 0.113
R716 VDD.n103 VDD.n78 0.113
R717 VDD.n99 VDD.n78 0.113
R718 VDD.n99 VDD.n98 0.113
R719 VDD.n98 VDD.n97 0.113
R720 VDD.n97 VDD.n83 0.113
R721 VDD.n93 VDD.n83 0.113
R722 VDD.n93 VDD.n92 0.113
R723 VDD.n92 VDD.n91 0.113
R724 VDD.n91 VDD.n60 0.113
R725 VDD.n113 VDD.n60 0.113
R726 VDD.n179 VDD.n178 0.02675
R727 VDD.n75 VDD.n73 0.023
R728 VDD.n73 VDD.n72 0.023
R729 VDD.n192 VDD.n1 0.023
R730 VDD.n188 VDD.n1 0.023
R731 VDD.n188 VDD.n187 0.023
R732 VDD.n185 VDD.n8 0.023
R733 VDD.n181 VDD.n8 0.023
R734 VDD.n187 VDD.n186 0.0183125
R735 VDD.n77 VDD.n76 0.0164375
R736 VDD.n180 VDD.n179 0.0164375
R737 VDD.n193 VDD.n192 0.0120625
R738 VDD.n76 VDD.n75 0.0070625
R739 VDD.n181 VDD.n180 0.0070625
R740 VDD.n193 VDD.n0 0.00675
R741 VDD.n72 VDD.n0 0.0051875
R742 VDD.n186 VDD.n185 0.0051875
R743 VSS.n336 VSS.n292 1424.76
R744 VSS.n63 VSS.n61 585
R745 VSS.n61 VSS.n54 585
R746 VSS.n263 VSS.n262 585
R747 VSS.n264 VSS.n263 585
R748 VSS.n81 VSS.n80 585
R749 VSS.n80 VSS.t10 585
R750 VSS.n257 VSS.n256 585
R751 VSS.n256 VSS.n255 585
R752 VSS.n84 VSS.n83 585
R753 VSS.n85 VSS.n84 585
R754 VSS.n232 VSS.n231 585
R755 VSS.n233 VSS.n232 585
R756 VSS.n104 VSS.n103 585
R757 VSS.n103 VSS.n102 585
R758 VSS.n227 VSS.n226 585
R759 VSS.n226 VSS.n225 585
R760 VSS.n107 VSS.n106 585
R761 VSS.n108 VSS.n107 585
R762 VSS.n214 VSS.n213 585
R763 VSS.n215 VSS.n214 585
R764 VSS.n125 VSS.n124 585
R765 VSS.n206 VSS.n124 585
R766 VSS.n209 VSS.n208 585
R767 VSS.n208 VSS.n207 585
R768 VSS.n128 VSS.n127 585
R769 VSS.t4 VSS.n128 585
R770 VSS.n197 VSS.n196 585
R771 VSS.n198 VSS.n197 585
R772 VSS.n146 VSS.n145 585
R773 VSS.n145 VSS.n144 585
R774 VSS.n192 VSS.n191 585
R775 VSS.n149 VSS.n148 585
R776 VSS.n188 VSS.n187 585
R777 VSS.n189 VSS.n188 585
R778 VSS.n186 VSS.n155 585
R779 VSS.n185 VSS.n184 585
R780 VSS.n183 VSS.n182 585
R781 VSS.n181 VSS.n180 585
R782 VSS.n179 VSS.n178 585
R783 VSS.n177 VSS.n176 585
R784 VSS.n175 VSS.n174 585
R785 VSS.n173 VSS.n172 585
R786 VSS.n171 VSS.n170 585
R787 VSS.n169 VSS.n168 585
R788 VSS.n268 VSS.n267 585
R789 VSS.n270 VSS.n269 585
R790 VSS.n272 VSS.n271 585
R791 VSS.n274 VSS.n273 585
R792 VSS.n276 VSS.n275 585
R793 VSS.n278 VSS.n277 585
R794 VSS.n280 VSS.n279 585
R795 VSS.n282 VSS.n281 585
R796 VSS.n284 VSS.n283 585
R797 VSS.n286 VSS.n285 585
R798 VSS.n288 VSS.n287 585
R799 VSS.n289 VSS.n62 585
R800 VSS.n291 VSS.n290 585
R801 VSS.n292 VSS.n291 585
R802 VSS.n266 VSS.n77 585
R803 VSS.n266 VSS.n54 585
R804 VSS.n265 VSS.n79 585
R805 VSS.n265 VSS.n264 585
R806 VSS.n88 VSS.n78 585
R807 VSS.t10 VSS.n78 585
R808 VSS.n254 VSS.n253 585
R809 VSS.n255 VSS.n254 585
R810 VSS.n87 VSS.n86 585
R811 VSS.n86 VSS.n85 585
R812 VSS.n235 VSS.n234 585
R813 VSS.n234 VSS.n233 585
R814 VSS.n101 VSS.n100 585
R815 VSS.n102 VSS.n101 585
R816 VSS.n224 VSS.n223 585
R817 VSS.n225 VSS.n224 585
R818 VSS.n110 VSS.n109 585
R819 VSS.n109 VSS.n108 585
R820 VSS.n217 VSS.n216 585
R821 VSS.n216 VSS.n215 585
R822 VSS.n123 VSS.n122 585
R823 VSS.n206 VSS.n123 585
R824 VSS.n205 VSS.n204 585
R825 VSS.n207 VSS.n205 585
R826 VSS.n130 VSS.n129 585
R827 VSS.n129 VSS.t4 585
R828 VSS.n200 VSS.n199 585
R829 VSS.n199 VSS.n198 585
R830 VSS.n143 VSS.n142 585
R831 VSS.n144 VSS.n143 585
R832 VSS.n53 VSS.n52 585
R833 VSS.n337 VSS.n53 585
R834 VSS.n341 VSS.n340 585
R835 VSS.n340 VSS.n339 585
R836 VSS.n50 VSS.n49 585
R837 VSS.n338 VSS.n49 585
R838 VSS.n346 VSS.n345 585
R839 VSS.n347 VSS.n346 585
R840 VSS.n47 VSS.n46 585
R841 VSS.n348 VSS.n47 585
R842 VSS.n351 VSS.n350 585
R843 VSS.n350 VSS.n349 585
R844 VSS.n44 VSS.n43 585
R845 VSS.n43 VSS.n41 585
R846 VSS.n356 VSS.n355 585
R847 VSS.n357 VSS.n356 585
R848 VSS.n40 VSS.n39 585
R849 VSS.n358 VSS.n40 585
R850 VSS.n361 VSS.n360 585
R851 VSS.n360 VSS.n359 585
R852 VSS.n36 VSS.n34 585
R853 VSS.n34 VSS.n32 585
R854 VSS.n403 VSS.n402 585
R855 VSS.n404 VSS.n403 585
R856 VSS.n407 VSS.n406 585
R857 VSS.n382 VSS.n30 585
R858 VSS.n384 VSS.n383 585
R859 VSS.n385 VSS.n380 585
R860 VSS.n379 VSS.n376 585
R861 VSS.n389 VSS.n375 585
R862 VSS.n390 VSS.n374 585
R863 VSS.n391 VSS.n372 585
R864 VSS.n371 VSS.n369 585
R865 VSS.n395 VSS.n368 585
R866 VSS.n396 VSS.n367 585
R867 VSS.n397 VSS.n365 585
R868 VSS.n37 VSS.n35 585
R869 VSS.n35 VSS.n33 585
R870 VSS.n405 VSS.n17 585
R871 VSS.n405 VSS.n404 585
R872 VSS.n413 VSS.n16 585
R873 VSS.n32 VSS.n16 585
R874 VSS.n414 VSS.n15 585
R875 VSS.n359 VSS.n15 585
R876 VSS.n415 VSS.n14 585
R877 VSS.n358 VSS.n14 585
R878 VSS.n42 VSS.n12 585
R879 VSS.n357 VSS.n42 585
R880 VSS.n419 VSS.n11 585
R881 VSS.n41 VSS.n11 585
R882 VSS.n420 VSS.n10 585
R883 VSS.n349 VSS.n10 585
R884 VSS.n421 VSS.n9 585
R885 VSS.n348 VSS.n9 585
R886 VSS.n48 VSS.n7 585
R887 VSS.n347 VSS.n48 585
R888 VSS.n426 VSS.n6 585
R889 VSS.n338 VSS.n6 585
R890 VSS.n427 VSS.n5 585
R891 VSS.n339 VSS.n5 585
R892 VSS.n428 VSS.n4 585
R893 VSS.n337 VSS.n4 585
R894 VSS.n334 VSS.n333 585
R895 VSS.n301 VSS.n300 585
R896 VSS.n329 VSS.n299 585
R897 VSS.n336 VSS.n299 585
R898 VSS.n328 VSS.n303 585
R899 VSS.n327 VSS.n304 585
R900 VSS.n306 VSS.n305 585
R901 VSS.n323 VSS.n308 585
R902 VSS.n322 VSS.n309 585
R903 VSS.n321 VSS.n310 585
R904 VSS.n312 VSS.n311 585
R905 VSS.n317 VSS.n314 585
R906 VSS.n316 VSS.n315 585
R907 VSS.n297 VSS.n3 585
R908 VSS.n403 VSS.n35 460.488
R909 VSS.n406 VSS.n405 460.488
R910 VSS.n297 VSS.n4 460.488
R911 VSS.n334 VSS.n53 460.488
R912 VSS.n291 VSS.n61 415.425
R913 VSS.n267 VSS.n266 415.425
R914 VSS.n168 VSS.n143 415.425
R915 VSS.n191 VSS.n145 415.425
R916 VSS.n26 VSS.n25 256.483
R917 VSS.n190 VSS.n189 255.031
R918 VSS.n189 VSS.n150 255.031
R919 VSS.n189 VSS.n151 255.031
R920 VSS.n189 VSS.n152 255.031
R921 VSS.n189 VSS.n153 255.031
R922 VSS.n189 VSS.n154 255.031
R923 VSS.n292 VSS.n55 255.031
R924 VSS.n292 VSS.n56 255.031
R925 VSS.n292 VSS.n57 255.031
R926 VSS.n292 VSS.n58 255.031
R927 VSS.n292 VSS.n59 255.031
R928 VSS.n292 VSS.n60 255.031
R929 VSS.n33 VSS.n31 254.01
R930 VSS.n381 VSS.n33 254.01
R931 VSS.n378 VSS.n33 254.01
R932 VSS.n373 VSS.n33 254.01
R933 VSS.n370 VSS.n33 254.01
R934 VSS.n366 VSS.n33 254.01
R935 VSS.n336 VSS.n335 254.01
R936 VSS.n336 VSS.n293 254.01
R937 VSS.n336 VSS.n294 254.01
R938 VSS.n336 VSS.n295 254.01
R939 VSS.n336 VSS.n296 254.01
R940 VSS.n336 VSS.n298 254.01
R941 VSS.n139 VSS.n138 248.305
R942 VSS.n119 VSS.n118 248.305
R943 VSS.n97 VSS.n96 248.305
R944 VSS.n246 VSS.n245 248.305
R945 VSS.n337 VSS.n336 228.381
R946 VSS.n404 VSS.n33 228.381
R947 VSS.n189 VSS.n144 201.143
R948 VSS.n292 VSS.n54 201.143
R949 VSS.n134 VSS.n133 185
R950 VSS.n138 VSS.n137 185
R951 VSS.n114 VSS.n113 185
R952 VSS.n118 VSS.n117 185
R953 VSS.n92 VSS.n91 185
R954 VSS.n96 VSS.n95 185
R955 VSS.n241 VSS.n240 185
R956 VSS.n245 VSS.n244 185
R957 VSS.n21 VSS.n20 185
R958 VSS.n25 VSS.n24 185
R959 VSS.n22 VSS.t1 180.947
R960 VSS.n365 VSS.n35 177.3
R961 VSS.n368 VSS.n367 177.3
R962 VSS.n372 VSS.n371 177.3
R963 VSS.n375 VSS.n374 177.3
R964 VSS.n380 VSS.n379 177.3
R965 VSS.n383 VSS.n382 177.3
R966 VSS.n5 VSS.n4 177.3
R967 VSS.n6 VSS.n5 177.3
R968 VSS.n48 VSS.n6 177.3
R969 VSS.n48 VSS.n9 177.3
R970 VSS.n10 VSS.n9 177.3
R971 VSS.n11 VSS.n10 177.3
R972 VSS.n42 VSS.n11 177.3
R973 VSS.n42 VSS.n14 177.3
R974 VSS.n15 VSS.n14 177.3
R975 VSS.n16 VSS.n15 177.3
R976 VSS.n405 VSS.n16 177.3
R977 VSS.n300 VSS.n299 177.3
R978 VSS.n303 VSS.n299 177.3
R979 VSS.n305 VSS.n304 177.3
R980 VSS.n309 VSS.n308 177.3
R981 VSS.n311 VSS.n310 177.3
R982 VSS.n315 VSS.n314 177.3
R983 VSS.n340 VSS.n53 177.3
R984 VSS.n340 VSS.n49 177.3
R985 VSS.n346 VSS.n49 177.3
R986 VSS.n346 VSS.n47 177.3
R987 VSS.n350 VSS.n47 177.3
R988 VSS.n350 VSS.n43 177.3
R989 VSS.n356 VSS.n43 177.3
R990 VSS.n356 VSS.n40 177.3
R991 VSS.n360 VSS.n40 177.3
R992 VSS.n360 VSS.n34 177.3
R993 VSS.n403 VSS.n34 177.3
R994 VSS.n135 VSS.t5 175.689
R995 VSS.n115 VSS.t3 175.689
R996 VSS.n93 VSS.t7 175.689
R997 VSS.n242 VSS.t11 175.689
R998 VSS.n291 VSS.n62 171.9
R999 VSS.n287 VSS.n286 171.9
R1000 VSS.n283 VSS.n282 171.9
R1001 VSS.n279 VSS.n278 171.9
R1002 VSS.n275 VSS.n274 171.9
R1003 VSS.n271 VSS.n270 171.9
R1004 VSS.n199 VSS.n143 171.9
R1005 VSS.n199 VSS.n129 171.9
R1006 VSS.n205 VSS.n129 171.9
R1007 VSS.n205 VSS.n123 171.9
R1008 VSS.n216 VSS.n123 171.9
R1009 VSS.n216 VSS.n109 171.9
R1010 VSS.n224 VSS.n109 171.9
R1011 VSS.n224 VSS.n101 171.9
R1012 VSS.n234 VSS.n101 171.9
R1013 VSS.n234 VSS.n86 171.9
R1014 VSS.n254 VSS.n86 171.9
R1015 VSS.n254 VSS.n78 171.9
R1016 VSS.n265 VSS.n78 171.9
R1017 VSS.n266 VSS.n265 171.9
R1018 VSS.n188 VSS.n149 171.9
R1019 VSS.n188 VSS.n155 171.9
R1020 VSS.n184 VSS.n183 171.9
R1021 VSS.n180 VSS.n179 171.9
R1022 VSS.n176 VSS.n175 171.9
R1023 VSS.n172 VSS.n171 171.9
R1024 VSS.n197 VSS.n145 171.9
R1025 VSS.n197 VSS.n128 171.9
R1026 VSS.n208 VSS.n128 171.9
R1027 VSS.n208 VSS.n124 171.9
R1028 VSS.n214 VSS.n124 171.9
R1029 VSS.n214 VSS.n107 171.9
R1030 VSS.n226 VSS.n107 171.9
R1031 VSS.n226 VSS.n103 171.9
R1032 VSS.n232 VSS.n103 171.9
R1033 VSS.n232 VSS.n84 171.9
R1034 VSS.n256 VSS.n84 171.9
R1035 VSS.n256 VSS.n80 171.9
R1036 VSS.n263 VSS.n80 171.9
R1037 VSS.n263 VSS.n61 171.9
R1038 VSS.n198 VSS.n144 150.857
R1039 VSS.n198 VSS.t4 150.857
R1040 VSS.n207 VSS.t4 150.857
R1041 VSS.n207 VSS.n206 150.857
R1042 VSS.n215 VSS.n108 150.857
R1043 VSS.n225 VSS.n108 150.857
R1044 VSS.n225 VSS.n102 150.857
R1045 VSS.n233 VSS.n102 150.857
R1046 VSS.n255 VSS.n85 150.857
R1047 VSS.n255 VSS.t10 150.857
R1048 VSS.n264 VSS.t10 150.857
R1049 VSS.n264 VSS.n54 150.857
R1050 VSS.n339 VSS.n337 150.857
R1051 VSS.n339 VSS.n338 150.857
R1052 VSS.n348 VSS.n347 150.857
R1053 VSS.n349 VSS.n348 150.857
R1054 VSS.n349 VSS.n41 150.857
R1055 VSS.n357 VSS.n41 150.857
R1056 VSS.n358 VSS.n357 150.857
R1057 VSS.n359 VSS.n358 150.857
R1058 VSS.n404 VSS.n32 150.857
R1059 VSS.n25 VSS.n20 144
R1060 VSS.n138 VSS.n133 136.8
R1061 VSS.n118 VSS.n113 136.8
R1062 VSS.n96 VSS.n91 136.8
R1063 VSS.n245 VSS.n240 136.8
R1064 VSS.n215 VSS.t2 117.334
R1065 VSS.n233 VSS.t6 117.334
R1066 VSS.n359 VSS.t0 100.572
R1067 VSS.n423 VSS.t9 98.7615
R1068 VSS.n338 VSS.t8 88.0005
R1069 VSS.n367 VSS.n366 76.985
R1070 VSS.n371 VSS.n370 76.985
R1071 VSS.n374 VSS.n373 76.985
R1072 VSS.n379 VSS.n378 76.985
R1073 VSS.n383 VSS.n381 76.985
R1074 VSS.n406 VSS.n31 76.985
R1075 VSS.n335 VSS.n334 76.985
R1076 VSS.n303 VSS.n293 76.985
R1077 VSS.n305 VSS.n294 76.985
R1078 VSS.n309 VSS.n295 76.985
R1079 VSS.n311 VSS.n296 76.985
R1080 VSS.n315 VSS.n298 76.985
R1081 VSS.n382 VSS.n31 76.985
R1082 VSS.n381 VSS.n380 76.985
R1083 VSS.n378 VSS.n375 76.985
R1084 VSS.n373 VSS.n372 76.985
R1085 VSS.n370 VSS.n368 76.985
R1086 VSS.n366 VSS.n365 76.985
R1087 VSS.n335 VSS.n300 76.985
R1088 VSS.n304 VSS.n293 76.985
R1089 VSS.n308 VSS.n294 76.985
R1090 VSS.n310 VSS.n295 76.985
R1091 VSS.n314 VSS.n296 76.985
R1092 VSS.n298 VSS.n297 76.985
R1093 VSS.n287 VSS.n60 74.9406
R1094 VSS.n283 VSS.n59 74.9406
R1095 VSS.n279 VSS.n58 74.9406
R1096 VSS.n275 VSS.n57 74.9406
R1097 VSS.n271 VSS.n56 74.9406
R1098 VSS.n267 VSS.n55 74.9406
R1099 VSS.n191 VSS.n190 74.9406
R1100 VSS.n155 VSS.n150 74.9406
R1101 VSS.n183 VSS.n151 74.9406
R1102 VSS.n179 VSS.n152 74.9406
R1103 VSS.n175 VSS.n153 74.9406
R1104 VSS.n171 VSS.n154 74.9406
R1105 VSS.n190 VSS.n149 74.9406
R1106 VSS.n184 VSS.n150 74.9406
R1107 VSS.n180 VSS.n151 74.9406
R1108 VSS.n176 VSS.n152 74.9406
R1109 VSS.n172 VSS.n153 74.9406
R1110 VSS.n168 VSS.n154 74.9406
R1111 VSS.n270 VSS.n55 74.9406
R1112 VSS.n274 VSS.n56 74.9406
R1113 VSS.n278 VSS.n57 74.9406
R1114 VSS.n282 VSS.n58 74.9406
R1115 VSS.n286 VSS.n59 74.9406
R1116 VSS.n62 VSS.n60 74.9406
R1117 VSS.t1 VSS.n20 72.0005
R1118 VSS.t5 VSS.n133 68.4005
R1119 VSS.t3 VSS.n113 68.4005
R1120 VSS.t7 VSS.n91 68.4005
R1121 VSS.t11 VSS.n240 68.4005
R1122 VSS.n347 VSS.t8 62.8576
R1123 VSS.t0 VSS.n32 50.2862
R1124 VSS.n206 VSS.t2 33.5243
R1125 VSS.t6 VSS.n85 33.5243
R1126 VSS.n333 VSS.n52 29.9205
R1127 VSS.n402 VSS.n37 29.9205
R1128 VSS.n407 VSS.n17 29.9205
R1129 VSS.n428 VSS.n3 29.9205
R1130 VSS.n290 VSS.n63 27.8405
R1131 VSS.n268 VSS.n77 27.8405
R1132 VSS.n169 VSS.n142 27.8405
R1133 VSS.n192 VSS.n146 27.8405
R1134 VSS.n137 VSS.n134 27.1064
R1135 VSS.n137 VSS.n132 27.1064
R1136 VSS.n117 VSS.n114 27.1064
R1137 VSS.n117 VSS.n112 27.1064
R1138 VSS.n95 VSS.n92 27.1064
R1139 VSS.n95 VSS.n90 27.1064
R1140 VSS.n244 VSS.n241 27.1064
R1141 VSS.n244 VSS.n239 27.1064
R1142 VSS.n24 VSS.n21 27.1064
R1143 VSS.n24 VSS.n19 27.1064
R1144 VSS.n27 VSS.n26 25.7818
R1145 VSS.n140 VSS.n139 25.6385
R1146 VSS.n120 VSS.n119 25.6385
R1147 VSS.n98 VSS.n97 25.6385
R1148 VSS.n247 VSS.n246 25.6385
R1149 VSS.n290 VSS.n289 11.5205
R1150 VSS.n289 VSS.n288 11.5205
R1151 VSS.n288 VSS.n285 11.5205
R1152 VSS.n285 VSS.n284 11.5205
R1153 VSS.n284 VSS.n281 11.5205
R1154 VSS.n281 VSS.n280 11.5205
R1155 VSS.n280 VSS.n277 11.5205
R1156 VSS.n277 VSS.n276 11.5205
R1157 VSS.n276 VSS.n273 11.5205
R1158 VSS.n273 VSS.n272 11.5205
R1159 VSS.n272 VSS.n269 11.5205
R1160 VSS.n269 VSS.n268 11.5205
R1161 VSS.n200 VSS.n142 11.5205
R1162 VSS.n200 VSS.n130 11.5205
R1163 VSS.n204 VSS.n130 11.5205
R1164 VSS.n204 VSS.n122 11.5205
R1165 VSS.n217 VSS.n122 11.5205
R1166 VSS.n217 VSS.n110 11.5205
R1167 VSS.n223 VSS.n110 11.5205
R1168 VSS.n223 VSS.n100 11.5205
R1169 VSS.n235 VSS.n100 11.5205
R1170 VSS.n235 VSS.n87 11.5205
R1171 VSS.n253 VSS.n87 11.5205
R1172 VSS.n253 VSS.n88 11.5205
R1173 VSS.n88 VSS.n79 11.5205
R1174 VSS.n79 VSS.n77 11.5205
R1175 VSS.n192 VSS.n148 11.5205
R1176 VSS.n187 VSS.n148 11.5205
R1177 VSS.n187 VSS.n186 11.5205
R1178 VSS.n186 VSS.n185 11.5205
R1179 VSS.n185 VSS.n182 11.5205
R1180 VSS.n182 VSS.n181 11.5205
R1181 VSS.n181 VSS.n178 11.5205
R1182 VSS.n178 VSS.n177 11.5205
R1183 VSS.n177 VSS.n174 11.5205
R1184 VSS.n174 VSS.n173 11.5205
R1185 VSS.n173 VSS.n170 11.5205
R1186 VSS.n170 VSS.n169 11.5205
R1187 VSS.n196 VSS.n146 11.5205
R1188 VSS.n196 VSS.n127 11.5205
R1189 VSS.n209 VSS.n127 11.5205
R1190 VSS.n209 VSS.n125 11.5205
R1191 VSS.n213 VSS.n125 11.5205
R1192 VSS.n213 VSS.n106 11.5205
R1193 VSS.n227 VSS.n106 11.5205
R1194 VSS.n227 VSS.n104 11.5205
R1195 VSS.n231 VSS.n104 11.5205
R1196 VSS.n231 VSS.n83 11.5205
R1197 VSS.n257 VSS.n83 11.5205
R1198 VSS.n257 VSS.n81 11.5205
R1199 VSS.n262 VSS.n81 11.5205
R1200 VSS.n262 VSS.n63 11.5205
R1201 VSS.n341 VSS.n52 11.5205
R1202 VSS.n341 VSS.n50 11.5205
R1203 VSS.n345 VSS.n50 11.5205
R1204 VSS.n345 VSS.n46 11.5205
R1205 VSS.n351 VSS.n46 11.5205
R1206 VSS.n351 VSS.n44 11.5205
R1207 VSS.n355 VSS.n44 11.5205
R1208 VSS.n355 VSS.n39 11.5205
R1209 VSS.n361 VSS.n39 11.5205
R1210 VSS.n361 VSS.n36 11.5205
R1211 VSS.n402 VSS.n36 11.5205
R1212 VSS.n397 VSS.n37 11.5205
R1213 VSS.n397 VSS.n396 11.5205
R1214 VSS.n396 VSS.n395 11.5205
R1215 VSS.n395 VSS.n369 11.5205
R1216 VSS.n391 VSS.n369 11.5205
R1217 VSS.n391 VSS.n390 11.5205
R1218 VSS.n390 VSS.n389 11.5205
R1219 VSS.n389 VSS.n376 11.5205
R1220 VSS.n385 VSS.n376 11.5205
R1221 VSS.n385 VSS.n384 11.5205
R1222 VSS.n384 VSS.n30 11.5205
R1223 VSS.n407 VSS.n30 11.5205
R1224 VSS.n428 VSS.n427 11.5205
R1225 VSS.n427 VSS.n426 11.5205
R1226 VSS.n426 VSS.n7 11.5205
R1227 VSS.n421 VSS.n7 11.5205
R1228 VSS.n421 VSS.n420 11.5205
R1229 VSS.n420 VSS.n419 11.5205
R1230 VSS.n419 VSS.n12 11.5205
R1231 VSS.n415 VSS.n12 11.5205
R1232 VSS.n415 VSS.n414 11.5205
R1233 VSS.n414 VSS.n413 11.5205
R1234 VSS.n413 VSS.n17 11.5205
R1235 VSS.n333 VSS.n301 11.5205
R1236 VSS.n329 VSS.n301 11.5205
R1237 VSS.n329 VSS.n328 11.5205
R1238 VSS.n328 VSS.n327 11.5205
R1239 VSS.n327 VSS.n306 11.5205
R1240 VSS.n323 VSS.n306 11.5205
R1241 VSS.n323 VSS.n322 11.5205
R1242 VSS.n322 VSS.n321 11.5205
R1243 VSS.n321 VSS.n312 11.5205
R1244 VSS.n317 VSS.n312 11.5205
R1245 VSS.n317 VSS.n316 11.5205
R1246 VSS.n316 VSS.n3 11.5205
R1247 VSS.n139 VSS.n132 9.39327
R1248 VSS.n119 VSS.n112 9.39327
R1249 VSS.n97 VSS.n90 9.39327
R1250 VSS.n246 VSS.n239 9.39327
R1251 VSS.n137 VSS.n136 9.3005
R1252 VSS.n132 VSS.n131 9.3005
R1253 VSS.n117 VSS.n116 9.3005
R1254 VSS.n112 VSS.n111 9.3005
R1255 VSS.n95 VSS.n94 9.3005
R1256 VSS.n90 VSS.n89 9.3005
R1257 VSS.n244 VSS.n243 9.3005
R1258 VSS.n239 VSS.n238 9.3005
R1259 VSS.n24 VSS.n23 9.3005
R1260 VSS.n19 VSS.n18 9.3005
R1261 VSS.n268 VSS.n76 9.3005
R1262 VSS.n269 VSS.n75 9.3005
R1263 VSS.n272 VSS.n74 9.3005
R1264 VSS.n273 VSS.n73 9.3005
R1265 VSS.n276 VSS.n72 9.3005
R1266 VSS.n277 VSS.n71 9.3005
R1267 VSS.n280 VSS.n70 9.3005
R1268 VSS.n281 VSS.n69 9.3005
R1269 VSS.n284 VSS.n68 9.3005
R1270 VSS.n285 VSS.n67 9.3005
R1271 VSS.n288 VSS.n66 9.3005
R1272 VSS.n289 VSS.n65 9.3005
R1273 VSS.n290 VSS.n64 9.3005
R1274 VSS.n193 VSS.n192 9.3005
R1275 VSS.n148 VSS.n147 9.3005
R1276 VSS.n187 VSS.n156 9.3005
R1277 VSS.n186 VSS.n157 9.3005
R1278 VSS.n185 VSS.n158 9.3005
R1279 VSS.n182 VSS.n159 9.3005
R1280 VSS.n181 VSS.n160 9.3005
R1281 VSS.n178 VSS.n161 9.3005
R1282 VSS.n177 VSS.n162 9.3005
R1283 VSS.n174 VSS.n163 9.3005
R1284 VSS.n173 VSS.n164 9.3005
R1285 VSS.n170 VSS.n165 9.3005
R1286 VSS.n169 VSS.n167 9.3005
R1287 VSS.n194 VSS.n146 9.3005
R1288 VSS.n196 VSS.n195 9.3005
R1289 VSS.n127 VSS.n126 9.3005
R1290 VSS.n210 VSS.n209 9.3005
R1291 VSS.n211 VSS.n125 9.3005
R1292 VSS.n213 VSS.n212 9.3005
R1293 VSS.n106 VSS.n105 9.3005
R1294 VSS.n228 VSS.n227 9.3005
R1295 VSS.n229 VSS.n104 9.3005
R1296 VSS.n231 VSS.n230 9.3005
R1297 VSS.n83 VSS.n82 9.3005
R1298 VSS.n258 VSS.n257 9.3005
R1299 VSS.n259 VSS.n81 9.3005
R1300 VSS.n262 VSS.n261 9.3005
R1301 VSS.n260 VSS.n63 9.3005
R1302 VSS.n408 VSS.n407 9.3005
R1303 VSS.n30 VSS.n29 9.3005
R1304 VSS.n384 VSS.n377 9.3005
R1305 VSS.n386 VSS.n385 9.3005
R1306 VSS.n387 VSS.n376 9.3005
R1307 VSS.n389 VSS.n388 9.3005
R1308 VSS.n390 VSS.n28 9.3005
R1309 VSS.n392 VSS.n391 9.3005
R1310 VSS.n393 VSS.n369 9.3005
R1311 VSS.n395 VSS.n394 9.3005
R1312 VSS.n396 VSS.n364 9.3005
R1313 VSS.n398 VSS.n397 9.3005
R1314 VSS.n399 VSS.n37 9.3005
R1315 VSS.n333 VSS.n332 9.3005
R1316 VSS.n331 VSS.n301 9.3005
R1317 VSS.n330 VSS.n329 9.3005
R1318 VSS.n328 VSS.n302 9.3005
R1319 VSS.n327 VSS.n326 9.3005
R1320 VSS.n325 VSS.n306 9.3005
R1321 VSS.n324 VSS.n323 9.3005
R1322 VSS.n322 VSS.n307 9.3005
R1323 VSS.n321 VSS.n320 9.3005
R1324 VSS.n319 VSS.n312 9.3005
R1325 VSS.n318 VSS.n317 9.3005
R1326 VSS.n316 VSS.n313 9.3005
R1327 VSS.n3 VSS.n1 9.3005
R1328 VSS.n52 VSS.n51 9.3005
R1329 VSS.n342 VSS.n341 9.3005
R1330 VSS.n343 VSS.n50 9.3005
R1331 VSS.n345 VSS.n344 9.3005
R1332 VSS.n46 VSS.n45 9.3005
R1333 VSS.n352 VSS.n351 9.3005
R1334 VSS.n353 VSS.n44 9.3005
R1335 VSS.n355 VSS.n354 9.3005
R1336 VSS.n39 VSS.n38 9.3005
R1337 VSS.n362 VSS.n361 9.3005
R1338 VSS.n363 VSS.n36 9.3005
R1339 VSS.n402 VSS.n401 9.3005
R1340 VSS.n201 VSS.n200 9.3005
R1341 VSS.n202 VSS.n130 9.3005
R1342 VSS.n204 VSS.n203 9.3005
R1343 VSS.n122 VSS.n121 9.3005
R1344 VSS.n218 VSS.n217 9.3005
R1345 VSS.n220 VSS.n110 9.3005
R1346 VSS.n223 VSS.n222 9.3005
R1347 VSS.n221 VSS.n100 9.3005
R1348 VSS.n236 VSS.n235 9.3005
R1349 VSS.n237 VSS.n87 9.3005
R1350 VSS.n253 VSS.n252 9.3005
R1351 VSS.n251 VSS.n88 9.3005
R1352 VSS.n250 VSS.n79 9.3005
R1353 VSS.n248 VSS.n77 9.3005
R1354 VSS.n166 VSS.n142 9.3005
R1355 VSS.n410 VSS.n17 9.3005
R1356 VSS.n413 VSS.n412 9.3005
R1357 VSS.n414 VSS.n13 9.3005
R1358 VSS.n416 VSS.n415 9.3005
R1359 VSS.n417 VSS.n12 9.3005
R1360 VSS.n419 VSS.n418 9.3005
R1361 VSS.n420 VSS.n8 9.3005
R1362 VSS.n422 VSS.n421 9.3005
R1363 VSS.n424 VSS.n7 9.3005
R1364 VSS.n426 VSS.n425 9.3005
R1365 VSS.n427 VSS.n2 9.3005
R1366 VSS.n429 VSS.n428 9.3005
R1367 VSS.n26 VSS.n19 9.2683
R1368 VSS.n135 VSS.n134 6.33109
R1369 VSS.n115 VSS.n114 6.33109
R1370 VSS.n93 VSS.n92 6.33109
R1371 VSS.n242 VSS.n241 6.33109
R1372 VSS.n22 VSS.n21 6.30777
R1373 VSS.n400 VSS.n28 2.1255
R1374 VSS.n409 VSS.n28 2.1255
R1375 VSS.n23 VSS.n22 1.18676
R1376 VSS.n136 VSS.n135 1.09351
R1377 VSS.n116 VSS.n115 1.09351
R1378 VSS.n94 VSS.n93 1.09351
R1379 VSS.n243 VSS.n242 1.09351
R1380 VSS.n411 VSS.n27 0.329204
R1381 VSS.n400 VSS.n399 0.318937
R1382 VSS.n409 VSS.n408 0.300188
R1383 VSS.n332 VSS.n51 0.292688
R1384 VSS.n194 VSS.n193 0.272375
R1385 VSS.n260 VSS.n64 0.272375
R1386 VSS VSS.n431 0.210312
R1387 VSS.n141 VSS.n140 0.206056
R1388 VSS.n219 VSS.n120 0.206056
R1389 VSS.n99 VSS.n98 0.206056
R1390 VSS.n249 VSS.n247 0.206056
R1391 VSS.n399 VSS.n398 0.1805
R1392 VSS.n398 VSS.n364 0.1805
R1393 VSS.n394 VSS.n364 0.1805
R1394 VSS.n394 VSS.n393 0.1805
R1395 VSS.n393 VSS.n392 0.1805
R1396 VSS.n392 VSS.n28 0.1805
R1397 VSS.n388 VSS.n28 0.1805
R1398 VSS.n388 VSS.n387 0.1805
R1399 VSS.n387 VSS.n386 0.1805
R1400 VSS.n386 VSS.n377 0.1805
R1401 VSS.n377 VSS.n29 0.1805
R1402 VSS.n408 VSS.n29 0.1805
R1403 VSS.n23 VSS.n18 0.167167
R1404 VSS.n27 VSS.n18 0.167167
R1405 VSS.n431 VSS.n430 0.153625
R1406 VSS.n167 VSS.n166 0.152375
R1407 VSS.n401 VSS.n400 0.13175
R1408 VSS.n76 VSS.n0 0.122375
R1409 VSS.n430 VSS.n1 0.122375
R1410 VSS.n193 VSS.n147 0.113
R1411 VSS.n156 VSS.n147 0.113
R1412 VSS.n157 VSS.n156 0.113
R1413 VSS.n158 VSS.n157 0.113
R1414 VSS.n159 VSS.n158 0.113
R1415 VSS.n160 VSS.n159 0.113
R1416 VSS.n161 VSS.n160 0.113
R1417 VSS.n162 VSS.n161 0.113
R1418 VSS.n163 VSS.n162 0.113
R1419 VSS.n164 VSS.n163 0.113
R1420 VSS.n165 VSS.n164 0.113
R1421 VSS.n167 VSS.n165 0.113
R1422 VSS.n195 VSS.n194 0.113
R1423 VSS.n195 VSS.n126 0.113
R1424 VSS.n210 VSS.n126 0.113
R1425 VSS.n211 VSS.n210 0.113
R1426 VSS.n212 VSS.n211 0.113
R1427 VSS.n212 VSS.n105 0.113
R1428 VSS.n228 VSS.n105 0.113
R1429 VSS.n229 VSS.n228 0.113
R1430 VSS.n230 VSS.n229 0.113
R1431 VSS.n230 VSS.n82 0.113
R1432 VSS.n258 VSS.n82 0.113
R1433 VSS.n259 VSS.n258 0.113
R1434 VSS.n261 VSS.n259 0.113
R1435 VSS.n261 VSS.n260 0.113
R1436 VSS.n65 VSS.n64 0.113
R1437 VSS.n66 VSS.n65 0.113
R1438 VSS.n67 VSS.n66 0.113
R1439 VSS.n68 VSS.n67 0.113
R1440 VSS.n69 VSS.n68 0.113
R1441 VSS.n70 VSS.n69 0.113
R1442 VSS.n71 VSS.n70 0.113
R1443 VSS.n72 VSS.n71 0.113
R1444 VSS.n73 VSS.n72 0.113
R1445 VSS.n74 VSS.n73 0.113
R1446 VSS.n75 VSS.n74 0.113
R1447 VSS.n76 VSS.n75 0.113
R1448 VSS.n332 VSS.n331 0.113
R1449 VSS.n331 VSS.n330 0.113
R1450 VSS.n330 VSS.n302 0.113
R1451 VSS.n326 VSS.n302 0.113
R1452 VSS.n326 VSS.n325 0.113
R1453 VSS.n325 VSS.n324 0.113
R1454 VSS.n324 VSS.n307 0.113
R1455 VSS.n320 VSS.n307 0.113
R1456 VSS.n320 VSS.n319 0.113
R1457 VSS.n319 VSS.n318 0.113
R1458 VSS.n318 VSS.n313 0.113
R1459 VSS.n313 VSS.n1 0.113
R1460 VSS.n342 VSS.n51 0.113
R1461 VSS.n343 VSS.n342 0.113
R1462 VSS.n344 VSS.n343 0.113
R1463 VSS.n344 VSS.n45 0.113
R1464 VSS.n352 VSS.n45 0.113
R1465 VSS.n353 VSS.n352 0.113
R1466 VSS.n354 VSS.n353 0.113
R1467 VSS.n354 VSS.n38 0.113
R1468 VSS.n362 VSS.n38 0.113
R1469 VSS.n363 VSS.n362 0.113
R1470 VSS.n401 VSS.n363 0.113
R1471 VSS.n136 VSS.n131 0.1005
R1472 VSS.n140 VSS.n131 0.1005
R1473 VSS.n116 VSS.n111 0.1005
R1474 VSS.n120 VSS.n111 0.1005
R1475 VSS.n94 VSS.n89 0.1005
R1476 VSS.n98 VSS.n89 0.1005
R1477 VSS.n243 VSS.n238 0.1005
R1478 VSS.n247 VSS.n238 0.1005
R1479 VSS.n431 VSS.n0 0.059875
R1480 VSS.n430 VSS.n429 0.0345625
R1481 VSS.n248 VSS.n0 0.0305
R1482 VSS.n410 VSS.n409 0.02675
R1483 VSS.n202 VSS.n201 0.023
R1484 VSS.n203 VSS.n202 0.023
R1485 VSS.n203 VSS.n121 0.023
R1486 VSS.n218 VSS.n121 0.023
R1487 VSS.n222 VSS.n220 0.023
R1488 VSS.n222 VSS.n221 0.023
R1489 VSS.n237 VSS.n236 0.023
R1490 VSS.n252 VSS.n237 0.023
R1491 VSS.n252 VSS.n251 0.023
R1492 VSS.n251 VSS.n250 0.023
R1493 VSS.n429 VSS.n2 0.023
R1494 VSS.n425 VSS.n2 0.023
R1495 VSS.n425 VSS.n424 0.023
R1496 VSS.n422 VSS.n8 0.023
R1497 VSS.n418 VSS.n8 0.023
R1498 VSS.n418 VSS.n417 0.023
R1499 VSS.n417 VSS.n416 0.023
R1500 VSS.n416 VSS.n13 0.023
R1501 VSS.n412 VSS.n13 0.023
R1502 VSS.n166 VSS.n141 0.0205
R1503 VSS.n249 VSS.n248 0.0205
R1504 VSS.n423 VSS.n422 0.0183125
R1505 VSS.n411 VSS.n410 0.0164375
R1506 VSS.n220 VSS.n219 0.0155
R1507 VSS.n221 VSS.n99 0.0155
R1508 VSS.n219 VSS.n218 0.008
R1509 VSS.n236 VSS.n99 0.008
R1510 VSS.n412 VSS.n411 0.0070625
R1511 VSS.n424 VSS.n423 0.0051875
R1512 VSS.n201 VSS.n141 0.003
R1513 VSS.n250 VSS.n249 0.003
C0 ctrl VAPWR 0.07992f
C1 VDD B 0.01099f
C2 ctrl_n ctrl 1.60926f
C3 ctrl_n VAPWR 0.01954f
C4 A B 1.82214f
C5 VDD in 1.04379f
C6 ctrl B 0.08843f
C7 B VAPWR 1.69466f
C8 VDD A 0.00239f
C9 ctrl_n B 0.68275f
C10 ctrl in 1.01935f
C11 ctrl VDD 2.91886f
C12 in VAPWR 0
C13 VDD VAPWR 0.53319f
C14 ctrl A 0.85742f
C15 ctrl_n in 0
C16 ctrl_n VDD 0.82347f
C17 A VAPWR 1.47403f
C18 ctrl_n A 0.47869f
C19 A VSS 1.4392f
C20 B VSS 1.43441f
C21 in VSS 0.91715f
C22 VAPWR VSS 8.70337f
C23 VDD VSS 7.83678f
C24 ctrl_n VSS 2.31496f
C25 ctrl VSS 2.90283f
C26 VDD.t7 VSS 0.0262f
C27 VDD.n0 VSS 0.06598f
C28 VDD.n1 VSS 0.03358f
C29 VDD.n2 VSS 0.00672f
C30 VDD.n3 VSS 0.00672f
C31 VDD.n4 VSS 0.00672f
C32 VDD.n5 VSS 0.00672f
C33 VDD.n6 VSS 0.00672f
C34 VDD.t5 VSS 0.01049f
C35 VDD.t3 VSS 0.01049f
C36 VDD.n7 VSS 0.02189f
C37 VDD.n8 VSS 0.03358f
C38 VDD.n9 VSS 0.00672f
C39 VDD.n10 VSS 0.00672f
C40 VDD.n11 VSS 0.00672f
C41 VDD.n12 VSS 0.01364f
C42 VDD.n13 VSS 0.00453f
C43 VDD.n14 VSS 0.00285f
C44 VDD.n15 VSS 0.00378f
C45 VDD.n16 VSS 0.0032f
C46 VDD.t1 VSS 0.00935f
C47 VDD.n17 VSS 0.01533f
C48 VDD.n18 VSS 0.03528f
C49 VDD.n19 VSS 0.00285f
C50 VDD.n20 VSS 0.01045f
C51 VDD.n21 VSS 0.00547f
C52 VDD.n22 VSS 0.00951f
C53 VDD.n23 VSS 0.02204f
C54 VDD.n24 VSS 0.0042f
C55 VDD.n25 VSS 0.01425f
C56 VDD.n26 VSS 0.00672f
C57 VDD.n27 VSS 0.00672f
C58 VDD.n28 VSS 0.00672f
C59 VDD.n29 VSS 0.0042f
C60 VDD.n30 VSS 0.00672f
C61 VDD.n31 VSS 0.00672f
C62 VDD.n32 VSS 0.00672f
C63 VDD.n33 VSS 0.00672f
C64 VDD.n34 VSS 0.00672f
C65 VDD.n35 VSS 0.0042f
C66 VDD.n36 VSS 0.00672f
C67 VDD.n37 VSS 0.00672f
C68 VDD.n38 VSS 0.00672f
C69 VDD.n39 VSS 0.01425f
C70 VDD.n40 VSS 0.00672f
C71 VDD.n41 VSS 0.00672f
C72 VDD.n42 VSS 0.00672f
C73 VDD.n43 VSS 0.01425f
C74 VDD.t2 VSS 0.05793f
C75 VDD.n44 VSS 0.00672f
C76 VDD.n45 VSS 0.00672f
C77 VDD.n46 VSS 0.00672f
C78 VDD.n47 VSS 0.00672f
C79 VDD.n48 VSS 0.00672f
C80 VDD.n49 VSS 0.11585f
C81 VDD.n50 VSS 0.00672f
C82 VDD.n51 VSS 0.00672f
C83 VDD.n52 VSS 0.00672f
C84 VDD.n53 VSS 0.00672f
C85 VDD.n54 VSS 0.00672f
C86 VDD.t6 VSS 0.05793f
C87 VDD.n55 VSS 0.00672f
C88 VDD.n56 VSS 0.00672f
C89 VDD.n57 VSS 0.14562f
C90 VDD.n58 VSS 0.01364f
C91 VDD.n59 VSS 0.01364f
C92 VDD.n60 VSS 0.00672f
C93 VDD.n61 VSS 0.00672f
C94 VDD.n62 VSS 0.00672f
C95 VDD.n67 VSS 0.00672f
C96 VDD.n68 VSS 0.00672f
C97 VDD.n69 VSS 0.01364f
C98 VDD.n70 VSS 0.01364f
C99 VDD.n71 VSS 0.00672f
C100 VDD.t9 VSS 0.0262f
C101 VDD.n72 VSS 0.02029f
C102 VDD.n73 VSS 0.03358f
C103 VDD.n74 VSS 0.00672f
C104 VDD.n75 VSS 0.02169f
C105 VDD.n76 VSS 0.07461f
C106 VDD.n77 VSS 0.16209f
C107 VDD.n78 VSS 0.00672f
C108 VDD.n79 VSS 0.00672f
C109 VDD.n80 VSS 0.00672f
C110 VDD.n81 VSS 0.00672f
C111 VDD.n82 VSS 0.00672f
C112 VDD.n83 VSS 0.00672f
C113 VDD.n84 VSS 0.00672f
C114 VDD.n85 VSS 0.00672f
C115 VDD.n86 VSS 0.00672f
C116 VDD.n87 VSS 0.00672f
C117 VDD.n88 VSS 0.00672f
C118 VDD.n89 VSS 0.00672f
C119 VDD.n90 VSS 0.00672f
C120 VDD.n91 VSS 0.00672f
C121 VDD.n92 VSS 0.00672f
C122 VDD.n93 VSS 0.00672f
C123 VDD.n94 VSS 0.00672f
C124 VDD.n95 VSS 0.00672f
C125 VDD.n96 VSS 0.00672f
C126 VDD.n97 VSS 0.00672f
C127 VDD.n98 VSS 0.00672f
C128 VDD.n99 VSS 0.00672f
C129 VDD.n100 VSS 0.00672f
C130 VDD.n101 VSS 0.00672f
C131 VDD.n102 VSS 0.00672f
C132 VDD.n103 VSS 0.00672f
C133 VDD.n104 VSS 0.00672f
C134 VDD.n105 VSS 0.04187f
C135 VDD.n106 VSS 0.01425f
C136 VDD.n107 VSS 0.01425f
C137 VDD.n109 VSS 0.31296f
C138 VDD.n111 VSS 0.01425f
C139 VDD.n112 VSS 0.01425f
C140 VDD.n113 VSS 0.01425f
C141 VDD.n114 VSS 0.01364f
C142 VDD.n115 VSS 0.00672f
C143 VDD.n116 VSS 0.00672f
C144 VDD.n117 VSS 0.00672f
C145 VDD.n118 VSS 0.07723f
C146 VDD.t8 VSS 0.05793f
C147 VDD.n119 VSS 0.07241f
C148 VDD.n120 VSS 0.00672f
C149 VDD.n121 VSS 0.00672f
C150 VDD.n122 VSS 0.08206f
C151 VDD.n123 VSS 0.00672f
C152 VDD.n124 VSS 0.00672f
C153 VDD.n125 VSS 0.00672f
C154 VDD.n126 VSS 0.00672f
C155 VDD.n127 VSS 0.00672f
C156 VDD.n128 VSS 0.00672f
C157 VDD.n129 VSS 0.00672f
C158 VDD.n130 VSS 0.11585f
C159 VDD.n131 VSS 0.11585f
C160 VDD.n132 VSS 0.07241f
C161 VDD.t4 VSS 0.05793f
C162 VDD.n133 VSS 0.00672f
C163 VDD.n134 VSS 0.06758f
C164 VDD.n135 VSS 0.00672f
C165 VDD.n136 VSS 0.00672f
C166 VDD.n137 VSS 0.00672f
C167 VDD.n138 VSS 0.00672f
C168 VDD.n139 VSS 0.00672f
C169 VDD.n140 VSS 0.00672f
C170 VDD.n141 VSS 0.00672f
C171 VDD.n142 VSS 0.07241f
C172 VDD.t0 VSS 0.05793f
C173 VDD.n143 VSS 0.07723f
C174 VDD.n146 VSS 0.00672f
C175 VDD.n149 VSS 0.00672f
C176 VDD.n152 VSS 0.31296f
C177 VDD.n153 VSS 0.01364f
C178 VDD.n154 VSS 0.14562f
C179 VDD.n155 VSS 0.01364f
C180 VDD.n156 VSS 0.01364f
C181 VDD.n157 VSS 0.00728f
C182 VDD.n158 VSS 0.01953f
C183 VDD.n159 VSS 0.00601f
C184 VDD.n160 VSS 0.0042f
C185 VDD.n161 VSS 0.00672f
C186 VDD.n162 VSS 0.00672f
C187 VDD.n163 VSS 0.00672f
C188 VDD.n164 VSS 0.0042f
C189 VDD.n165 VSS 0.0042f
C190 VDD.n166 VSS 0.0042f
C191 VDD.n167 VSS 0.00672f
C192 VDD.n168 VSS 0.00672f
C193 VDD.n169 VSS 0.00672f
C194 VDD.n170 VSS 0.00672f
C195 VDD.n171 VSS 0.0042f
C196 VDD.n172 VSS 0.0042f
C197 VDD.n173 VSS 0.0042f
C198 VDD.n174 VSS 0.00672f
C199 VDD.n175 VSS 0.00672f
C200 VDD.n176 VSS 0.01425f
C201 VDD.n177 VSS 0.00568f
C202 VDD.n178 VSS 0.04113f
C203 VDD.n179 VSS 0.03148f
C204 VDD.n180 VSS 0.02126f
C205 VDD.n181 VSS 0.02169f
C206 VDD.n182 VSS 0.00672f
C207 VDD.n183 VSS 0.00672f
C208 VDD.n184 VSS 0.00672f
C209 VDD.n185 VSS 0.02029f
C210 VDD.n186 VSS 0.08099f
C211 VDD.n187 VSS 0.03008f
C212 VDD.n188 VSS 0.03358f
C213 VDD.n189 VSS 0.00672f
C214 VDD.n190 VSS 0.00672f
C215 VDD.n191 VSS 0.00672f
C216 VDD.n192 VSS 0.02542f
C217 VDD.n193 VSS 0.68292f
C218 VAPWR.n0 VSS 0.01292f
C219 VAPWR.t7 VSS 0.00971f
C220 VAPWR.n1 VSS 0.02067f
C221 VAPWR.n2 VSS 0.00413f
C222 VAPWR.n3 VSS 0.00413f
C223 VAPWR.n4 VSS 0.00413f
C224 VAPWR.n5 VSS 0.00413f
C225 VAPWR.n6 VSS 0.00413f
C226 VAPWR.t5 VSS 0.00971f
C227 VAPWR.n7 VSS 0.0648f
C228 VAPWR.n8 VSS 0.00413f
C229 VAPWR.n9 VSS 0.00809f
C230 VAPWR.n10 VSS 0.00833f
C231 VAPWR.n11 VSS 0.00413f
C232 VAPWR.n12 VSS 0.00413f
C233 VAPWR.n13 VSS 0.00413f
C234 VAPWR.n14 VSS 0.00413f
C235 VAPWR.n15 VSS 0.00413f
C236 VAPWR.n16 VSS 0.00413f
C237 VAPWR.n17 VSS 0.00413f
C238 VAPWR.n18 VSS 0.00413f
C239 VAPWR.n19 VSS 0.00413f
C240 VAPWR.n20 VSS 0.00413f
C241 VAPWR.n21 VSS 0.00413f
C242 VAPWR.n22 VSS 0.00413f
C243 VAPWR.n23 VSS 0.00413f
C244 VAPWR.n24 VSS 0.00413f
C245 VAPWR.n25 VSS 0.00833f
C246 VAPWR.n26 VSS 0.00413f
C247 VAPWR.n27 VSS 0.00413f
C248 VAPWR.n28 VSS 0.00413f
C249 VAPWR.n29 VSS 0.00833f
C250 VAPWR.n30 VSS 0.07131f
C251 VAPWR.n31 VSS 0.00413f
C252 VAPWR.n32 VSS 0.00413f
C253 VAPWR.n33 VSS 0.00413f
C254 VAPWR.n34 VSS 0.00413f
C255 VAPWR.n35 VSS 0.00413f
C256 VAPWR.n36 VSS 0.07131f
C257 VAPWR.n37 VSS 0.00413f
C258 VAPWR.n38 VSS 0.00413f
C259 VAPWR.n39 VSS 0.00413f
C260 VAPWR.t1 VSS 0.00971f
C261 VAPWR.n40 VSS 0.02067f
C262 VAPWR.n41 VSS 0.00413f
C263 VAPWR.n42 VSS 0.00413f
C264 VAPWR.t0 VSS 0.03565f
C265 VAPWR.n43 VSS 0.00413f
C266 VAPWR.n44 VSS 0.00413f
C267 VAPWR.n45 VSS 0.00413f
C268 VAPWR.n46 VSS 0.00413f
C269 VAPWR.n47 VSS 0.00413f
C270 VAPWR.n48 VSS 0.00413f
C271 VAPWR.n49 VSS 0.00413f
C272 VAPWR.t2 VSS 0.07131f
C273 VAPWR.n50 VSS 0.00413f
C274 VAPWR.n51 VSS 0.00413f
C275 VAPWR.t3 VSS 0.00971f
C276 VAPWR.n52 VSS 0.0648f
C277 VAPWR.n53 VSS 0.00809f
C278 VAPWR.n54 VSS 0.00809f
C279 VAPWR.n55 VSS 0.08319f
C280 VAPWR.n56 VSS 0.00809f
C281 VAPWR.n57 VSS 0.00413f
C282 VAPWR.n58 VSS 0.00809f
C283 VAPWR.n59 VSS 0.00413f
C284 VAPWR.n60 VSS 0.00413f
C285 VAPWR.n61 VSS 0.00413f
C286 VAPWR.n62 VSS 0.00413f
C287 VAPWR.n67 VSS 0.00413f
C288 VAPWR.n68 VSS 0.00413f
C289 VAPWR.n69 VSS 0.00413f
C290 VAPWR.n70 VSS 0.05886f
C291 VAPWR.n71 VSS 0.00413f
C292 VAPWR.n72 VSS 0.00413f
C293 VAPWR.n73 VSS 0.00413f
C294 VAPWR.n74 VSS 0.00413f
C295 VAPWR.n75 VSS 0.00413f
C296 VAPWR.n76 VSS 0.00413f
C297 VAPWR.n77 VSS 0.00413f
C298 VAPWR.n78 VSS 0.00413f
C299 VAPWR.n79 VSS 0.00413f
C300 VAPWR.n80 VSS 0.00413f
C301 VAPWR.n81 VSS 0.00413f
C302 VAPWR.n82 VSS 0.00413f
C303 VAPWR.n83 VSS 0.00413f
C304 VAPWR.n84 VSS 0.00413f
C305 VAPWR.n85 VSS 0.00413f
C306 VAPWR.n86 VSS 0.00413f
C307 VAPWR.n87 VSS 0.00413f
C308 VAPWR.n88 VSS 0.00413f
C309 VAPWR.n89 VSS 0.00413f
C310 VAPWR.n90 VSS 0.00413f
C311 VAPWR.n91 VSS 0.00413f
C312 VAPWR.n92 VSS 0.00413f
C313 VAPWR.n93 VSS 0.00413f
C314 VAPWR.n94 VSS 0.00413f
C315 VAPWR.n95 VSS 0.00413f
C316 VAPWR.n96 VSS 0.00413f
C317 VAPWR.n97 VSS 0.00413f
C318 VAPWR.n98 VSS 0.01314f
C319 VAPWR.n99 VSS 0.00833f
C320 VAPWR.n100 VSS 0.00833f
C321 VAPWR.n102 VSS 0.18619f
C322 VAPWR.n104 VSS 0.00833f
C323 VAPWR.n105 VSS 0.00833f
C324 VAPWR.n106 VSS 0.00833f
C325 VAPWR.n107 VSS 0.00809f
C326 VAPWR.n108 VSS 0.00413f
C327 VAPWR.n109 VSS 0.00413f
C328 VAPWR.n110 VSS 0.00413f
C329 VAPWR.n111 VSS 0.00413f
C330 VAPWR.n112 VSS 0.07131f
C331 VAPWR.n113 VSS 0.00413f
C332 VAPWR.n114 VSS 0.00413f
C333 VAPWR.n115 VSS 0.01148f
C334 VAPWR.n116 VSS 0.02067f
C335 VAPWR.n117 VSS 0.02067f
C336 VAPWR.n118 VSS 0.00413f
C337 VAPWR.n119 VSS 0.00413f
C338 VAPWR.n120 VSS 0.07131f
C339 VAPWR.n121 VSS 0.04358f
C340 VAPWR.n122 VSS 0.00413f
C341 VAPWR.n123 VSS 0.00413f
C342 VAPWR.n124 VSS 0.00413f
C343 VAPWR.n125 VSS 0.00413f
C344 VAPWR.n126 VSS 0.00413f
C345 VAPWR.n127 VSS 0.00413f
C346 VAPWR.n128 VSS 0.00413f
C347 VAPWR.n129 VSS 0.00413f
C348 VAPWR.n130 VSS 0.00413f
C349 VAPWR.n131 VSS 0.00413f
C350 VAPWR.n132 VSS 0.07131f
C351 VAPWR.n133 VSS 0.06338f
C352 VAPWR.n134 VSS 0.00413f
C353 VAPWR.n135 VSS 0.00413f
C354 VAPWR.n136 VSS 0.01378f
C355 VAPWR.n137 VSS 0.0648f
C356 VAPWR.n138 VSS 0.01722f
C357 VAPWR.n139 VSS 0.02067f
C358 VAPWR.n140 VSS 0.00413f
C359 VAPWR.n141 VSS 0.00413f
C360 VAPWR.n142 VSS 0.00413f
C361 VAPWR.n143 VSS 0.07131f
C362 VAPWR.n144 VSS 0.06338f
C363 VAPWR.t6 VSS 0.03565f
C364 VAPWR.n145 VSS 0.04358f
C365 VAPWR.n146 VSS 0.00413f
C366 VAPWR.n147 VSS 0.00413f
C367 VAPWR.n148 VSS 0.00413f
C368 VAPWR.n149 VSS 0.00413f
C369 VAPWR.n150 VSS 0.00413f
C370 VAPWR.n151 VSS 0.00413f
C371 VAPWR.n152 VSS 0.00413f
C372 VAPWR.n153 VSS 0.00413f
C373 VAPWR.t4 VSS 0.07131f
C374 VAPWR.n154 VSS 0.07131f
C375 VAPWR.n157 VSS 0.00413f
C376 VAPWR.n160 VSS 0.00413f
C377 VAPWR.n163 VSS 0.00833f
C378 VAPWR.n164 VSS 0.18619f
C379 VAPWR.n165 VSS 0.08319f
C380 VAPWR.n166 VSS 0.00809f
C381 VAPWR.n167 VSS 0.00809f
C382 VAPWR.n168 VSS 0.00809f
C383 VAPWR.n169 VSS 0.00833f
C384 VAPWR.n170 VSS 0.00413f
C385 VAPWR.n171 VSS 0.00413f
C386 VAPWR.n172 VSS 0.00413f
C387 VAPWR.n173 VSS 0.00413f
C388 VAPWR.n174 VSS 0.00413f
C389 VAPWR.n175 VSS 0.00413f
C390 VAPWR.n176 VSS 0.00413f
C391 VAPWR.n177 VSS 0.00413f
C392 VAPWR.n178 VSS 0.00413f
C393 VAPWR.n179 VSS 0.00413f
C394 VAPWR.n180 VSS 0.00413f
C395 VAPWR.n181 VSS 0.00413f
C396 VAPWR.n182 VSS 0.00413f
C397 VAPWR.n183 VSS 0.00413f
C398 VAPWR.n184 VSS 0.00413f
C399 VAPWR.n185 VSS 0.00413f
C400 VAPWR.n186 VSS 0.00413f
C401 VAPWR.n187 VSS 0.02335f
C402 VAPWR.n188 VSS 0.10032f
C403 VAPWR.n189 VSS 0.00809f
C404 VAPWR.n190 VSS 0.00413f
C405 VAPWR.n191 VSS 0.01148f
C406 VAPWR.n192 VSS 0.02067f
C407 VAPWR.n193 VSS 0.02067f
C408 VAPWR.n194 VSS 0.00413f
C409 VAPWR.n195 VSS 0.00413f
C410 VAPWR.n196 VSS 0.00413f
C411 VAPWR.n197 VSS 0.01378f
C412 VAPWR.n198 VSS 0.06222f
C413 VAPWR.n199 VSS 0.56925f
C414 in.t1 VSS 0.11976f
C415 in.t2 VSS 0.13573f
C416 in.n0 VSS 0.40924f
C417 in.t3 VSS 0.11975f
C418 in.n1 VSS 0.22504f
C419 in.t0 VSS 0.12127f
C420 in.n2 VSS 0.7477f
C421 B.t4 VSS 0.32715f
C422 B.t5 VSS 0.26134f
C423 B.n0 VSS 0.67133f
C424 B.t1 VSS 0.03891f
C425 B.t0 VSS 0.03891f
C426 B.n1 VSS 0.0903f
C427 B.t3 VSS 0.0681f
C428 B.t2 VSS 0.0681f
C429 B.n2 VSS 0.28214f
C430 B.n3 VSS 1.51152f
C431 B.n4 VSS 0.74121f
C432 A.t0 VSS 0.04119f
C433 A.t1 VSS 0.04119f
C434 A.n0 VSS 0.09853f
C435 A.t3 VSS 0.07208f
C436 A.t2 VSS 0.07208f
C437 A.n1 VSS 0.27866f
C438 A.n2 VSS 1.63121f
C439 A.t4 VSS 0.3463f
C440 A.t5 VSS 0.27663f
C441 A.n3 VSS 0.78237f
C442 A.n4 VSS 0.74639f
.ends
