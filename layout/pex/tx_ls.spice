* tx_ls: magic R+C extraction of layout/tx_ls.gds (layout/pex.sh)
.subckt tx_ls in A B VDD VAPWR VSS
X0 ctrl_n ctrl VDD.t7 VDD.t6 sky130_fd_pr__pfet_01v8_hvt ad=0.3 pd=2.6 as=0.3 ps=2.6 w=1 l=0.15
X1 ctrl_n ctrl VSS.t7 VSS.t6 sky130_fd_pr__nfet_01v8 ad=0.126 pd=1.44 as=0.126 ps=1.44 w=0.42 l=0.15
X2 A.t0 B.t2 VAPWR.t3 VAPWR.t2 sky130_fd_pr__pfet_g5v0d10v5 ad=0.504 pd=3.96 as=0.504 ps=3.96 w=1.68 l=0.5
X3 B.t1 ctrl_n VSS.t3 VSS.t2 sky130_fd_pr__nfet_g5v0d10v5 ad=1.26 pd=9 as=1.26 ps=9 w=4.2 l=0.5
X4 ctrl in.t0 VSS.t1 VSS.t0 sky130_fd_pr__nfet_01v8 ad=0.9 pd=6.6 as=0.9 ps=6.6 w=3 l=0.15
X5 ctrl in.t1 VDD.t5 VDD.t4 sky130_fd_pr__pfet_01v8 ad=0.9 pd=6.6 as=0.45 ps=3.3 w=3 l=0.15
X6 A.t1 ctrl VSS.t5 VSS.t4 sky130_fd_pr__nfet_g5v0d10v5 ad=1.26 pd=9 as=1.26 ps=9 w=4.2 l=0.5
X7 VDD.t3 in.t2 ctrl VDD.t2 sky130_fd_pr__pfet_01v8 ad=0.45 pd=3.3 as=0.45 ps=3.3 w=3 l=0.15
X8 ctrl in.t3 VDD.t1 VDD.t0 sky130_fd_pr__pfet_01v8 ad=0.45 pd=3.3 as=0.9 ps=6.6 w=3 l=0.15
X9 B.t0 A.t2 VAPWR.t1 VAPWR.t0 sky130_fd_pr__pfet_g5v0d10v5 ad=0.504 pd=3.96 as=0.504 ps=3.96 w=1.68 l=0.5
R0 A.n1 A.t2 286.959
R1 A.n0 A.t0 236.319
R2 A.n0 A.t1 27.7823
R3 A.n1 A.n0 3.55667
R4 A A.n1 0.11659
R5 B.n1 B.t2 286.522
R6 B.n0 B.t0 235.651
R7 B.n0 B.t1 28.449
R8 B.n1 B.n0 3.4105
R9 B B.n1 0.07476
R10 in.n0 in.t2 961.957
R11 in.n2 in.t0 743.15
R12 in.n0 in.t1 737.083
R13 in.n1 in.t3 737.023
R14 in in.n2 3.49886
R15 in.n2 in.n1 2.99947
R16 in.n1 in.n0 0.0609839
R17 VAPWR.n7 VAPWR.t3 230.542
R18 VAPWR.n114 VAPWR.t1 230.542
R19 VAPWR.n141 VAPWR.n9 225.15
R20 VAPWR.n143 VAPWR.n24 225.15
R21 VAPWR.n74 VAPWR.n73 225.15
R22 VAPWR.n48 VAPWR.n45 225.15
R23 VAPWR.n46 VAPWR.n45 185
R24 VAPWR.n45 VAPWR.n44 185
R25 VAPWR.n99 VAPWR.n98 185
R26 VAPWR.n100 VAPWR.n99 185
R27 VAPWR.n38 VAPWR.n37 185
R28 VAPWR.n101 VAPWR.n38 185
R29 VAPWR.n112 VAPWR.n111 185
R30 VAPWR.n111 VAPWR.n110 185
R31 VAPWR.n35 VAPWR.n34 185
R32 VAPWR.n109 VAPWR.n34 185
R33 VAPWR.n118 VAPWR.n117 185
R34 VAPWR.n118 VAPWR.n32 185
R35 VAPWR.n119 VAPWR.n2 185
R36 VAPWR.n120 VAPWR.n119 185
R37 VAPWR.n169 VAPWR.n3 185
R38 VAPWR.n33 VAPWR.n3 185
R39 VAPWR.n168 VAPWR.n4 185
R40 VAPWR.n129 VAPWR.n4 185
R41 VAPWR.n167 VAPWR.n5 185
R42 VAPWR.n130 VAPWR.n5 185
R43 VAPWR.n141 VAPWR.n6 185
R44 VAPWR.n142 VAPWR.n141 185
R45 VAPWR.n94 VAPWR.n48 185
R46 VAPWR.n93 VAPWR.n49 185
R47 VAPWR.n92 VAPWR.n50 185
R48 VAPWR.n71 VAPWR.n50 185
R49 VAPWR.n64 VAPWR.n51 185
R50 VAPWR.n88 VAPWR.n53 185
R51 VAPWR.n87 VAPWR.n54 185
R52 VAPWR.n86 VAPWR.n55 185
R53 VAPWR.n67 VAPWR.n56 185
R54 VAPWR.n82 VAPWR.n58 185
R55 VAPWR.n81 VAPWR.n59 185
R56 VAPWR.n80 VAPWR.n60 185
R57 VAPWR.n63 VAPWR.n61 185
R58 VAPWR.n76 VAPWR.n73 185
R59 VAPWR.n144 VAPWR.n143 185
R60 VAPWR.n143 VAPWR.n142 185
R61 VAPWR.n26 VAPWR.n25 185
R62 VAPWR.n130 VAPWR.n26 185
R63 VAPWR.n128 VAPWR.n127 185
R64 VAPWR.n129 VAPWR.n128 185
R65 VAPWR.n28 VAPWR.n27 185
R66 VAPWR.n33 VAPWR.n27 185
R67 VAPWR.n122 VAPWR.n121 185
R68 VAPWR.n121 VAPWR.n120 185
R69 VAPWR.n31 VAPWR.n30 185
R70 VAPWR.n32 VAPWR.n31 185
R71 VAPWR.n108 VAPWR.n107 185
R72 VAPWR.n109 VAPWR.n108 185
R73 VAPWR.n40 VAPWR.n39 185
R74 VAPWR.n110 VAPWR.n39 185
R75 VAPWR.n103 VAPWR.n102 185
R76 VAPWR.n102 VAPWR.n101 185
R77 VAPWR.n43 VAPWR.n42 185
R78 VAPWR.n100 VAPWR.n43 185
R79 VAPWR.n75 VAPWR.n74 185
R80 VAPWR.n74 VAPWR.n44 185
R81 VAPWR.n145 VAPWR.n24 185
R82 VAPWR.n131 VAPWR.n22 185
R83 VAPWR.n149 VAPWR.n21 185
R84 VAPWR.n150 VAPWR.n20 185
R85 VAPWR.n151 VAPWR.n19 185
R86 VAPWR.n134 VAPWR.n17 185
R87 VAPWR.n155 VAPWR.n16 185
R88 VAPWR.n156 VAPWR.n15 185
R89 VAPWR.n157 VAPWR.n14 185
R90 VAPWR.n137 VAPWR.n12 185
R91 VAPWR.n161 VAPWR.n11 185
R92 VAPWR.n162 VAPWR.n10 185
R93 VAPWR.n163 VAPWR.n9 185
R94 VAPWR.n140 VAPWR.n9 185
R95 VAPWR.n10 VAPWR.n9 102.6
R96 VAPWR.n137 VAPWR.n11 102.6
R97 VAPWR.n15 VAPWR.n14 102.6
R98 VAPWR.n134 VAPWR.n16 102.6
R99 VAPWR.n20 VAPWR.n19 102.6
R100 VAPWR.n131 VAPWR.n21 102.6
R101 VAPWR.n74 VAPWR.n43 102.6
R102 VAPWR.n102 VAPWR.n43 102.6
R103 VAPWR.n102 VAPWR.n39 102.6
R104 VAPWR.n108 VAPWR.n39 102.6
R105 VAPWR.n108 VAPWR.n31 102.6
R106 VAPWR.n121 VAPWR.n31 102.6
R107 VAPWR.n121 VAPWR.n27 102.6
R108 VAPWR.n128 VAPWR.n27 102.6
R109 VAPWR.n128 VAPWR.n26 102.6
R110 VAPWR.n143 VAPWR.n26 102.6
R111 VAPWR.n50 VAPWR.n49 102.6
R112 VAPWR.n64 VAPWR.n50 102.6
R113 VAPWR.n54 VAPWR.n53 102.6
R114 VAPWR.n67 VAPWR.n55 102.6
R115 VAPWR.n59 VAPWR.n58 102.6
R116 VAPWR.n63 VAPWR.n60 102.6
R117 VAPWR.n99 VAPWR.n45 102.6
R118 VAPWR.n99 VAPWR.n38 102.6
R119 VAPWR.n111 VAPWR.n38 102.6
R120 VAPWR.n111 VAPWR.n34 102.6
R121 VAPWR.n118 VAPWR.n34 102.6
R122 VAPWR.n119 VAPWR.n118 102.6
R123 VAPWR.n119 VAPWR.n3 102.6
R124 VAPWR.n4 VAPWR.n3 102.6
R125 VAPWR.n5 VAPWR.n4 102.6
R126 VAPWR.n141 VAPWR.n5 102.6
R127 VAPWR.n71 VAPWR.n70 72.4195
R128 VAPWR.n71 VAPWR.n65 72.4195
R129 VAPWR.n71 VAPWR.n66 72.4195
R130 VAPWR.n71 VAPWR.n68 72.4195
R131 VAPWR.n71 VAPWR.n69 72.4195
R132 VAPWR.n72 VAPWR.n71 72.4195
R133 VAPWR.n140 VAPWR.n132 72.4195
R134 VAPWR.n140 VAPWR.n133 72.4195
R135 VAPWR.n140 VAPWR.n135 72.4195
R136 VAPWR.n140 VAPWR.n136 72.4195
R137 VAPWR.n140 VAPWR.n138 72.4195
R138 VAPWR.n140 VAPWR.n139 72.4195
R139 VAPWR.n71 VAPWR.n44 55.073
R140 VAPWR.n142 VAPWR.n140 55.073
R141 VAPWR.n100 VAPWR.n44 49.5657
R142 VAPWR.n101 VAPWR.n100 49.5657
R143 VAPWR.n110 VAPWR.n109 49.5657
R144 VAPWR.n109 VAPWR.n32 49.5657
R145 VAPWR.n120 VAPWR.n32 49.5657
R146 VAPWR.n120 VAPWR.n33 49.5657
R147 VAPWR.n130 VAPWR.n129 49.5657
R148 VAPWR.n142 VAPWR.n130 49.5657
R149 VAPWR.n139 VAPWR.n11 40.1639
R150 VAPWR.n138 VAPWR.n14 40.1639
R151 VAPWR.n136 VAPWR.n16 40.1639
R152 VAPWR.n135 VAPWR.n19 40.1639
R153 VAPWR.n133 VAPWR.n21 40.1639
R154 VAPWR.n132 VAPWR.n24 40.1639
R155 VAPWR.n70 VAPWR.n48 40.1639
R156 VAPWR.n65 VAPWR.n64 40.1639
R157 VAPWR.n66 VAPWR.n54 40.1639
R158 VAPWR.n68 VAPWR.n67 40.1639
R159 VAPWR.n69 VAPWR.n59 40.1639
R160 VAPWR.n72 VAPWR.n63 40.1639
R161 VAPWR.n70 VAPWR.n49 40.1639
R162 VAPWR.n65 VAPWR.n53 40.1639
R163 VAPWR.n66 VAPWR.n55 40.1639
R164 VAPWR.n68 VAPWR.n58 40.1639
R165 VAPWR.n69 VAPWR.n60 40.1639
R166 VAPWR.n73 VAPWR.n72 40.1639
R167 VAPWR.n132 VAPWR.n131 40.1639
R168 VAPWR.n133 VAPWR.n20 40.1639
R169 VAPWR.n135 VAPWR.n134 40.1639
R170 VAPWR.n136 VAPWR.n15 40.1639
R171 VAPWR.n138 VAPWR.n137 40.1639
R172 VAPWR.n139 VAPWR.n10 40.1639
R173 VAPWR.n110 VAPWR.t0 38.5512
R174 VAPWR.n33 VAPWR.t2 38.5512
R175 VAPWR.n94 VAPWR.n46 25.2805
R176 VAPWR.n163 VAPWR.n6 25.2805
R177 VAPWR.n76 VAPWR.n75 25.2805
R178 VAPWR.n145 VAPWR.n144 25.2805
R179 VAPWR.n98 VAPWR.n46 11.5205
R180 VAPWR.n98 VAPWR.n37 11.5205
R181 VAPWR.n112 VAPWR.n37 11.5205
R182 VAPWR.n112 VAPWR.n35 11.5205
R183 VAPWR.n117 VAPWR.n35 11.5205
R184 VAPWR.n117 VAPWR.n2 11.5205
R185 VAPWR.n169 VAPWR.n2 11.5205
R186 VAPWR.n169 VAPWR.n168 11.5205
R187 VAPWR.n168 VAPWR.n167 11.5205
R188 VAPWR.n167 VAPWR.n6 11.5205
R189 VAPWR.n94 VAPWR.n93 11.5205
R190 VAPWR.n93 VAPWR.n92 11.5205
R191 VAPWR.n92 VAPWR.n51 11.5205
R192 VAPWR.n88 VAPWR.n51 11.5205
R193 VAPWR.n88 VAPWR.n87 11.5205
R194 VAPWR.n87 VAPWR.n86 11.5205
R195 VAPWR.n86 VAPWR.n56 11.5205
R196 VAPWR.n82 VAPWR.n56 11.5205
R197 VAPWR.n82 VAPWR.n81 11.5205
R198 VAPWR.n81 VAPWR.n80 11.5205
R199 VAPWR.n80 VAPWR.n61 11.5205
R200 VAPWR.n76 VAPWR.n61 11.5205
R201 VAPWR.n75 VAPWR.n42 11.5205
R202 VAPWR.n103 VAPWR.n42 11.5205
R203 VAPWR.n103 VAPWR.n40 11.5205
R204 VAPWR.n107 VAPWR.n40 11.5205
R205 VAPWR.n107 VAPWR.n30 11.5205
R206 VAPWR.n122 VAPWR.n30 11.5205
R207 VAPWR.n122 VAPWR.n28 11.5205
R208 VAPWR.n127 VAPWR.n28 11.5205
R209 VAPWR.n127 VAPWR.n25 11.5205
R210 VAPWR.n144 VAPWR.n25 11.5205
R211 VAPWR.n163 VAPWR.n162 11.5205
R212 VAPWR.n162 VAPWR.n161 11.5205
R213 VAPWR.n161 VAPWR.n12 11.5205
R214 VAPWR.n157 VAPWR.n12 11.5205
R215 VAPWR.n157 VAPWR.n156 11.5205
R216 VAPWR.n156 VAPWR.n155 11.5205
R217 VAPWR.n155 VAPWR.n17 11.5205
R218 VAPWR.n151 VAPWR.n17 11.5205
R219 VAPWR.n151 VAPWR.n150 11.5205
R220 VAPWR.n150 VAPWR.n149 11.5205
R221 VAPWR.n149 VAPWR.n22 11.5205
R222 VAPWR.n145 VAPWR.n22 11.5205
R223 VAPWR.n101 VAPWR.t0 11.015
R224 VAPWR.n129 VAPWR.t2 11.015
R225 VAPWR.n146 VAPWR.n145 9.3005
R226 VAPWR.n147 VAPWR.n22 9.3005
R227 VAPWR.n149 VAPWR.n148 9.3005
R228 VAPWR.n150 VAPWR.n18 9.3005
R229 VAPWR.n152 VAPWR.n151 9.3005
R230 VAPWR.n153 VAPWR.n17 9.3005
R231 VAPWR.n155 VAPWR.n154 9.3005
R232 VAPWR.n156 VAPWR.n13 9.3005
R233 VAPWR.n158 VAPWR.n157 9.3005
R234 VAPWR.n159 VAPWR.n12 9.3005
R235 VAPWR.n161 VAPWR.n160 9.3005
R236 VAPWR.n162 VAPWR.n8 9.3005
R237 VAPWR.n164 VAPWR.n163 9.3005
R238 VAPWR.n144 VAPWR.n23 9.3005
R239 VAPWR.n125 VAPWR.n25 9.3005
R240 VAPWR.n127 VAPWR.n126 9.3005
R241 VAPWR.n124 VAPWR.n28 9.3005
R242 VAPWR.n123 VAPWR.n122 9.3005
R243 VAPWR.n30 VAPWR.n29 9.3005
R244 VAPWR.n107 VAPWR.n106 9.3005
R245 VAPWR.n105 VAPWR.n40 9.3005
R246 VAPWR.n104 VAPWR.n103 9.3005
R247 VAPWR.n42 VAPWR.n41 9.3005
R248 VAPWR.n75 VAPWR.n62 9.3005
R249 VAPWR.n95 VAPWR.n94 9.3005
R250 VAPWR.n93 VAPWR.n47 9.3005
R251 VAPWR.n92 VAPWR.n91 9.3005
R252 VAPWR.n90 VAPWR.n51 9.3005
R253 VAPWR.n89 VAPWR.n88 9.3005
R254 VAPWR.n87 VAPWR.n52 9.3005
R255 VAPWR.n86 VAPWR.n85 9.3005
R256 VAPWR.n84 VAPWR.n56 9.3005
R257 VAPWR.n83 VAPWR.n82 9.3005
R258 VAPWR.n81 VAPWR.n57 9.3005
R259 VAPWR.n80 VAPWR.n79 9.3005
R260 VAPWR.n78 VAPWR.n61 9.3005
R261 VAPWR.n77 VAPWR.n76 9.3005
R262 VAPWR.n96 VAPWR.n46 9.3005
R263 VAPWR.n98 VAPWR.n97 9.3005
R264 VAPWR.n37 VAPWR.n36 9.3005
R265 VAPWR.n113 VAPWR.n112 9.3005
R266 VAPWR.n115 VAPWR.n35 9.3005
R267 VAPWR.n117 VAPWR.n116 9.3005
R268 VAPWR.n2 VAPWR.n0 9.3005
R269 VAPWR.n170 VAPWR.n169 9.3005
R270 VAPWR.n168 VAPWR.n1 9.3005
R271 VAPWR.n167 VAPWR.n166 9.3005
R272 VAPWR.n165 VAPWR.n6 9.3005
R273 VAPWR.n146 VAPWR.n23 0.247375
R274 VAPWR.n77 VAPWR.n62 0.247375
R275 VAPWR VAPWR.n171 0.159465
R276 VAPWR.n165 VAPWR.n164 0.147375
R277 VAPWR.n96 VAPWR.n95 0.147375
R278 VAPWR.n164 VAPWR.n8 0.113
R279 VAPWR.n160 VAPWR.n8 0.113
R280 VAPWR.n160 VAPWR.n159 0.113
R281 VAPWR.n159 VAPWR.n158 0.113
R282 VAPWR.n158 VAPWR.n13 0.113
R283 VAPWR.n154 VAPWR.n13 0.113
R284 VAPWR.n154 VAPWR.n153 0.113
R285 VAPWR.n153 VAPWR.n152 0.113
R286 VAPWR.n152 VAPWR.n18 0.113
R287 VAPWR.n148 VAPWR.n18 0.113
R288 VAPWR.n148 VAPWR.n147 0.113
R289 VAPWR.n147 VAPWR.n146 0.113
R290 VAPWR.n62 VAPWR.n41 0.113
R291 VAPWR.n104 VAPWR.n41 0.113
R292 VAPWR.n105 VAPWR.n104 0.113
R293 VAPWR.n106 VAPWR.n105 0.113
R294 VAPWR.n106 VAPWR.n29 0.113
R295 VAPWR.n123 VAPWR.n29 0.113
R296 VAPWR.n124 VAPWR.n123 0.113
R297 VAPWR.n126 VAPWR.n124 0.113
R298 VAPWR.n126 VAPWR.n125 0.113
R299 VAPWR.n125 VAPWR.n23 0.113
R300 VAPWR.n95 VAPWR.n47 0.113
R301 VAPWR.n91 VAPWR.n47 0.113
R302 VAPWR.n91 VAPWR.n90 0.113
R303 VAPWR.n90 VAPWR.n89 0.113
R304 VAPWR.n89 VAPWR.n52 0.113
R305 VAPWR.n85 VAPWR.n52 0.113
R306 VAPWR.n85 VAPWR.n84 0.113
R307 VAPWR.n84 VAPWR.n83 0.113
R308 VAPWR.n83 VAPWR.n57 0.113
R309 VAPWR.n79 VAPWR.n57 0.113
R310 VAPWR.n79 VAPWR.n78 0.113
R311 VAPWR.n78 VAPWR.n77 0.113
R312 VAPWR.n97 VAPWR.n96 0.023
R313 VAPWR.n97 VAPWR.n36 0.023
R314 VAPWR.n113 VAPWR.n36 0.023
R315 VAPWR.n116 VAPWR.n115 0.023
R316 VAPWR.n116 VAPWR.n0 0.023
R317 VAPWR.n170 VAPWR.n1 0.023
R318 VAPWR.n166 VAPWR.n165 0.023
R319 VAPWR.n7 VAPWR.n1 0.0205
R320 VAPWR.n171 VAPWR.n170 0.017375
R321 VAPWR.n115 VAPWR.n114 0.0155
R322 VAPWR.n114 VAPWR.n113 0.008
R323 VAPWR.n171 VAPWR.n0 0.006125
R324 VAPWR.n166 VAPWR.n7 0.003
R325 VDD.n20 VDD.n19 585
R326 VDD.n16 VDD.n15 585
R327 VDD.n21 VDD.n20 571.606
R328 VDD.n17 VDD.t1 397.385
R329 VDD.n0 VDD.t7 357.586
R330 VDD.n145 VDD.n25 267
R331 VDD.n147 VDD.n43 267
R332 VDD.n109 VDD.n58 267
R333 VDD.n78 VDD.n55 267
R334 VDD.n20 VDD.n15 236.4
R335 VDD.n71 VDD.n55 185
R336 VDD.n110 VDD.n55 185
R337 VDD.n112 VDD.n56 185
R338 VDD.n112 VDD.n111 185
R339 VDD.n113 VDD.n2 185
R340 VDD.n114 VDD.n113 185
R341 VDD.n183 VDD.n3 185
R342 VDD.n49 VDD.n3 185
R343 VDD.n182 VDD.n4 185
R344 VDD.n122 VDD.n4 185
R345 VDD.n181 VDD.n5 185
R346 VDD.n123 VDD.n5 185
R347 VDD.n125 VDD.n6 185
R348 VDD.n126 VDD.n125 185
R349 VDD.n176 VDD.n9 185
R350 VDD.n124 VDD.n9 185
R351 VDD.n175 VDD.n10 185
R352 VDD.n134 VDD.n10 185
R353 VDD.n174 VDD.n11 185
R354 VDD.n135 VDD.n11 185
R355 VDD.n145 VDD.n12 185
R356 VDD.n146 VDD.n145 185
R357 VDD.n78 VDD.n77 185
R358 VDD.n80 VDD.n70 185
R359 VDD.n81 VDD.n69 185
R360 VDD.n81 VDD.n57 185
R361 VDD.n84 VDD.n83 185
R362 VDD.n67 VDD.n66 185
R363 VDD.n89 VDD.n88 185
R364 VDD.n91 VDD.n65 185
R365 VDD.n94 VDD.n93 185
R366 VDD.n63 VDD.n62 185
R367 VDD.n99 VDD.n98 185
R368 VDD.n101 VDD.n61 185
R369 VDD.n104 VDD.n103 185
R370 VDD.n59 VDD.n58 185
R371 VDD.n148 VDD.n147 185
R372 VDD.n147 VDD.n146 185
R373 VDD.n42 VDD.n41 185
R374 VDD.n135 VDD.n42 185
R375 VDD.n133 VDD.n132 185
R376 VDD.n134 VDD.n133 185
R377 VDD.n45 VDD.n44 185
R378 VDD.n124 VDD.n44 185
R379 VDD.n128 VDD.n127 185
R380 VDD.n127 VDD.n126 185
R381 VDD.n48 VDD.n47 185
R382 VDD.n123 VDD.n48 185
R383 VDD.n121 VDD.n120 185
R384 VDD.n122 VDD.n121 185
R385 VDD.n51 VDD.n50 185
R386 VDD.n50 VDD.n49 185
R387 VDD.n116 VDD.n115 185
R388 VDD.n115 VDD.n114 185
R389 VDD.n54 VDD.n53 185
R390 VDD.n111 VDD.n54 185
R391 VDD.n109 VDD.n108 185
R392 VDD.n110 VDD.n109 185
R393 VDD.n43 VDD.n39 185
R394 VDD.n153 VDD.n38 185
R395 VDD.n154 VDD.n37 185
R396 VDD.n155 VDD.n36 185
R397 VDD.n138 VDD.n34 185
R398 VDD.n159 VDD.n33 185
R399 VDD.n160 VDD.n32 185
R400 VDD.n161 VDD.n31 185
R401 VDD.n162 VDD.n30 185
R402 VDD.n141 VDD.n28 185
R403 VDD.n166 VDD.n27 185
R404 VDD.n167 VDD.n26 185
R405 VDD.n168 VDD.n25 185
R406 VDD.n144 VDD.n25 185
R407 VDD.t1 VDD.n15 118.201
R408 VDD.n26 VDD.n25 108.001
R409 VDD.n141 VDD.n27 108.001
R410 VDD.n31 VDD.n30 108.001
R411 VDD.n33 VDD.n32 108.001
R412 VDD.n138 VDD.n36 108.001
R413 VDD.n38 VDD.n37 108.001
R414 VDD.n109 VDD.n54 108.001
R415 VDD.n115 VDD.n54 108.001
R416 VDD.n115 VDD.n50 108.001
R417 VDD.n121 VDD.n50 108.001
R418 VDD.n121 VDD.n48 108.001
R419 VDD.n127 VDD.n48 108.001
R420 VDD.n127 VDD.n44 108.001
R421 VDD.n133 VDD.n44 108.001
R422 VDD.n133 VDD.n42 108.001
R423 VDD.n147 VDD.n42 108.001
R424 VDD.n81 VDD.n80 108.001
R425 VDD.n83 VDD.n81 108.001
R426 VDD.n89 VDD.n66 108.001
R427 VDD.n93 VDD.n91 108.001
R428 VDD.n99 VDD.n62 108.001
R429 VDD.n103 VDD.n101 108.001
R430 VDD.n112 VDD.n55 108.001
R431 VDD.n113 VDD.n112 108.001
R432 VDD.n113 VDD.n3 108.001
R433 VDD.n4 VDD.n3 108.001
R434 VDD.n5 VDD.n4 108.001
R435 VDD.n125 VDD.n5 108.001
R436 VDD.n125 VDD.n9 108.001
R437 VDD.n10 VDD.n9 108.001
R438 VDD.n11 VDD.n10 108.001
R439 VDD.n145 VDD.n11 108.001
R440 VDD.n178 VDD.n7 74.9836
R441 VDD.n79 VDD.n57 71.6014
R442 VDD.n82 VDD.n57 71.6014
R443 VDD.n90 VDD.n57 71.6014
R444 VDD.n92 VDD.n57 71.6014
R445 VDD.n100 VDD.n57 71.6014
R446 VDD.n102 VDD.n57 71.6014
R447 VDD.n144 VDD.n136 71.6014
R448 VDD.n144 VDD.n137 71.6014
R449 VDD.n144 VDD.n139 71.6014
R450 VDD.n144 VDD.n140 71.6014
R451 VDD.n144 VDD.n142 71.6014
R452 VDD.n144 VDD.n143 71.6014
R453 VDD.n110 VDD.n57 68.8411
R454 VDD.n146 VDD.n144 68.8411
R455 VDD.n111 VDD.n110 49.5657
R456 VDD.n114 VDD.n49 49.5657
R457 VDD.n122 VDD.n49 49.5657
R458 VDD.n123 VDD.n122 49.5657
R459 VDD.n126 VDD.n123 49.5657
R460 VDD.n146 VDD.n135 49.5657
R461 VDD.t4 VDD.n124 47.5005
R462 VDD.n143 VDD.n27 41.8002
R463 VDD.n142 VDD.n30 41.8002
R464 VDD.n140 VDD.n32 41.8002
R465 VDD.n139 VDD.n138 41.8002
R466 VDD.n137 VDD.n37 41.8002
R467 VDD.n136 VDD.n43 41.8002
R468 VDD.n79 VDD.n78 41.8002
R469 VDD.n83 VDD.n82 41.8002
R470 VDD.n90 VDD.n89 41.8002
R471 VDD.n93 VDD.n92 41.8002
R472 VDD.n100 VDD.n99 41.8002
R473 VDD.n103 VDD.n102 41.8002
R474 VDD.n80 VDD.n79 41.8002
R475 VDD.n82 VDD.n66 41.8002
R476 VDD.n91 VDD.n90 41.8002
R477 VDD.n92 VDD.n62 41.8002
R478 VDD.n101 VDD.n100 41.8002
R479 VDD.n102 VDD.n58 41.8002
R480 VDD.n136 VDD.n38 41.8002
R481 VDD.n137 VDD.n36 41.8002
R482 VDD.n139 VDD.n33 41.8002
R483 VDD.n140 VDD.n31 41.8002
R484 VDD.n142 VDD.n141 41.8002
R485 VDD.n143 VDD.n26 41.8002
R486 VDD.n134 VDD.t2 35.1092
R487 VDD.n77 VDD.n71 28.4805
R488 VDD.n168 VDD.n12 28.4805
R489 VDD.n108 VDD.n59 28.4805
R490 VDD.n148 VDD.n39 28.4805
R491 VDD.n19 VDD.n14 27.1064
R492 VDD.n19 VDD.n16 27.1064
R493 VDD.n114 VDD.t6 26.8483
R494 VDD.t0 VDD.n134 26.8483
R495 VDD.n22 VDD.n21 24.8327
R496 VDD.n111 VDD.t6 22.7179
R497 VDD.n135 VDD.t0 22.7179
R498 VDD.n124 VDD.t2 14.457
R499 VDD.n71 VDD.n56 11.5205
R500 VDD.n56 VDD.n2 11.5205
R501 VDD.n183 VDD.n2 11.5205
R502 VDD.n183 VDD.n182 11.5205
R503 VDD.n182 VDD.n181 11.5205
R504 VDD.n181 VDD.n6 11.5205
R505 VDD.n176 VDD.n6 11.5205
R506 VDD.n176 VDD.n175 11.5205
R507 VDD.n175 VDD.n174 11.5205
R508 VDD.n174 VDD.n12 11.5205
R509 VDD.n77 VDD.n70 11.5205
R510 VDD.n70 VDD.n69 11.5205
R511 VDD.n84 VDD.n69 11.5205
R512 VDD.n84 VDD.n67 11.5205
R513 VDD.n88 VDD.n67 11.5205
R514 VDD.n88 VDD.n65 11.5205
R515 VDD.n94 VDD.n65 11.5205
R516 VDD.n94 VDD.n63 11.5205
R517 VDD.n98 VDD.n63 11.5205
R518 VDD.n98 VDD.n61 11.5205
R519 VDD.n104 VDD.n61 11.5205
R520 VDD.n104 VDD.n59 11.5205
R521 VDD.n108 VDD.n53 11.5205
R522 VDD.n116 VDD.n53 11.5205
R523 VDD.n116 VDD.n51 11.5205
R524 VDD.n120 VDD.n51 11.5205
R525 VDD.n120 VDD.n47 11.5205
R526 VDD.n128 VDD.n47 11.5205
R527 VDD.n128 VDD.n45 11.5205
R528 VDD.n132 VDD.n45 11.5205
R529 VDD.n132 VDD.n41 11.5205
R530 VDD.n148 VDD.n41 11.5205
R531 VDD.n168 VDD.n167 11.5205
R532 VDD.n167 VDD.n166 11.5205
R533 VDD.n166 VDD.n28 11.5205
R534 VDD.n162 VDD.n28 11.5205
R535 VDD.n162 VDD.n161 11.5205
R536 VDD.n161 VDD.n160 11.5205
R537 VDD.n160 VDD.n159 11.5205
R538 VDD.n159 VDD.n34 11.5205
R539 VDD.n155 VDD.n34 11.5205
R540 VDD.n155 VDD.n154 11.5205
R541 VDD.n154 VDD.n153 11.5205
R542 VDD.n153 VDD.n39 11.5205
R543 VDD.n21 VDD.n14 11.0627
R544 VDD.n7 VDD.t5 9.8505
R545 VDD.n7 VDD.t3 9.8505
R546 VDD.n14 VDD.n13 9.3005
R547 VDD.n19 VDD.n18 9.3005
R548 VDD.n151 VDD.n39 9.3005
R549 VDD.n153 VDD.n152 9.3005
R550 VDD.n154 VDD.n35 9.3005
R551 VDD.n156 VDD.n155 9.3005
R552 VDD.n157 VDD.n34 9.3005
R553 VDD.n159 VDD.n158 9.3005
R554 VDD.n160 VDD.n23 9.3005
R555 VDD.n161 VDD.n29 9.3005
R556 VDD.n163 VDD.n162 9.3005
R557 VDD.n164 VDD.n28 9.3005
R558 VDD.n166 VDD.n165 9.3005
R559 VDD.n167 VDD.n24 9.3005
R560 VDD.n169 VDD.n168 9.3005
R561 VDD.n149 VDD.n148 9.3005
R562 VDD.n41 VDD.n40 9.3005
R563 VDD.n132 VDD.n131 9.3005
R564 VDD.n130 VDD.n45 9.3005
R565 VDD.n129 VDD.n128 9.3005
R566 VDD.n47 VDD.n46 9.3005
R567 VDD.n120 VDD.n119 9.3005
R568 VDD.n118 VDD.n51 9.3005
R569 VDD.n117 VDD.n116 9.3005
R570 VDD.n53 VDD.n52 9.3005
R571 VDD.n108 VDD.n107 9.3005
R572 VDD.n77 VDD.n76 9.3005
R573 VDD.n75 VDD.n70 9.3005
R574 VDD.n69 VDD.n68 9.3005
R575 VDD.n85 VDD.n84 9.3005
R576 VDD.n86 VDD.n67 9.3005
R577 VDD.n88 VDD.n87 9.3005
R578 VDD.n65 VDD.n64 9.3005
R579 VDD.n95 VDD.n94 9.3005
R580 VDD.n96 VDD.n63 9.3005
R581 VDD.n98 VDD.n97 9.3005
R582 VDD.n61 VDD.n60 9.3005
R583 VDD.n105 VDD.n104 9.3005
R584 VDD.n106 VDD.n59 9.3005
R585 VDD.n74 VDD.n71 9.3005
R586 VDD.n73 VDD.n56 9.3005
R587 VDD.n72 VDD.n2 9.3005
R588 VDD.n184 VDD.n183 9.3005
R589 VDD.n182 VDD.n1 9.3005
R590 VDD.n181 VDD.n180 9.3005
R591 VDD.n179 VDD.n6 9.3005
R592 VDD.n177 VDD.n176 9.3005
R593 VDD.n175 VDD.n8 9.3005
R594 VDD.n174 VDD.n173 9.3005
R595 VDD.n171 VDD.n12 9.3005
R596 VDD.n17 VDD.n16 6.45639
R597 VDD.n170 VDD.n23 2.1255
R598 VDD.n150 VDD.n23 2.1255
R599 VDD.n126 VDD.t4 2.06572
R600 VDD.n18 VDD.n17 1.04058
R601 VDD.n172 VDD.n22 0.329204
R602 VDD.n151 VDD.n150 0.318937
R603 VDD.n170 VDD.n169 0.300188
R604 VDD.n107 VDD.n106 0.278625
R605 VDD.n169 VDD.n24 0.1805
R606 VDD.n165 VDD.n24 0.1805
R607 VDD.n165 VDD.n164 0.1805
R608 VDD.n164 VDD.n163 0.1805
R609 VDD.n163 VDD.n29 0.1805
R610 VDD.n29 VDD.n23 0.1805
R611 VDD.n158 VDD.n23 0.1805
R612 VDD.n158 VDD.n157 0.1805
R613 VDD.n157 VDD.n156 0.1805
R614 VDD.n156 VDD.n35 0.1805
R615 VDD.n152 VDD.n35 0.1805
R616 VDD.n152 VDD.n151 0.1805
R617 VDD.n22 VDD.n13 0.167167
R618 VDD.n18 VDD.n13 0.167167
R619 VDD VDD.n185 0.160793
R620 VDD.n76 VDD.n74 0.153625
R621 VDD.n150 VDD.n149 0.117688
R622 VDD.n107 VDD.n52 0.113
R623 VDD.n117 VDD.n52 0.113
R624 VDD.n118 VDD.n117 0.113
R625 VDD.n119 VDD.n118 0.113
R626 VDD.n119 VDD.n46 0.113
R627 VDD.n129 VDD.n46 0.113
R628 VDD.n130 VDD.n129 0.113
R629 VDD.n131 VDD.n130 0.113
R630 VDD.n131 VDD.n40 0.113
R631 VDD.n149 VDD.n40 0.113
R632 VDD.n76 VDD.n75 0.113
R633 VDD.n75 VDD.n68 0.113
R634 VDD.n85 VDD.n68 0.113
R635 VDD.n86 VDD.n85 0.113
R636 VDD.n87 VDD.n86 0.113
R637 VDD.n87 VDD.n64 0.113
R638 VDD.n95 VDD.n64 0.113
R639 VDD.n96 VDD.n95 0.113
R640 VDD.n97 VDD.n96 0.113
R641 VDD.n97 VDD.n60 0.113
R642 VDD.n105 VDD.n60 0.113
R643 VDD.n106 VDD.n105 0.113
R644 VDD.n171 VDD.n170 0.0239375
R645 VDD.n74 VDD.n73 0.023
R646 VDD.n73 VDD.n72 0.023
R647 VDD.n184 VDD.n1 0.023
R648 VDD.n180 VDD.n1 0.023
R649 VDD.n180 VDD.n179 0.023
R650 VDD.n177 VDD.n8 0.023
R651 VDD.n173 VDD.n8 0.023
R652 VDD.n185 VDD.n0 0.0208125
R653 VDD.n172 VDD.n171 0.01925
R654 VDD.n179 VDD.n178 0.0155
R655 VDD.n178 VDD.n177 0.008
R656 VDD.n173 VDD.n172 0.00425
R657 VDD.n72 VDD.n0 0.002375
R658 VDD.n185 VDD.n184 0.0008125
R659 VSS.n292 VSS.n245 1360
R660 VSS.n230 VSS.n229 585
R661 VSS.n229 VSS.n68 585
R662 VSS.n231 VSS.n86 585
R663 VSS.n86 VSS.n84 585
R664 VSS.n233 VSS.n232 585
R665 VSS.n234 VSS.n233 585
R666 VSS.n87 VSS.n85 585
R667 VSS.n183 VSS.n85 585
R668 VSS.n186 VSS.n185 585
R669 VSS.n185 VSS.n184 585
R670 VSS.n90 VSS.n89 585
R671 VSS.n91 VSS.n90 585
R672 VSS.n174 VSS.n173 585
R673 VSS.n175 VSS.n174 585
R674 VSS.n99 VSS.n98 585
R675 VSS.n98 VSS.n97 585
R676 VSS.n169 VSS.n168 585
R677 VSS.n168 VSS.n167 585
R678 VSS.n102 VSS.n101 585
R679 VSS.n103 VSS.n102 585
R680 VSS.n157 VSS.n156 585
R681 VSS.n158 VSS.n157 585
R682 VSS.n111 VSS.n110 585
R683 VSS.n152 VSS.n151 585
R684 VSS.n149 VSS.n113 585
R685 VSS.n149 VSS.n109 585
R686 VSS.n148 VSS.n147 585
R687 VSS.n146 VSS.n145 585
R688 VSS.n144 VSS.n117 585
R689 VSS.n142 VSS.n141 585
R690 VSS.n140 VSS.n118 585
R691 VSS.n139 VSS.n138 585
R692 VSS.n136 VSS.n123 585
R693 VSS.n134 VSS.n133 585
R694 VSS.n132 VSS.n124 585
R695 VSS.n131 VSS.n130 585
R696 VSS.n108 VSS.n107 585
R697 VSS.n109 VSS.n108 585
R698 VSS.n243 VSS.n242 585
R699 VSS.n77 VSS.n75 585
R700 VSS.n206 VSS.n205 585
R701 VSS.n208 VSS.n207 585
R702 VSS.n210 VSS.n209 585
R703 VSS.n212 VSS.n211 585
R704 VSS.n214 VSS.n213 585
R705 VSS.n216 VSS.n215 585
R706 VSS.n218 VSS.n217 585
R707 VSS.n220 VSS.n219 585
R708 VSS.n222 VSS.n221 585
R709 VSS.n224 VSS.n223 585
R710 VSS.n226 VSS.n225 585
R711 VSS.n228 VSS.n227 585
R712 VSS.n241 VSS.n76 585
R713 VSS.n76 VSS.n68 585
R714 VSS.n83 VSS.n79 585
R715 VSS.n84 VSS.n83 585
R716 VSS.n236 VSS.n235 585
R717 VSS.n235 VSS.n234 585
R718 VSS.n82 VSS.n81 585
R719 VSS.n183 VSS.n82 585
R720 VSS.n182 VSS.n181 585
R721 VSS.n184 VSS.n182 585
R722 VSS.n93 VSS.n92 585
R723 VSS.n92 VSS.n91 585
R724 VSS.n177 VSS.n176 585
R725 VSS.n176 VSS.n175 585
R726 VSS.n96 VSS.n95 585
R727 VSS.n97 VSS.n96 585
R728 VSS.n166 VSS.n165 585
R729 VSS.n167 VSS.n166 585
R730 VSS.n105 VSS.n104 585
R731 VSS.n104 VSS.n103 585
R732 VSS.n160 VSS.n159 585
R733 VSS.n159 VSS.n158 585
R734 VSS.n67 VSS.n66 585
R735 VSS.n293 VSS.n67 585
R736 VSS.n296 VSS.n295 585
R737 VSS.n295 VSS.n294 585
R738 VSS.n64 VSS.n63 585
R739 VSS.n63 VSS.n61 585
R740 VSS.n301 VSS.n300 585
R741 VSS.n302 VSS.n301 585
R742 VSS.n60 VSS.n59 585
R743 VSS.n303 VSS.n60 585
R744 VSS.n306 VSS.n305 585
R745 VSS.n305 VSS.n304 585
R746 VSS.n56 VSS.n55 585
R747 VSS.n55 VSS.n53 585
R748 VSS.n314 VSS.n313 585
R749 VSS.n315 VSS.n314 585
R750 VSS.n57 VSS.n51 585
R751 VSS.n316 VSS.n51 585
R752 VSS.n318 VSS.n52 585
R753 VSS.n318 VSS.n317 585
R754 VSS.n319 VSS.n50 585
R755 VSS.n319 VSS.n33 585
R756 VSS.n345 VSS.n17 585
R757 VSS.n348 VSS.n347 585
R758 VSS.n32 VSS.n31 585
R759 VSS.n342 VSS.n341 585
R760 VSS.n40 VSS.n39 585
R761 VSS.n337 VSS.n336 585
R762 VSS.n335 VSS.n334 585
R763 VSS.n333 VSS.n44 585
R764 VSS.n43 VSS.n42 585
R765 VSS.n329 VSS.n328 585
R766 VSS.n327 VSS.n326 585
R767 VSS.n325 VSS.n48 585
R768 VSS.n47 VSS.n46 585
R769 VSS.n321 VSS.n320 585
R770 VSS.n353 VSS.n16 585
R771 VSS.n33 VSS.n16 585
R772 VSS.n354 VSS.n15 585
R773 VSS.n317 VSS.n15 585
R774 VSS.n355 VSS.n14 585
R775 VSS.n316 VSS.n14 585
R776 VSS.n54 VSS.n12 585
R777 VSS.n315 VSS.n54 585
R778 VSS.n359 VSS.n11 585
R779 VSS.n53 VSS.n11 585
R780 VSS.n360 VSS.n10 585
R781 VSS.n304 VSS.n10 585
R782 VSS.n361 VSS.n9 585
R783 VSS.n303 VSS.n9 585
R784 VSS.n62 VSS.n7 585
R785 VSS.n302 VSS.n62 585
R786 VSS.n366 VSS.n6 585
R787 VSS.n61 VSS.n6 585
R788 VSS.n367 VSS.n5 585
R789 VSS.n294 VSS.n5 585
R790 VSS.n368 VSS.n4 585
R791 VSS.n293 VSS.n4 585
R792 VSS.n290 VSS.n289 585
R793 VSS.n254 VSS.n253 585
R794 VSS.n285 VSS.n252 585
R795 VSS.n292 VSS.n252 585
R796 VSS.n284 VSS.n256 585
R797 VSS.n283 VSS.n257 585
R798 VSS.n259 VSS.n258 585
R799 VSS.n279 VSS.n261 585
R800 VSS.n278 VSS.n262 585
R801 VSS.n277 VSS.n263 585
R802 VSS.n265 VSS.n264 585
R803 VSS.n273 VSS.n267 585
R804 VSS.n272 VSS.n268 585
R805 VSS.n271 VSS.n269 585
R806 VSS.n251 VSS.n3 585
R807 VSS.n292 VSS.n251 585
R808 VSS.n320 VSS.n319 472.8
R809 VSS.n345 VSS.n16 472.8
R810 VSS.n251 VSS.n4 472.8
R811 VSS.n290 VSS.n67 472.8
R812 VSS.n229 VSS.n228 410.651
R813 VSS.n243 VSS.n76 410.651
R814 VSS.n159 VSS.n108 410.651
R815 VSS.n157 VSS.n110 410.651
R816 VSS.n26 VSS.n25 256.483
R817 VSS.n150 VSS.n109 255.031
R818 VSS.n114 VSS.n109 255.031
R819 VSS.n143 VSS.n109 255.031
R820 VSS.n137 VSS.n109 255.031
R821 VSS.n135 VSS.n109 255.031
R822 VSS.n129 VSS.n109 255.031
R823 VSS.n245 VSS.n244 255.031
R824 VSS.n245 VSS.n74 255.031
R825 VSS.n245 VSS.n73 255.031
R826 VSS.n245 VSS.n72 255.031
R827 VSS.n245 VSS.n71 255.031
R828 VSS.n245 VSS.n70 255.031
R829 VSS.n245 VSS.n69 255.031
R830 VSS.n346 VSS.n344 254.01
R831 VSS.n344 VSS.n343 254.01
R832 VSS.n344 VSS.n38 254.01
R833 VSS.n344 VSS.n37 254.01
R834 VSS.n344 VSS.n36 254.01
R835 VSS.n344 VSS.n35 254.01
R836 VSS.n344 VSS.n34 254.01
R837 VSS.n292 VSS.n291 254.01
R838 VSS.n292 VSS.n246 254.01
R839 VSS.n292 VSS.n247 254.01
R840 VSS.n292 VSS.n248 254.01
R841 VSS.n292 VSS.n249 254.01
R842 VSS.n292 VSS.n250 254.01
R843 VSS.n364 VSS.t7 239.218
R844 VSS.n293 VSS.n292 200
R845 VSS.n344 VSS.n33 200
R846 VSS.n21 VSS.n20 185
R847 VSS.n25 VSS.n24 185
R848 VSS.n22 VSS.t1 180.947
R849 VSS.n48 VSS.n47 177.3
R850 VSS.n328 VSS.n327 177.3
R851 VSS.n44 VSS.n43 177.3
R852 VSS.n336 VSS.n335 177.3
R853 VSS.n342 VSS.n39 177.3
R854 VSS.n347 VSS.n32 177.3
R855 VSS.n5 VSS.n4 177.3
R856 VSS.n6 VSS.n5 177.3
R857 VSS.n62 VSS.n6 177.3
R858 VSS.n62 VSS.n9 177.3
R859 VSS.n10 VSS.n9 177.3
R860 VSS.n11 VSS.n10 177.3
R861 VSS.n54 VSS.n11 177.3
R862 VSS.n54 VSS.n14 177.3
R863 VSS.n15 VSS.n14 177.3
R864 VSS.n16 VSS.n15 177.3
R865 VSS.n253 VSS.n252 177.3
R866 VSS.n256 VSS.n252 177.3
R867 VSS.n258 VSS.n257 177.3
R868 VSS.n262 VSS.n261 177.3
R869 VSS.n264 VSS.n263 177.3
R870 VSS.n268 VSS.n267 177.3
R871 VSS.n269 VSS.n251 177.3
R872 VSS.n295 VSS.n67 177.3
R873 VSS.n295 VSS.n63 177.3
R874 VSS.n301 VSS.n63 177.3
R875 VSS.n301 VSS.n60 177.3
R876 VSS.n305 VSS.n60 177.3
R877 VSS.n305 VSS.n55 177.3
R878 VSS.n314 VSS.n55 177.3
R879 VSS.n314 VSS.n51 177.3
R880 VSS.n318 VSS.n51 177.3
R881 VSS.n319 VSS.n318 177.3
R882 VSS.n225 VSS.n224 171.9
R883 VSS.n221 VSS.n220 171.9
R884 VSS.n217 VSS.n216 171.9
R885 VSS.n213 VSS.n212 171.9
R886 VSS.n209 VSS.n208 171.9
R887 VSS.n205 VSS.n75 171.9
R888 VSS.n159 VSS.n104 171.9
R889 VSS.n166 VSS.n104 171.9
R890 VSS.n166 VSS.n96 171.9
R891 VSS.n176 VSS.n96 171.9
R892 VSS.n176 VSS.n92 171.9
R893 VSS.n182 VSS.n92 171.9
R894 VSS.n182 VSS.n82 171.9
R895 VSS.n235 VSS.n82 171.9
R896 VSS.n235 VSS.n83 171.9
R897 VSS.n83 VSS.n76 171.9
R898 VSS.n151 VSS.n149 171.9
R899 VSS.n149 VSS.n148 171.9
R900 VSS.n145 VSS.n144 171.9
R901 VSS.n142 VSS.n118 171.9
R902 VSS.n138 VSS.n136 171.9
R903 VSS.n134 VSS.n124 171.9
R904 VSS.n130 VSS.n108 171.9
R905 VSS.n157 VSS.n102 171.9
R906 VSS.n168 VSS.n102 171.9
R907 VSS.n168 VSS.n98 171.9
R908 VSS.n174 VSS.n98 171.9
R909 VSS.n174 VSS.n90 171.9
R910 VSS.n185 VSS.n90 171.9
R911 VSS.n185 VSS.n85 171.9
R912 VSS.n233 VSS.n85 171.9
R913 VSS.n233 VSS.n86 171.9
R914 VSS.n229 VSS.n86 171.9
R915 VSS.n158 VSS.n109 160
R916 VSS.n245 VSS.n68 160
R917 VSS.n25 VSS.n20 144
R918 VSS.n158 VSS.n103 144
R919 VSS.n167 VSS.n103 144
R920 VSS.n175 VSS.n97 144
R921 VSS.n175 VSS.n91 144
R922 VSS.n184 VSS.n91 144
R923 VSS.n184 VSS.n183 144
R924 VSS.n234 VSS.n84 144
R925 VSS.n84 VSS.n68 144
R926 VSS.n294 VSS.n293 144
R927 VSS.n302 VSS.n61 144
R928 VSS.n303 VSS.n302 144
R929 VSS.n304 VSS.n303 144
R930 VSS.n304 VSS.n53 144
R931 VSS.n315 VSS.n53 144
R932 VSS.n316 VSS.n315 144
R933 VSS.n317 VSS.n33 144
R934 VSS.t2 VSS.n97 112.001
R935 VSS.n183 VSS.t4 112.001
R936 VSS.t6 VSS.n61 78.0005
R937 VSS.t0 VSS.n316 78.0005
R938 VSS.n47 VSS.n34 76.985
R939 VSS.n327 VSS.n35 76.985
R940 VSS.n43 VSS.n36 76.985
R941 VSS.n335 VSS.n37 76.985
R942 VSS.n39 VSS.n38 76.985
R943 VSS.n343 VSS.n32 76.985
R944 VSS.n346 VSS.n345 76.985
R945 VSS.n291 VSS.n290 76.985
R946 VSS.n256 VSS.n246 76.985
R947 VSS.n258 VSS.n247 76.985
R948 VSS.n262 VSS.n248 76.985
R949 VSS.n264 VSS.n249 76.985
R950 VSS.n268 VSS.n250 76.985
R951 VSS.n347 VSS.n346 76.985
R952 VSS.n343 VSS.n342 76.985
R953 VSS.n336 VSS.n38 76.985
R954 VSS.n44 VSS.n37 76.985
R955 VSS.n328 VSS.n36 76.985
R956 VSS.n48 VSS.n35 76.985
R957 VSS.n320 VSS.n34 76.985
R958 VSS.n291 VSS.n253 76.985
R959 VSS.n257 VSS.n246 76.985
R960 VSS.n261 VSS.n247 76.985
R961 VSS.n263 VSS.n248 76.985
R962 VSS.n267 VSS.n249 76.985
R963 VSS.n269 VSS.n250 76.985
R964 VSS.n225 VSS.n69 74.9406
R965 VSS.n221 VSS.n70 74.9406
R966 VSS.n217 VSS.n71 74.9406
R967 VSS.n213 VSS.n72 74.9406
R968 VSS.n209 VSS.n73 74.9406
R969 VSS.n205 VSS.n74 74.9406
R970 VSS.n244 VSS.n243 74.9406
R971 VSS.n150 VSS.n110 74.9406
R972 VSS.n148 VSS.n114 74.9406
R973 VSS.n144 VSS.n143 74.9406
R974 VSS.n137 VSS.n118 74.9406
R975 VSS.n136 VSS.n135 74.9406
R976 VSS.n129 VSS.n124 74.9406
R977 VSS.n151 VSS.n150 74.9406
R978 VSS.n145 VSS.n114 74.9406
R979 VSS.n143 VSS.n142 74.9406
R980 VSS.n138 VSS.n137 74.9406
R981 VSS.n135 VSS.n134 74.9406
R982 VSS.n130 VSS.n129 74.9406
R983 VSS.n244 VSS.n75 74.9406
R984 VSS.n208 VSS.n74 74.9406
R985 VSS.n212 VSS.n73 74.9406
R986 VSS.n216 VSS.n72 74.9406
R987 VSS.n220 VSS.n71 74.9406
R988 VSS.n224 VSS.n70 74.9406
R989 VSS.n228 VSS.n69 74.9406
R990 VSS.t1 VSS.n20 72.0005
R991 VSS.n294 VSS.t6 66.0005
R992 VSS.n317 VSS.t0 66.0005
R993 VSS.n167 VSS.t2 32.0005
R994 VSS.n234 VSS.t4 32.0005
R995 VSS.n289 VSS.n66 30.7205
R996 VSS.n321 VSS.n50 30.7205
R997 VSS.n353 VSS.n17 30.7205
R998 VSS.n368 VSS.n3 30.7205
R999 VSS.n230 VSS.n227 27.5205
R1000 VSS.n242 VSS.n241 27.5205
R1001 VSS.n160 VSS.n107 27.5205
R1002 VSS.n156 VSS.n111 27.5205
R1003 VSS.n24 VSS.n21 27.1064
R1004 VSS.n24 VSS.n19 27.1064
R1005 VSS.n27 VSS.n26 25.7818
R1006 VSS.n94 VSS.t3 22.2713
R1007 VSS.n238 VSS.t5 22.2713
R1008 VSS.n227 VSS.n226 11.5205
R1009 VSS.n226 VSS.n223 11.5205
R1010 VSS.n223 VSS.n222 11.5205
R1011 VSS.n222 VSS.n219 11.5205
R1012 VSS.n219 VSS.n218 11.5205
R1013 VSS.n218 VSS.n215 11.5205
R1014 VSS.n215 VSS.n214 11.5205
R1015 VSS.n214 VSS.n211 11.5205
R1016 VSS.n211 VSS.n210 11.5205
R1017 VSS.n210 VSS.n207 11.5205
R1018 VSS.n207 VSS.n206 11.5205
R1019 VSS.n206 VSS.n77 11.5205
R1020 VSS.n242 VSS.n77 11.5205
R1021 VSS.n160 VSS.n105 11.5205
R1022 VSS.n165 VSS.n105 11.5205
R1023 VSS.n165 VSS.n95 11.5205
R1024 VSS.n177 VSS.n95 11.5205
R1025 VSS.n177 VSS.n93 11.5205
R1026 VSS.n181 VSS.n93 11.5205
R1027 VSS.n181 VSS.n81 11.5205
R1028 VSS.n236 VSS.n81 11.5205
R1029 VSS.n236 VSS.n79 11.5205
R1030 VSS.n241 VSS.n79 11.5205
R1031 VSS.n152 VSS.n111 11.5205
R1032 VSS.n152 VSS.n113 11.5205
R1033 VSS.n147 VSS.n113 11.5205
R1034 VSS.n147 VSS.n146 11.5205
R1035 VSS.n146 VSS.n117 11.5205
R1036 VSS.n141 VSS.n117 11.5205
R1037 VSS.n141 VSS.n140 11.5205
R1038 VSS.n140 VSS.n139 11.5205
R1039 VSS.n139 VSS.n123 11.5205
R1040 VSS.n133 VSS.n123 11.5205
R1041 VSS.n133 VSS.n132 11.5205
R1042 VSS.n132 VSS.n131 11.5205
R1043 VSS.n131 VSS.n107 11.5205
R1044 VSS.n156 VSS.n101 11.5205
R1045 VSS.n169 VSS.n101 11.5205
R1046 VSS.n169 VSS.n99 11.5205
R1047 VSS.n173 VSS.n99 11.5205
R1048 VSS.n173 VSS.n89 11.5205
R1049 VSS.n186 VSS.n89 11.5205
R1050 VSS.n186 VSS.n87 11.5205
R1051 VSS.n232 VSS.n87 11.5205
R1052 VSS.n232 VSS.n231 11.5205
R1053 VSS.n231 VSS.n230 11.5205
R1054 VSS.n296 VSS.n66 11.5205
R1055 VSS.n296 VSS.n64 11.5205
R1056 VSS.n300 VSS.n64 11.5205
R1057 VSS.n300 VSS.n59 11.5205
R1058 VSS.n306 VSS.n59 11.5205
R1059 VSS.n306 VSS.n56 11.5205
R1060 VSS.n313 VSS.n56 11.5205
R1061 VSS.n313 VSS.n57 11.5205
R1062 VSS.n57 VSS.n52 11.5205
R1063 VSS.n52 VSS.n50 11.5205
R1064 VSS.n321 VSS.n46 11.5205
R1065 VSS.n325 VSS.n46 11.5205
R1066 VSS.n326 VSS.n325 11.5205
R1067 VSS.n329 VSS.n326 11.5205
R1068 VSS.n329 VSS.n42 11.5205
R1069 VSS.n333 VSS.n42 11.5205
R1070 VSS.n334 VSS.n333 11.5205
R1071 VSS.n337 VSS.n334 11.5205
R1072 VSS.n337 VSS.n40 11.5205
R1073 VSS.n341 VSS.n40 11.5205
R1074 VSS.n341 VSS.n31 11.5205
R1075 VSS.n348 VSS.n31 11.5205
R1076 VSS.n348 VSS.n17 11.5205
R1077 VSS.n368 VSS.n367 11.5205
R1078 VSS.n367 VSS.n366 11.5205
R1079 VSS.n366 VSS.n7 11.5205
R1080 VSS.n361 VSS.n7 11.5205
R1081 VSS.n361 VSS.n360 11.5205
R1082 VSS.n360 VSS.n359 11.5205
R1083 VSS.n359 VSS.n12 11.5205
R1084 VSS.n355 VSS.n12 11.5205
R1085 VSS.n355 VSS.n354 11.5205
R1086 VSS.n354 VSS.n353 11.5205
R1087 VSS.n289 VSS.n254 11.5205
R1088 VSS.n285 VSS.n254 11.5205
R1089 VSS.n285 VSS.n284 11.5205
R1090 VSS.n284 VSS.n283 11.5205
R1091 VSS.n283 VSS.n259 11.5205
R1092 VSS.n279 VSS.n259 11.5205
R1093 VSS.n279 VSS.n278 11.5205
R1094 VSS.n278 VSS.n277 11.5205
R1095 VSS.n277 VSS.n265 11.5205
R1096 VSS.n273 VSS.n265 11.5205
R1097 VSS.n273 VSS.n272 11.5205
R1098 VSS.n272 VSS.n271 11.5205
R1099 VSS.n271 VSS.n3 11.5205
R1100 VSS.n24 VSS.n23 9.3005
R1101 VSS.n19 VSS.n18 9.3005
R1102 VSS.n242 VSS.n78 9.3005
R1103 VSS.n203 VSS.n77 9.3005
R1104 VSS.n206 VSS.n204 9.3005
R1105 VSS.n207 VSS.n202 9.3005
R1106 VSS.n210 VSS.n201 9.3005
R1107 VSS.n211 VSS.n200 9.3005
R1108 VSS.n214 VSS.n199 9.3005
R1109 VSS.n215 VSS.n198 9.3005
R1110 VSS.n218 VSS.n197 9.3005
R1111 VSS.n219 VSS.n196 9.3005
R1112 VSS.n222 VSS.n195 9.3005
R1113 VSS.n223 VSS.n194 9.3005
R1114 VSS.n226 VSS.n193 9.3005
R1115 VSS.n227 VSS.n192 9.3005
R1116 VSS.n154 VSS.n111 9.3005
R1117 VSS.n153 VSS.n152 9.3005
R1118 VSS.n113 VSS.n112 9.3005
R1119 VSS.n147 VSS.n115 9.3005
R1120 VSS.n146 VSS.n116 9.3005
R1121 VSS.n119 VSS.n117 9.3005
R1122 VSS.n141 VSS.n120 9.3005
R1123 VSS.n140 VSS.n121 9.3005
R1124 VSS.n139 VSS.n122 9.3005
R1125 VSS.n125 VSS.n123 9.3005
R1126 VSS.n133 VSS.n126 9.3005
R1127 VSS.n132 VSS.n127 9.3005
R1128 VSS.n131 VSS.n128 9.3005
R1129 VSS.n107 VSS.n106 9.3005
R1130 VSS.n156 VSS.n155 9.3005
R1131 VSS.n101 VSS.n100 9.3005
R1132 VSS.n170 VSS.n169 9.3005
R1133 VSS.n171 VSS.n99 9.3005
R1134 VSS.n173 VSS.n172 9.3005
R1135 VSS.n89 VSS.n88 9.3005
R1136 VSS.n187 VSS.n186 9.3005
R1137 VSS.n188 VSS.n87 9.3005
R1138 VSS.n232 VSS.n189 9.3005
R1139 VSS.n231 VSS.n190 9.3005
R1140 VSS.n230 VSS.n191 9.3005
R1141 VSS.n350 VSS.n17 9.3005
R1142 VSS.n349 VSS.n348 9.3005
R1143 VSS.n31 VSS.n30 9.3005
R1144 VSS.n341 VSS.n340 9.3005
R1145 VSS.n339 VSS.n40 9.3005
R1146 VSS.n338 VSS.n337 9.3005
R1147 VSS.n334 VSS.n41 9.3005
R1148 VSS.n333 VSS.n332 9.3005
R1149 VSS.n331 VSS.n42 9.3005
R1150 VSS.n330 VSS.n329 9.3005
R1151 VSS.n326 VSS.n45 9.3005
R1152 VSS.n325 VSS.n324 9.3005
R1153 VSS.n323 VSS.n46 9.3005
R1154 VSS.n322 VSS.n321 9.3005
R1155 VSS.n289 VSS.n288 9.3005
R1156 VSS.n287 VSS.n254 9.3005
R1157 VSS.n286 VSS.n285 9.3005
R1158 VSS.n284 VSS.n255 9.3005
R1159 VSS.n283 VSS.n282 9.3005
R1160 VSS.n281 VSS.n259 9.3005
R1161 VSS.n280 VSS.n279 9.3005
R1162 VSS.n278 VSS.n260 9.3005
R1163 VSS.n277 VSS.n276 9.3005
R1164 VSS.n275 VSS.n265 9.3005
R1165 VSS.n274 VSS.n273 9.3005
R1166 VSS.n272 VSS.n266 9.3005
R1167 VSS.n271 VSS.n270 9.3005
R1168 VSS.n3 VSS.n1 9.3005
R1169 VSS.n66 VSS.n65 9.3005
R1170 VSS.n297 VSS.n296 9.3005
R1171 VSS.n298 VSS.n64 9.3005
R1172 VSS.n300 VSS.n299 9.3005
R1173 VSS.n59 VSS.n58 9.3005
R1174 VSS.n307 VSS.n306 9.3005
R1175 VSS.n308 VSS.n56 9.3005
R1176 VSS.n313 VSS.n312 9.3005
R1177 VSS.n311 VSS.n57 9.3005
R1178 VSS.n310 VSS.n52 9.3005
R1179 VSS.n309 VSS.n50 9.3005
R1180 VSS.n162 VSS.n105 9.3005
R1181 VSS.n165 VSS.n164 9.3005
R1182 VSS.n163 VSS.n95 9.3005
R1183 VSS.n178 VSS.n177 9.3005
R1184 VSS.n179 VSS.n93 9.3005
R1185 VSS.n181 VSS.n180 9.3005
R1186 VSS.n81 VSS.n80 9.3005
R1187 VSS.n237 VSS.n236 9.3005
R1188 VSS.n239 VSS.n79 9.3005
R1189 VSS.n241 VSS.n240 9.3005
R1190 VSS.n161 VSS.n160 9.3005
R1191 VSS.n353 VSS.n352 9.3005
R1192 VSS.n354 VSS.n13 9.3005
R1193 VSS.n356 VSS.n355 9.3005
R1194 VSS.n357 VSS.n12 9.3005
R1195 VSS.n359 VSS.n358 9.3005
R1196 VSS.n360 VSS.n8 9.3005
R1197 VSS.n362 VSS.n361 9.3005
R1198 VSS.n363 VSS.n7 9.3005
R1199 VSS.n366 VSS.n365 9.3005
R1200 VSS.n367 VSS.n2 9.3005
R1201 VSS.n369 VSS.n368 9.3005
R1202 VSS.n26 VSS.n19 9.2683
R1203 VSS.n22 VSS.n21 6.30777
R1204 VSS.n49 VSS.n29 2.33383
R1205 VSS.n351 VSS.n29 2.33383
R1206 VSS.n23 VSS.n22 1.18676
R1207 VSS.n28 VSS.n27 0.884759
R1208 VSS.n322 VSS.n49 0.353938
R1209 VSS.n351 VSS.n350 0.335188
R1210 VSS.n288 VSS.n65 0.3005
R1211 VSS.n155 VSS.n154 0.26925
R1212 VSS.n192 VSS.n191 0.26925
R1213 VSS VSS.n371 0.19155
R1214 VSS.n323 VSS.n322 0.1805
R1215 VSS.n324 VSS.n323 0.1805
R1216 VSS.n324 VSS.n45 0.1805
R1217 VSS.n330 VSS.n45 0.1805
R1218 VSS.n331 VSS.n330 0.1805
R1219 VSS.n332 VSS.n331 0.1805
R1220 VSS.n338 VSS.n41 0.1805
R1221 VSS.n339 VSS.n338 0.1805
R1222 VSS.n340 VSS.n339 0.1805
R1223 VSS.n340 VSS.n30 0.1805
R1224 VSS.n349 VSS.n30 0.1805
R1225 VSS.n350 VSS.n349 0.1805
R1226 VSS.n161 VSS.n106 0.16925
R1227 VSS.n23 VSS.n18 0.167167
R1228 VSS.n27 VSS.n18 0.167167
R1229 VSS.n78 VSS.n0 0.14425
R1230 VSS.n370 VSS.n1 0.14425
R1231 VSS.n309 VSS.n49 0.117688
R1232 VSS.n371 VSS.n370 0.117688
R1233 VSS.n154 VSS.n153 0.113
R1234 VSS.n153 VSS.n112 0.113
R1235 VSS.n115 VSS.n112 0.113
R1236 VSS.n116 VSS.n115 0.113
R1237 VSS.n119 VSS.n116 0.113
R1238 VSS.n120 VSS.n119 0.113
R1239 VSS.n121 VSS.n120 0.113
R1240 VSS.n122 VSS.n121 0.113
R1241 VSS.n125 VSS.n122 0.113
R1242 VSS.n126 VSS.n125 0.113
R1243 VSS.n127 VSS.n126 0.113
R1244 VSS.n128 VSS.n127 0.113
R1245 VSS.n128 VSS.n106 0.113
R1246 VSS.n155 VSS.n100 0.113
R1247 VSS.n170 VSS.n100 0.113
R1248 VSS.n171 VSS.n170 0.113
R1249 VSS.n172 VSS.n171 0.113
R1250 VSS.n172 VSS.n88 0.113
R1251 VSS.n187 VSS.n88 0.113
R1252 VSS.n188 VSS.n187 0.113
R1253 VSS.n189 VSS.n188 0.113
R1254 VSS.n190 VSS.n189 0.113
R1255 VSS.n191 VSS.n190 0.113
R1256 VSS.n193 VSS.n192 0.113
R1257 VSS.n194 VSS.n193 0.113
R1258 VSS.n195 VSS.n194 0.113
R1259 VSS.n196 VSS.n195 0.113
R1260 VSS.n197 VSS.n196 0.113
R1261 VSS.n198 VSS.n197 0.113
R1262 VSS.n199 VSS.n198 0.113
R1263 VSS.n200 VSS.n199 0.113
R1264 VSS.n201 VSS.n200 0.113
R1265 VSS.n202 VSS.n201 0.113
R1266 VSS.n204 VSS.n202 0.113
R1267 VSS.n204 VSS.n203 0.113
R1268 VSS.n203 VSS.n78 0.113
R1269 VSS.n288 VSS.n287 0.113
R1270 VSS.n287 VSS.n286 0.113
R1271 VSS.n286 VSS.n255 0.113
R1272 VSS.n282 VSS.n255 0.113
R1273 VSS.n282 VSS.n281 0.113
R1274 VSS.n281 VSS.n280 0.113
R1275 VSS.n280 VSS.n260 0.113
R1276 VSS.n276 VSS.n260 0.113
R1277 VSS.n276 VSS.n275 0.113
R1278 VSS.n275 VSS.n274 0.113
R1279 VSS.n274 VSS.n266 0.113
R1280 VSS.n270 VSS.n266 0.113
R1281 VSS.n270 VSS.n1 0.113
R1282 VSS.n297 VSS.n65 0.113
R1283 VSS.n298 VSS.n297 0.113
R1284 VSS.n299 VSS.n298 0.113
R1285 VSS.n299 VSS.n58 0.113
R1286 VSS.n307 VSS.n58 0.113
R1287 VSS.n308 VSS.n307 0.113
R1288 VSS.n312 VSS.n308 0.113
R1289 VSS.n312 VSS.n311 0.113
R1290 VSS.n311 VSS.n310 0.113
R1291 VSS.n310 VSS.n309 0.113
R1292 VSS.n371 VSS.n0 0.0958125
R1293 VSS.n332 VSS.n29 0.0905
R1294 VSS.n41 VSS.n29 0.0905
R1295 VSS.n370 VSS.n369 0.03175
R1296 VSS.n240 VSS.n0 0.0255
R1297 VSS.n352 VSS.n351 0.0239375
R1298 VSS.n162 VSS.n161 0.023
R1299 VSS.n164 VSS.n162 0.023
R1300 VSS.n164 VSS.n163 0.023
R1301 VSS.n179 VSS.n178 0.023
R1302 VSS.n180 VSS.n179 0.023
R1303 VSS.n180 VSS.n80 0.023
R1304 VSS.n237 VSS.n80 0.023
R1305 VSS.n240 VSS.n239 0.023
R1306 VSS.n369 VSS.n2 0.023
R1307 VSS.n365 VSS.n2 0.023
R1308 VSS.n363 VSS.n362 0.023
R1309 VSS.n362 VSS.n8 0.023
R1310 VSS.n358 VSS.n8 0.023
R1311 VSS.n358 VSS.n357 0.023
R1312 VSS.n357 VSS.n356 0.023
R1313 VSS.n356 VSS.n13 0.023
R1314 VSS.n364 VSS.n363 0.021125
R1315 VSS.n238 VSS.n237 0.0205
R1316 VSS.n352 VSS.n28 0.01925
R1317 VSS.n178 VSS.n94 0.0155
R1318 VSS.n163 VSS.n94 0.008
R1319 VSS.n28 VSS.n13 0.00425
R1320 VSS.n239 VSS.n238 0.003
R1321 VSS.n365 VSS.n364 0.002375
C0 B ctrl 0.083f
C1 ctrl_n B 0.40635f
C2 VDD VAPWR 0.53319f
C3 A ctrl 0.58047f
C4 VDD in 1.06318f
C5 A ctrl_n 0.38963f
C6 in VAPWR 0.00142f
C7 ctrl_n ctrl 1.31354f
C8 VDD B 0.00839f
C9 B VAPWR 1.21011f
C10 A VDD 0.00184f
C11 B in 0.00463f
C12 A VAPWR 0.97059f
C13 VDD ctrl 2.55712f
C14 VDD ctrl_n 0.4541f
C15 VAPWR ctrl 0.07808f
C16 ctrl_n VAPWR 0.01936f
C17 A in 0
C18 in ctrl 0.91632f
C19 ctrl_n in 0.002f
C20 A B 1.34506f
C21 A VSS 1.43099f
C22 B VSS 1.66314f
C23 in VSS 0.87415f
C24 VAPWR VSS 7.1309f
C25 VDD VSS 7.39604f
C26 ctrl_n VSS 1.45338f
C27 ctrl VSS 2.31652f
C28 VDD.t7 VSS 0.01154f
C29 VDD.n0 VSS 0.06132f
C30 VDD.n1 VSS 0.03156f
C31 VDD.n2 VSS 0.00631f
C32 VDD.n3 VSS 0.00631f
C33 VDD.n4 VSS 0.00631f
C34 VDD.n5 VSS 0.00631f
C35 VDD.n6 VSS 0.00631f
C36 VDD.t5 VSS 0.00986f
C37 VDD.t3 VSS 0.00986f
C38 VDD.n7 VSS 0.02057f
C39 VDD.n8 VSS 0.03156f
C40 VDD.n9 VSS 0.00631f
C41 VDD.n10 VSS 0.00631f
C42 VDD.n11 VSS 0.00631f
C43 VDD.n12 VSS 0.0125f
C44 VDD.n13 VSS 0.00426f
C45 VDD.n14 VSS 0.00268f
C46 VDD.n15 VSS 0.00355f
C47 VDD.n16 VSS 0.00301f
C48 VDD.t1 VSS 0.00879f
C49 VDD.n17 VSS 0.01441f
C50 VDD.n18 VSS 0.03316f
C51 VDD.n19 VSS 0.00268f
C52 VDD.n20 VSS 0.00982f
C53 VDD.n21 VSS 0.00514f
C54 VDD.n22 VSS 0.00893f
C55 VDD.n23 VSS 0.02071f
C56 VDD.n24 VSS 0.00395f
C57 VDD.n25 VSS 0.01293f
C58 VDD.n26 VSS 0.00631f
C59 VDD.n27 VSS 0.00631f
C60 VDD.n28 VSS 0.00631f
C61 VDD.n29 VSS 0.00395f
C62 VDD.n30 VSS 0.00631f
C63 VDD.n31 VSS 0.00631f
C64 VDD.n32 VSS 0.00631f
C65 VDD.n33 VSS 0.00631f
C66 VDD.n34 VSS 0.00631f
C67 VDD.n35 VSS 0.00395f
C68 VDD.n36 VSS 0.00631f
C69 VDD.n37 VSS 0.00631f
C70 VDD.n38 VSS 0.00631f
C71 VDD.n39 VSS 0.01293f
C72 VDD.n40 VSS 0.00631f
C73 VDD.n41 VSS 0.00631f
C74 VDD.n42 VSS 0.00631f
C75 VDD.n43 VSS 0.01293f
C76 VDD.t2 VSS 0.05445f
C77 VDD.n44 VSS 0.00631f
C78 VDD.n45 VSS 0.00631f
C79 VDD.n46 VSS 0.00631f
C80 VDD.n47 VSS 0.00631f
C81 VDD.n48 VSS 0.00631f
C82 VDD.n49 VSS 0.10889f
C83 VDD.n50 VSS 0.00631f
C84 VDD.n51 VSS 0.00631f
C85 VDD.n52 VSS 0.00631f
C86 VDD.n53 VSS 0.00631f
C87 VDD.n54 VSS 0.00631f
C88 VDD.t6 VSS 0.05445f
C89 VDD.n55 VSS 0.0125f
C90 VDD.n56 VSS 0.00631f
C91 VDD.n57 VSS 0.28736f
C92 VDD.n58 VSS 0.01293f
C93 VDD.n59 VSS 0.01293f
C94 VDD.n60 VSS 0.00631f
C95 VDD.n61 VSS 0.00631f
C96 VDD.n62 VSS 0.00631f
C97 VDD.n63 VSS 0.00631f
C98 VDD.n64 VSS 0.00631f
C99 VDD.n65 VSS 0.00631f
C100 VDD.n66 VSS 0.00631f
C101 VDD.n67 VSS 0.00631f
C102 VDD.n68 VSS 0.00631f
C103 VDD.n69 VSS 0.00631f
C104 VDD.n70 VSS 0.00631f
C105 VDD.n71 VSS 0.0125f
C106 VDD.n72 VSS 0.0171f
C107 VDD.n73 VSS 0.03156f
C108 VDD.n74 VSS 0.15556f
C109 VDD.n75 VSS 0.00631f
C110 VDD.n76 VSS 0.0368f
C111 VDD.n77 VSS 0.01293f
C112 VDD.n78 VSS 0.01293f
C113 VDD.n80 VSS 0.00631f
C114 VDD.n81 VSS 0.00631f
C115 VDD.n83 VSS 0.00631f
C116 VDD.n84 VSS 0.00631f
C117 VDD.n85 VSS 0.00631f
C118 VDD.n86 VSS 0.00631f
C119 VDD.n87 VSS 0.00631f
C120 VDD.n88 VSS 0.00631f
C121 VDD.n89 VSS 0.00631f
C122 VDD.n91 VSS 0.00631f
C123 VDD.n93 VSS 0.00631f
C124 VDD.n94 VSS 0.00631f
C125 VDD.n95 VSS 0.00631f
C126 VDD.n96 VSS 0.00631f
C127 VDD.n97 VSS 0.00631f
C128 VDD.n98 VSS 0.00631f
C129 VDD.n99 VSS 0.00631f
C130 VDD.n101 VSS 0.00631f
C131 VDD.n103 VSS 0.00631f
C132 VDD.n104 VSS 0.00631f
C133 VDD.n105 VSS 0.00631f
C134 VDD.n106 VSS 0.01293f
C135 VDD.n107 VSS 0.0125f
C136 VDD.n108 VSS 0.0125f
C137 VDD.n109 VSS 0.0125f
C138 VDD.n110 VSS 0.13007f
C139 VDD.n111 VSS 0.0794f
C140 VDD.n112 VSS 0.00631f
C141 VDD.n113 VSS 0.00631f
C142 VDD.n114 VSS 0.08394f
C143 VDD.n115 VSS 0.00631f
C144 VDD.n116 VSS 0.00631f
C145 VDD.n117 VSS 0.00631f
C146 VDD.n118 VSS 0.00631f
C147 VDD.n119 VSS 0.00631f
C148 VDD.n120 VSS 0.00631f
C149 VDD.n121 VSS 0.00631f
C150 VDD.n122 VSS 0.10889f
C151 VDD.n123 VSS 0.10889f
C152 VDD.n124 VSS 0.06806f
C153 VDD.t4 VSS 0.05445f
C154 VDD.n125 VSS 0.00631f
C155 VDD.n126 VSS 0.05672f
C156 VDD.n127 VSS 0.00631f
C157 VDD.n128 VSS 0.00631f
C158 VDD.n129 VSS 0.00631f
C159 VDD.n130 VSS 0.00631f
C160 VDD.n131 VSS 0.00631f
C161 VDD.n132 VSS 0.00631f
C162 VDD.n133 VSS 0.00631f
C163 VDD.n134 VSS 0.06806f
C164 VDD.t0 VSS 0.05445f
C165 VDD.n135 VSS 0.0794f
C166 VDD.n138 VSS 0.00631f
C167 VDD.n141 VSS 0.00631f
C168 VDD.n144 VSS 0.28736f
C169 VDD.n145 VSS 0.0125f
C170 VDD.n146 VSS 0.13007f
C171 VDD.n147 VSS 0.0125f
C172 VDD.n148 VSS 0.0125f
C173 VDD.n149 VSS 0.00644f
C174 VDD.n150 VSS 0.01796f
C175 VDD.n151 VSS 0.00565f
C176 VDD.n152 VSS 0.00395f
C177 VDD.n153 VSS 0.00631f
C178 VDD.n154 VSS 0.00631f
C179 VDD.n155 VSS 0.00631f
C180 VDD.n156 VSS 0.00395f
C181 VDD.n157 VSS 0.00395f
C182 VDD.n158 VSS 0.00395f
C183 VDD.n159 VSS 0.00631f
C184 VDD.n160 VSS 0.00631f
C185 VDD.n161 VSS 0.00631f
C186 VDD.n162 VSS 0.00631f
C187 VDD.n163 VSS 0.00395f
C188 VDD.n164 VSS 0.00395f
C189 VDD.n165 VSS 0.00395f
C190 VDD.n166 VSS 0.00631f
C191 VDD.n167 VSS 0.00631f
C192 VDD.n168 VSS 0.01293f
C193 VDD.n169 VSS 0.00534f
C194 VDD.n170 VSS 0.03669f
C195 VDD.n171 VSS 0.02959f
C196 VDD.n172 VSS 0.01998f
C197 VDD.n173 VSS 0.01841f
C198 VDD.n174 VSS 0.00631f
C199 VDD.n175 VSS 0.00631f
C200 VDD.n176 VSS 0.00631f
C201 VDD.n177 VSS 0.02104f
C202 VDD.n178 VSS 0.07612f
C203 VDD.n179 VSS 0.0263f
C204 VDD.n180 VSS 0.03156f
C205 VDD.n181 VSS 0.00631f
C206 VDD.n182 VSS 0.00631f
C207 VDD.n183 VSS 0.00631f
C208 VDD.n184 VSS 0.016f
C209 VDD.n185 VSS 0.57118f
C210 VAPWR.n0 VSS 0.01216f
C211 VAPWR.n1 VSS 0.01837f
C212 VAPWR.n2 VSS 0.00389f
C213 VAPWR.n3 VSS 0.00389f
C214 VAPWR.n4 VSS 0.00389f
C215 VAPWR.n5 VSS 0.00389f
C216 VAPWR.n6 VSS 0.00728f
C217 VAPWR.t3 VSS 0.00913f
C218 VAPWR.n7 VSS 0.06097f
C219 VAPWR.n8 VSS 0.00389f
C220 VAPWR.n9 VSS 0.00731f
C221 VAPWR.n10 VSS 0.00389f
C222 VAPWR.n11 VSS 0.00389f
C223 VAPWR.n12 VSS 0.00389f
C224 VAPWR.n13 VSS 0.00389f
C225 VAPWR.n14 VSS 0.00389f
C226 VAPWR.n15 VSS 0.00389f
C227 VAPWR.n16 VSS 0.00389f
C228 VAPWR.n17 VSS 0.00389f
C229 VAPWR.n18 VSS 0.00389f
C230 VAPWR.n19 VSS 0.00389f
C231 VAPWR.n20 VSS 0.00389f
C232 VAPWR.n21 VSS 0.00389f
C233 VAPWR.n22 VSS 0.00389f
C234 VAPWR.n23 VSS 0.00728f
C235 VAPWR.n24 VSS 0.00731f
C236 VAPWR.n25 VSS 0.00389f
C237 VAPWR.n26 VSS 0.00389f
C238 VAPWR.t2 VSS 0.03355f
C239 VAPWR.n27 VSS 0.00389f
C240 VAPWR.n28 VSS 0.00389f
C241 VAPWR.n29 VSS 0.00389f
C242 VAPWR.n30 VSS 0.00389f
C243 VAPWR.n31 VSS 0.00389f
C244 VAPWR.n32 VSS 0.0671f
C245 VAPWR.n33 VSS 0.05964f
C246 VAPWR.n34 VSS 0.00389f
C247 VAPWR.n35 VSS 0.00389f
C248 VAPWR.t1 VSS 0.00913f
C249 VAPWR.n36 VSS 0.01945f
C250 VAPWR.n37 VSS 0.00389f
C251 VAPWR.n38 VSS 0.00389f
C252 VAPWR.t0 VSS 0.03355f
C253 VAPWR.n39 VSS 0.00389f
C254 VAPWR.n40 VSS 0.00389f
C255 VAPWR.n41 VSS 0.00389f
C256 VAPWR.n42 VSS 0.00389f
C257 VAPWR.n43 VSS 0.00389f
C258 VAPWR.n44 VSS 0.07082f
C259 VAPWR.n45 VSS 0.00728f
C260 VAPWR.n46 VSS 0.00728f
C261 VAPWR.n47 VSS 0.00389f
C262 VAPWR.n48 VSS 0.00731f
C263 VAPWR.n49 VSS 0.00389f
C264 VAPWR.n50 VSS 0.00389f
C265 VAPWR.n51 VSS 0.00389f
C266 VAPWR.n52 VSS 0.00389f
C267 VAPWR.n53 VSS 0.00389f
C268 VAPWR.n54 VSS 0.00389f
C269 VAPWR.n55 VSS 0.00389f
C270 VAPWR.n56 VSS 0.00389f
C271 VAPWR.n57 VSS 0.00389f
C272 VAPWR.n58 VSS 0.00389f
C273 VAPWR.n59 VSS 0.00389f
C274 VAPWR.n60 VSS 0.00389f
C275 VAPWR.n61 VSS 0.00389f
C276 VAPWR.n62 VSS 0.00728f
C277 VAPWR.n63 VSS 0.00389f
C278 VAPWR.n64 VSS 0.00389f
C279 VAPWR.n67 VSS 0.00389f
C280 VAPWR.n71 VSS 0.16774f
C281 VAPWR.n73 VSS 0.00731f
C282 VAPWR.n74 VSS 0.00728f
C283 VAPWR.n75 VSS 0.00728f
C284 VAPWR.n76 VSS 0.00731f
C285 VAPWR.n77 VSS 0.00731f
C286 VAPWR.n78 VSS 0.00389f
C287 VAPWR.n79 VSS 0.00389f
C288 VAPWR.n80 VSS 0.00389f
C289 VAPWR.n81 VSS 0.00389f
C290 VAPWR.n82 VSS 0.00389f
C291 VAPWR.n83 VSS 0.00389f
C292 VAPWR.n84 VSS 0.00389f
C293 VAPWR.n85 VSS 0.00389f
C294 VAPWR.n86 VSS 0.00389f
C295 VAPWR.n87 VSS 0.00389f
C296 VAPWR.n88 VSS 0.00389f
C297 VAPWR.n89 VSS 0.00389f
C298 VAPWR.n90 VSS 0.00389f
C299 VAPWR.n91 VSS 0.00389f
C300 VAPWR.n92 VSS 0.00389f
C301 VAPWR.n93 VSS 0.00389f
C302 VAPWR.n94 VSS 0.00731f
C303 VAPWR.n95 VSS 0.01085f
C304 VAPWR.n96 VSS 0.05366f
C305 VAPWR.n97 VSS 0.01945f
C306 VAPWR.n98 VSS 0.00389f
C307 VAPWR.n99 VSS 0.00389f
C308 VAPWR.n100 VSS 0.0671f
C309 VAPWR.n101 VSS 0.041f
C310 VAPWR.n102 VSS 0.00389f
C311 VAPWR.n103 VSS 0.00389f
C312 VAPWR.n104 VSS 0.00389f
C313 VAPWR.n105 VSS 0.00389f
C314 VAPWR.n106 VSS 0.00389f
C315 VAPWR.n107 VSS 0.00389f
C316 VAPWR.n108 VSS 0.00389f
C317 VAPWR.n109 VSS 0.0671f
C318 VAPWR.n110 VSS 0.05964f
C319 VAPWR.n111 VSS 0.00389f
C320 VAPWR.n112 VSS 0.00389f
C321 VAPWR.n113 VSS 0.01297f
C322 VAPWR.n114 VSS 0.06097f
C323 VAPWR.n115 VSS 0.01621f
C324 VAPWR.n116 VSS 0.01945f
C325 VAPWR.n117 VSS 0.00389f
C326 VAPWR.n118 VSS 0.00389f
C327 VAPWR.n119 VSS 0.00389f
C328 VAPWR.n120 VSS 0.0671f
C329 VAPWR.n121 VSS 0.00389f
C330 VAPWR.n122 VSS 0.00389f
C331 VAPWR.n123 VSS 0.00389f
C332 VAPWR.n124 VSS 0.00389f
C333 VAPWR.n125 VSS 0.00389f
C334 VAPWR.n126 VSS 0.00389f
C335 VAPWR.n127 VSS 0.00389f
C336 VAPWR.n128 VSS 0.00389f
C337 VAPWR.n129 VSS 0.041f
C338 VAPWR.n130 VSS 0.0671f
C339 VAPWR.n131 VSS 0.00389f
C340 VAPWR.n134 VSS 0.00389f
C341 VAPWR.n137 VSS 0.00389f
C342 VAPWR.n140 VSS 0.16774f
C343 VAPWR.n141 VSS 0.00728f
C344 VAPWR.n142 VSS 0.07082f
C345 VAPWR.n143 VSS 0.00728f
C346 VAPWR.n144 VSS 0.00728f
C347 VAPWR.n145 VSS 0.00731f
C348 VAPWR.n146 VSS 0.00731f
C349 VAPWR.n147 VSS 0.00389f
C350 VAPWR.n148 VSS 0.00389f
C351 VAPWR.n149 VSS 0.00389f
C352 VAPWR.n150 VSS 0.00389f
C353 VAPWR.n151 VSS 0.00389f
C354 VAPWR.n152 VSS 0.00389f
C355 VAPWR.n153 VSS 0.00389f
C356 VAPWR.n154 VSS 0.00389f
C357 VAPWR.n155 VSS 0.00389f
C358 VAPWR.n156 VSS 0.00389f
C359 VAPWR.n157 VSS 0.00389f
C360 VAPWR.n158 VSS 0.00389f
C361 VAPWR.n159 VSS 0.00389f
C362 VAPWR.n160 VSS 0.00389f
C363 VAPWR.n161 VSS 0.00389f
C364 VAPWR.n162 VSS 0.00389f
C365 VAPWR.n163 VSS 0.00731f
C366 VAPWR.n164 VSS 0.01912f
C367 VAPWR.n165 VSS 0.094f
C368 VAPWR.n166 VSS 0.0108f
C369 VAPWR.n167 VSS 0.00389f
C370 VAPWR.n168 VSS 0.00389f
C371 VAPWR.n169 VSS 0.00389f
C372 VAPWR.n170 VSS 0.01702f
C373 VAPWR.n171 VSS 0.38442f
C374 in.t1 VSS 0.11914f
C375 in.t2 VSS 0.13502f
C376 in.n0 VSS 0.4071f
C377 in.t3 VSS 0.11912f
C378 in.n1 VSS 0.22386f
C379 in.t0 VSS 0.12043f
C380 in.n2 VSS 0.67757f
C381 B.t2 VSS 0.22934f
C382 B.t0 VSS 0.09571f
C383 B.t1 VSS 0.4682f
C384 B.n0 VSS 1.45145f
C385 B.n1 VSS 0.69465f
C386 A.t0 VSS 0.10246f
C387 A.t1 VSS 0.47103f
C388 A.n0 VSS 1.55223f
C389 A.t2 VSS 0.24322f
C390 A.n1 VSS 0.76344f
.ends
