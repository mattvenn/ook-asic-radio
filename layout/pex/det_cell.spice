* det_cell: magic R+C extraction of layout/det_cell.gds (layout/pex.sh)
.subckt det_cell inp inn vb out VSS
X0 a_337_2520# vb.t0 VSS.t1 sky130_fd_pr__res_xhigh_po_0p35 l=6.78
X1 a_737_2520# a_537_760# VSS.t2 sky130_fd_pr__res_xhigh_po_0p35 l=6.78
X2 a_3159_2520# a_3359_760# VSS.t14 sky130_fd_pr__res_xhigh_po_0p35 l=6.78
X3 out.t0 gp sp VSS.t6 sky130_fd_pr__nfet_01v8 ad=0.3 pd=2.6 as=0.3 ps=2.6 w=1 l=0.15
X4 a_2525_2072# VSS.t11 VSS.t10 sky130_fd_pr__res_high_po_0p35 l=4.54
X5 a_3559_2520# vb.t1 VSS.t15 sky130_fd_pr__res_xhigh_po_0p35 l=6.78
X6 a_1371_2072# sp VSS.t3 sky130_fd_pr__res_high_po_0p35 l=4.54
X7 sn gn out.t1 VSS.t7 sky130_fd_pr__nfet_01v8 ad=0.3 pd=2.6 as=0.3 ps=2.6 w=1 l=0.15
X8 gn inn.t0 sky130_fd_pr__cap_mim_m3_1 l=6.965 w=6.965
X9 a_337_2520# a_537_760# VSS.t0 sky130_fd_pr__res_xhigh_po_0p35 l=6.78
X10 a_737_2520# gp VSS.t8 sky130_fd_pr__res_xhigh_po_0p35 l=6.78
X11 a_2525_2072# sn VSS.t9 sky130_fd_pr__res_high_po_0p35 l=4.54
X12 a_3159_2520# gn VSS.t12 sky130_fd_pr__res_xhigh_po_0p35 l=6.78
X13 a_3559_2520# a_3359_760# VSS.t13 sky130_fd_pr__res_xhigh_po_0p35 l=6.78
X14 a_1371_2072# VSS.t5 VSS.t4 sky130_fd_pr__res_high_po_0p35 l=4.54
X15 gp inp.t0 sky130_fd_pr__cap_mim_m3_1 l=6.965 w=6.965
R0 inn inn.t0 0.023984
R1 inp inp.t0 0.023984
R2 out.n1 out.t0 136.309
R3 out.n0 out.t1 136.309
R4 out out.n1 3.14844
R5 out.n0 out 2.8931
R6 out.n1 out.n0 0.312911
R7 vb.n24 vb.n19 50.6672
R8 vb.n7 vb.n2 50.6672
R9 vb.n31 vb.n18 17.8167
R10 vb.n14 vb.n1 17.8167
R11 vb.n32 vb.n31 15.8839
R12 vb.n15 vb.n14 15.8839
R13 vb.n22 vb.n20 13.1884
R14 vb.n5 vb.n3 13.1884
R15 vb.n23 vb.n22 13.1662
R16 vb.n25 vb.n23 13.1662
R17 vb.n26 vb.n21 13.1662
R18 vb.n30 vb.n29 13.1662
R19 vb.n6 vb.n5 13.1662
R20 vb.n8 vb.n6 13.1662
R21 vb.n9 vb.n4 13.1662
R22 vb.n13 vb.n12 13.1662
R23 vb.n30 vb.n17 9.3005
R24 vb.n29 vb.n28 9.3005
R25 vb.n29 vb.n18 9.3005
R26 vb.n27 vb.n26 9.3005
R27 vb.n26 vb.n25 9.3005
R28 vb.n23 vb.n21 9.3005
R29 vb.n13 vb.n0 9.3005
R30 vb.n12 vb.n11 9.3005
R31 vb.n12 vb.n1 9.3005
R32 vb.n10 vb.n9 9.3005
R33 vb.n9 vb.n8 9.3005
R34 vb.n6 vb.n4 9.3005
R35 vb.n22 vb.t0 7.13193
R36 vb.n5 vb.t1 7.13193
R37 vb.n24 vb.n18 6.76621
R38 vb.n29 vb.n19 6.76621
R39 vb.n7 vb.n1 6.76621
R40 vb.n12 vb.n2 6.76621
R41 vb.n25 vb.n24 6.4005
R42 vb.n26 vb.n19 6.4005
R43 vb.n8 vb.n7 6.4005
R44 vb.n9 vb.n2 6.4005
R45 vb.n33 vb.n16 5.34728
R46 vb.n21 vb.n20 3.8419
R47 vb.n4 vb.n3 3.8419
R48 vb.n27 vb.n20 2.85946
R49 vb.n10 vb.n3 2.85946
R50 vb.n31 vb.n30 2.72607
R51 vb.n14 vb.n13 2.72607
R52 vb.n33 vb.n32 2.61092
R53 vb.n16 vb.n15 2.61092
R54 vb vb.n33 0.631389
R55 vb.n16 vb 0.375769
R56 vb.n28 vb.n27 0.113
R57 vb.n28 vb.n17 0.113
R58 vb.n32 vb.n17 0.113
R59 vb.n11 vb.n10 0.113
R60 vb.n11 vb.n0 0.113
R61 vb.n15 vb.n0 0.113
R62 VSS.n198 VSS.n197 585
R63 VSS.n197 VSS.n195 585
R64 VSS.n332 VSS.n331 585
R65 VSS.n333 VSS.n332 585
R66 VSS.n189 VSS.n188 585
R67 VSS.n196 VSS.n189 585
R68 VSS.n343 VSS.n342 585
R69 VSS.n342 VSS.n341 585
R70 VSS.n186 VSS.n185 585
R71 VSS.n185 VSS.n184 585
R72 VSS.n348 VSS.n347 585
R73 VSS.n349 VSS.n348 585
R74 VSS.n177 VSS.n176 585
R75 VSS.n178 VSS.n177 585
R76 VSS.n360 VSS.n359 585
R77 VSS.n359 VSS.n358 585
R78 VSS.n174 VSS.n173 585
R79 VSS.n357 VSS.n173 585
R80 VSS.n365 VSS.n364 585
R81 VSS.n366 VSS.n365 585
R82 VSS.n166 VSS.n165 585
R83 VSS.n167 VSS.n166 585
R84 VSS.n376 VSS.n375 585
R85 VSS.n375 VSS.n374 585
R86 VSS.n163 VSS.n162 585
R87 VSS.n162 VSS.n161 585
R88 VSS.n381 VSS.n380 585
R89 VSS.n382 VSS.n381 585
R90 VSS.n154 VSS.n153 585
R91 VSS.n155 VSS.n154 585
R92 VSS.n392 VSS.n391 585
R93 VSS.n391 VSS.n390 585
R94 VSS.n151 VSS.n150 585
R95 VSS.n150 VSS.n149 585
R96 VSS.n397 VSS.n396 585
R97 VSS.n398 VSS.n397 585
R98 VSS.n126 VSS.n125 585
R99 VSS.n127 VSS.n126 585
R100 VSS.n409 VSS.n408 585
R101 VSS.n408 VSS.n407 585
R102 VSS.n123 VSS.n122 585
R103 VSS.n122 VSS.n121 585
R104 VSS.n414 VSS.n413 585
R105 VSS.n415 VSS.n414 585
R106 VSS.n114 VSS.n113 585
R107 VSS.n115 VSS.n114 585
R108 VSS.n426 VSS.n425 585
R109 VSS.n425 VSS.n424 585
R110 VSS.n111 VSS.n110 585
R111 VSS.n423 VSS.n110 585
R112 VSS.n431 VSS.n430 585
R113 VSS.n432 VSS.n431 585
R114 VSS.n103 VSS.n102 585
R115 VSS.n104 VSS.n103 585
R116 VSS.n443 VSS.n442 585
R117 VSS.n442 VSS.n441 585
R118 VSS.n100 VSS.n99 585
R119 VSS.n440 VSS.n99 585
R120 VSS.n448 VSS.n447 585
R121 VSS.n449 VSS.n448 585
R122 VSS.n92 VSS.n91 585
R123 VSS.n93 VSS.n92 585
R124 VSS.n459 VSS.n458 585
R125 VSS.n458 VSS.n457 585
R126 VSS.n89 VSS.n88 585
R127 VSS.n88 VSS.n87 585
R128 VSS.n464 VSS.n463 585
R129 VSS.n465 VSS.n464 585
R130 VSS.n80 VSS.n79 585
R131 VSS.n81 VSS.n80 585
R132 VSS.n492 VSS.n491 585
R133 VSS.n491 VSS.n490 585
R134 VSS.n77 VSS.n76 585
R135 VSS.n76 VSS.n75 585
R136 VSS.n497 VSS.n496 585
R137 VSS.n498 VSS.n497 585
R138 VSS.n68 VSS.n67 585
R139 VSS.n69 VSS.n68 585
R140 VSS.n508 VSS.n507 585
R141 VSS.n507 VSS.n506 585
R142 VSS.n65 VSS.n64 585
R143 VSS.n64 VSS.n63 585
R144 VSS.n513 VSS.n512 585
R145 VSS.n514 VSS.n513 585
R146 VSS.n56 VSS.n55 585
R147 VSS.n57 VSS.n56 585
R148 VSS.n525 VSS.n524 585
R149 VSS.n524 VSS.n523 585
R150 VSS.n53 VSS.n52 585
R151 VSS.n522 VSS.n52 585
R152 VSS.n530 VSS.n529 585
R153 VSS.n531 VSS.n530 585
R154 VSS.n45 VSS.n44 585
R155 VSS.n46 VSS.n45 585
R156 VSS.n541 VSS.n540 585
R157 VSS.n540 VSS.n539 585
R158 VSS.n41 VSS.n39 585
R159 VSS.n39 VSS.n37 585
R160 VSS.n547 VSS.n546 585
R161 VSS.n548 VSS.n547 585
R162 VSS.n42 VSS.n40 585
R163 VSS.n40 VSS.n38 585
R164 VSS.n30 VSS.n29 585
R165 VSS.n31 VSS.n30 585
R166 VSS.n559 VSS.n558 585
R167 VSS.n558 VSS.n557 585
R168 VSS.n26 VSS.n24 585
R169 VSS.n24 VSS.n6 585
R170 VSS.n669 VSS.n668 585
R171 VSS.n5 VSS.n4 585
R172 VSS.n612 VSS.n611 585
R173 VSS.n609 VSS.n608 585
R174 VSS.n616 VSS.n607 585
R175 VSS.n617 VSS.n606 585
R176 VSS.n618 VSS.n605 585
R177 VSS.n603 VSS.n602 585
R178 VSS.n622 VSS.n601 585
R179 VSS.n623 VSS.n600 585
R180 VSS.n624 VSS.n599 585
R181 VSS.n597 VSS.n596 585
R182 VSS.n628 VSS.n595 585
R183 VSS.n629 VSS.n594 585
R184 VSS.n630 VSS.n593 585
R185 VSS.n591 VSS.n590 585
R186 VSS.n634 VSS.n589 585
R187 VSS.n635 VSS.n588 585
R188 VSS.n636 VSS.n587 585
R189 VSS.n585 VSS.n584 585
R190 VSS.n640 VSS.n583 585
R191 VSS.n641 VSS.n582 585
R192 VSS.n642 VSS.n581 585
R193 VSS.n579 VSS.n578 585
R194 VSS.n646 VSS.n577 585
R195 VSS.n647 VSS.n576 585
R196 VSS.n648 VSS.n575 585
R197 VSS.n573 VSS.n572 585
R198 VSS.n652 VSS.n571 585
R199 VSS.n653 VSS.n570 585
R200 VSS.n654 VSS.n569 585
R201 VSS.n567 VSS.n566 585
R202 VSS.n658 VSS.n565 585
R203 VSS.n659 VSS.n564 585
R204 VSS.n660 VSS.n563 585
R205 VSS.n27 VSS.n25 585
R206 VSS.n665 VSS.n664 585
R207 VSS.n666 VSS.n665 585
R208 VSS.n670 VSS.n3 585
R209 VSS.n6 VSS.n3 585
R210 VSS.n556 VSS.n2 585
R211 VSS.n557 VSS.n556 585
R212 VSS.n555 VSS.n554 585
R213 VSS.n555 VSS.n31 585
R214 VSS.n33 VSS.n32 585
R215 VSS.n38 VSS.n32 585
R216 VSS.n550 VSS.n549 585
R217 VSS.n549 VSS.n548 585
R218 VSS.n36 VSS.n35 585
R219 VSS.n37 VSS.n36 585
R220 VSS.n538 VSS.n537 585
R221 VSS.n539 VSS.n538 585
R222 VSS.n48 VSS.n47 585
R223 VSS.n47 VSS.n46 585
R224 VSS.n533 VSS.n532 585
R225 VSS.n532 VSS.n531 585
R226 VSS.n51 VSS.n50 585
R227 VSS.n522 VSS.n51 585
R228 VSS.n521 VSS.n520 585
R229 VSS.n523 VSS.n521 585
R230 VSS.n59 VSS.n58 585
R231 VSS.n58 VSS.n57 585
R232 VSS.n516 VSS.n515 585
R233 VSS.n515 VSS.n514 585
R234 VSS.n62 VSS.n61 585
R235 VSS.n63 VSS.n62 585
R236 VSS.n505 VSS.n504 585
R237 VSS.n506 VSS.n505 585
R238 VSS.n71 VSS.n70 585
R239 VSS.n70 VSS.n69 585
R240 VSS.n500 VSS.n499 585
R241 VSS.n499 VSS.n498 585
R242 VSS.n74 VSS.n73 585
R243 VSS.n75 VSS.n74 585
R244 VSS.n489 VSS.n488 585
R245 VSS.n490 VSS.n489 585
R246 VSS.n83 VSS.n82 585
R247 VSS.n82 VSS.n81 585
R248 VSS.n467 VSS.n466 585
R249 VSS.n466 VSS.n465 585
R250 VSS.n86 VSS.n85 585
R251 VSS.n87 VSS.n86 585
R252 VSS.n456 VSS.n455 585
R253 VSS.n457 VSS.n456 585
R254 VSS.n95 VSS.n94 585
R255 VSS.n94 VSS.n93 585
R256 VSS.n451 VSS.n450 585
R257 VSS.n450 VSS.n449 585
R258 VSS.n98 VSS.n97 585
R259 VSS.n440 VSS.n98 585
R260 VSS.n439 VSS.n438 585
R261 VSS.n441 VSS.n439 585
R262 VSS.n106 VSS.n105 585
R263 VSS.n105 VSS.n104 585
R264 VSS.n434 VSS.n433 585
R265 VSS.n433 VSS.n432 585
R266 VSS.n109 VSS.n108 585
R267 VSS.n423 VSS.n109 585
R268 VSS.n422 VSS.n421 585
R269 VSS.n424 VSS.n422 585
R270 VSS.n117 VSS.n116 585
R271 VSS.n116 VSS.n115 585
R272 VSS.n417 VSS.n416 585
R273 VSS.n416 VSS.n415 585
R274 VSS.n120 VSS.n119 585
R275 VSS.n121 VSS.n120 585
R276 VSS.n406 VSS.n405 585
R277 VSS.n407 VSS.n406 585
R278 VSS.n129 VSS.n128 585
R279 VSS.n128 VSS.n127 585
R280 VSS.n400 VSS.n399 585
R281 VSS.n399 VSS.n398 585
R282 VSS.n148 VSS.n147 585
R283 VSS.n149 VSS.n148 585
R284 VSS.n389 VSS.n388 585
R285 VSS.n390 VSS.n389 585
R286 VSS.n157 VSS.n156 585
R287 VSS.n156 VSS.n155 585
R288 VSS.n384 VSS.n383 585
R289 VSS.n383 VSS.n382 585
R290 VSS.n160 VSS.n159 585
R291 VSS.n161 VSS.n160 585
R292 VSS.n373 VSS.n372 585
R293 VSS.n374 VSS.n373 585
R294 VSS.n169 VSS.n168 585
R295 VSS.n168 VSS.n167 585
R296 VSS.n368 VSS.n367 585
R297 VSS.n367 VSS.n366 585
R298 VSS.n172 VSS.n171 585
R299 VSS.n357 VSS.n172 585
R300 VSS.n356 VSS.n355 585
R301 VSS.n358 VSS.n356 585
R302 VSS.n180 VSS.n179 585
R303 VSS.n179 VSS.n178 585
R304 VSS.n351 VSS.n350 585
R305 VSS.n350 VSS.n349 585
R306 VSS.n183 VSS.n182 585
R307 VSS.n184 VSS.n183 585
R308 VSS.n340 VSS.n339 585
R309 VSS.n341 VSS.n340 585
R310 VSS.n191 VSS.n190 585
R311 VSS.n196 VSS.n190 585
R312 VSS.n335 VSS.n334 585
R313 VSS.n334 VSS.n333 585
R314 VSS.n194 VSS.n193 585
R315 VSS.n195 VSS.n194 585
R316 VSS.n327 VSS.n200 585
R317 VSS.n326 VSS.n201 585
R318 VSS.n325 VSS.n202 585
R319 VSS.n270 VSS.n202 585
R320 VSS.n245 VSS.n203 585
R321 VSS.n321 VSS.n205 585
R322 VSS.n320 VSS.n206 585
R323 VSS.n319 VSS.n207 585
R324 VSS.n248 VSS.n208 585
R325 VSS.n315 VSS.n210 585
R326 VSS.n314 VSS.n211 585
R327 VSS.n313 VSS.n212 585
R328 VSS.n251 VSS.n213 585
R329 VSS.n309 VSS.n215 585
R330 VSS.n308 VSS.n216 585
R331 VSS.n307 VSS.n217 585
R332 VSS.n254 VSS.n218 585
R333 VSS.n303 VSS.n220 585
R334 VSS.n302 VSS.n221 585
R335 VSS.n301 VSS.n222 585
R336 VSS.n257 VSS.n223 585
R337 VSS.n297 VSS.n225 585
R338 VSS.n296 VSS.n226 585
R339 VSS.n295 VSS.n227 585
R340 VSS.n260 VSS.n228 585
R341 VSS.n291 VSS.n230 585
R342 VSS.n290 VSS.n231 585
R343 VSS.n289 VSS.n232 585
R344 VSS.n263 VSS.n233 585
R345 VSS.n285 VSS.n235 585
R346 VSS.n284 VSS.n236 585
R347 VSS.n283 VSS.n237 585
R348 VSS.n266 VSS.n238 585
R349 VSS.n279 VSS.n240 585
R350 VSS.n278 VSS.n241 585
R351 VSS.n277 VSS.n242 585
R352 VSS.n244 VSS.n243 585
R353 VSS.n273 VSS.n272 585
R354 VSS.n665 VSS.n24 472.8
R355 VSS.n668 VSS.n3 472.8
R356 VSS.n272 VSS.n194 472.8
R357 VSS.n200 VSS.n197 472.8
R358 VSS.n667 VSS.n666 254.01
R359 VSS.n666 VSS.n7 254.01
R360 VSS.n666 VSS.n8 254.01
R361 VSS.n666 VSS.n9 254.01
R362 VSS.n666 VSS.n10 254.01
R363 VSS.n666 VSS.n11 254.01
R364 VSS.n666 VSS.n12 254.01
R365 VSS.n666 VSS.n13 254.01
R366 VSS.n666 VSS.n14 254.01
R367 VSS.n666 VSS.n15 254.01
R368 VSS.n666 VSS.n16 254.01
R369 VSS.n666 VSS.n17 254.01
R370 VSS.n666 VSS.n18 254.01
R371 VSS.n666 VSS.n19 254.01
R372 VSS.n666 VSS.n20 254.01
R373 VSS.n666 VSS.n21 254.01
R374 VSS.n666 VSS.n22 254.01
R375 VSS.n666 VSS.n23 254.01
R376 VSS.n270 VSS.n269 254.01
R377 VSS.n270 VSS.n246 254.01
R378 VSS.n270 VSS.n247 254.01
R379 VSS.n270 VSS.n249 254.01
R380 VSS.n270 VSS.n250 254.01
R381 VSS.n270 VSS.n252 254.01
R382 VSS.n270 VSS.n253 254.01
R383 VSS.n270 VSS.n255 254.01
R384 VSS.n270 VSS.n256 254.01
R385 VSS.n270 VSS.n258 254.01
R386 VSS.n270 VSS.n259 254.01
R387 VSS.n270 VSS.n261 254.01
R388 VSS.n270 VSS.n262 254.01
R389 VSS.n270 VSS.n264 254.01
R390 VSS.n270 VSS.n265 254.01
R391 VSS.n270 VSS.n267 254.01
R392 VSS.n270 VSS.n268 254.01
R393 VSS.n271 VSS.n270 254.01
R394 VSS.n665 VSS.n25 177.3
R395 VSS.n564 VSS.n563 177.3
R396 VSS.n566 VSS.n565 177.3
R397 VSS.n570 VSS.n569 177.3
R398 VSS.n572 VSS.n571 177.3
R399 VSS.n576 VSS.n575 177.3
R400 VSS.n578 VSS.n577 177.3
R401 VSS.n582 VSS.n581 177.3
R402 VSS.n584 VSS.n583 177.3
R403 VSS.n588 VSS.n587 177.3
R404 VSS.n590 VSS.n589 177.3
R405 VSS.n594 VSS.n593 177.3
R406 VSS.n596 VSS.n595 177.3
R407 VSS.n600 VSS.n599 177.3
R408 VSS.n602 VSS.n601 177.3
R409 VSS.n606 VSS.n605 177.3
R410 VSS.n608 VSS.n607 177.3
R411 VSS.n611 VSS.n5 177.3
R412 VSS.n334 VSS.n194 177.3
R413 VSS.n334 VSS.n190 177.3
R414 VSS.n340 VSS.n190 177.3
R415 VSS.n340 VSS.n183 177.3
R416 VSS.n350 VSS.n183 177.3
R417 VSS.n350 VSS.n179 177.3
R418 VSS.n356 VSS.n179 177.3
R419 VSS.n356 VSS.n172 177.3
R420 VSS.n367 VSS.n172 177.3
R421 VSS.n367 VSS.n168 177.3
R422 VSS.n373 VSS.n168 177.3
R423 VSS.n373 VSS.n160 177.3
R424 VSS.n383 VSS.n160 177.3
R425 VSS.n383 VSS.n156 177.3
R426 VSS.n389 VSS.n156 177.3
R427 VSS.n389 VSS.n148 177.3
R428 VSS.n399 VSS.n148 177.3
R429 VSS.n399 VSS.n128 177.3
R430 VSS.n406 VSS.n128 177.3
R431 VSS.n406 VSS.n120 177.3
R432 VSS.n416 VSS.n120 177.3
R433 VSS.n416 VSS.n116 177.3
R434 VSS.n422 VSS.n116 177.3
R435 VSS.n422 VSS.n109 177.3
R436 VSS.n433 VSS.n109 177.3
R437 VSS.n433 VSS.n105 177.3
R438 VSS.n439 VSS.n105 177.3
R439 VSS.n439 VSS.n98 177.3
R440 VSS.n450 VSS.n98 177.3
R441 VSS.n450 VSS.n94 177.3
R442 VSS.n456 VSS.n94 177.3
R443 VSS.n456 VSS.n86 177.3
R444 VSS.n466 VSS.n86 177.3
R445 VSS.n466 VSS.n82 177.3
R446 VSS.n489 VSS.n82 177.3
R447 VSS.n489 VSS.n74 177.3
R448 VSS.n499 VSS.n74 177.3
R449 VSS.n499 VSS.n70 177.3
R450 VSS.n505 VSS.n70 177.3
R451 VSS.n505 VSS.n62 177.3
R452 VSS.n515 VSS.n62 177.3
R453 VSS.n515 VSS.n58 177.3
R454 VSS.n521 VSS.n58 177.3
R455 VSS.n521 VSS.n51 177.3
R456 VSS.n532 VSS.n51 177.3
R457 VSS.n532 VSS.n47 177.3
R458 VSS.n538 VSS.n47 177.3
R459 VSS.n538 VSS.n36 177.3
R460 VSS.n549 VSS.n36 177.3
R461 VSS.n549 VSS.n32 177.3
R462 VSS.n555 VSS.n32 177.3
R463 VSS.n556 VSS.n555 177.3
R464 VSS.n556 VSS.n3 177.3
R465 VSS.n202 VSS.n201 177.3
R466 VSS.n245 VSS.n202 177.3
R467 VSS.n206 VSS.n205 177.3
R468 VSS.n248 VSS.n207 177.3
R469 VSS.n211 VSS.n210 177.3
R470 VSS.n251 VSS.n212 177.3
R471 VSS.n216 VSS.n215 177.3
R472 VSS.n254 VSS.n217 177.3
R473 VSS.n221 VSS.n220 177.3
R474 VSS.n257 VSS.n222 177.3
R475 VSS.n226 VSS.n225 177.3
R476 VSS.n260 VSS.n227 177.3
R477 VSS.n231 VSS.n230 177.3
R478 VSS.n263 VSS.n232 177.3
R479 VSS.n236 VSS.n235 177.3
R480 VSS.n266 VSS.n237 177.3
R481 VSS.n241 VSS.n240 177.3
R482 VSS.n244 VSS.n242 177.3
R483 VSS.n332 VSS.n197 177.3
R484 VSS.n332 VSS.n189 177.3
R485 VSS.n342 VSS.n189 177.3
R486 VSS.n342 VSS.n185 177.3
R487 VSS.n348 VSS.n185 177.3
R488 VSS.n348 VSS.n177 177.3
R489 VSS.n359 VSS.n177 177.3
R490 VSS.n359 VSS.n173 177.3
R491 VSS.n365 VSS.n173 177.3
R492 VSS.n365 VSS.n166 177.3
R493 VSS.n375 VSS.n166 177.3
R494 VSS.n375 VSS.n162 177.3
R495 VSS.n381 VSS.n162 177.3
R496 VSS.n381 VSS.n154 177.3
R497 VSS.n391 VSS.n154 177.3
R498 VSS.n391 VSS.n150 177.3
R499 VSS.n397 VSS.n150 177.3
R500 VSS.n397 VSS.n126 177.3
R501 VSS.n408 VSS.n126 177.3
R502 VSS.n408 VSS.n122 177.3
R503 VSS.n414 VSS.n122 177.3
R504 VSS.n414 VSS.n114 177.3
R505 VSS.n425 VSS.n114 177.3
R506 VSS.n425 VSS.n110 177.3
R507 VSS.n431 VSS.n110 177.3
R508 VSS.n431 VSS.n103 177.3
R509 VSS.n442 VSS.n103 177.3
R510 VSS.n442 VSS.n99 177.3
R511 VSS.n448 VSS.n99 177.3
R512 VSS.n448 VSS.n92 177.3
R513 VSS.n458 VSS.n92 177.3
R514 VSS.n458 VSS.n88 177.3
R515 VSS.n464 VSS.n88 177.3
R516 VSS.n464 VSS.n80 177.3
R517 VSS.n491 VSS.n80 177.3
R518 VSS.n491 VSS.n76 177.3
R519 VSS.n497 VSS.n76 177.3
R520 VSS.n497 VSS.n68 177.3
R521 VSS.n507 VSS.n68 177.3
R522 VSS.n507 VSS.n64 177.3
R523 VSS.n513 VSS.n64 177.3
R524 VSS.n513 VSS.n56 177.3
R525 VSS.n524 VSS.n56 177.3
R526 VSS.n524 VSS.n52 177.3
R527 VSS.n530 VSS.n52 177.3
R528 VSS.n530 VSS.n45 177.3
R529 VSS.n540 VSS.n45 177.3
R530 VSS.n540 VSS.n39 177.3
R531 VSS.n547 VSS.n39 177.3
R532 VSS.n547 VSS.n40 177.3
R533 VSS.n40 VSS.n30 177.3
R534 VSS.n558 VSS.n30 177.3
R535 VSS.n558 VSS.n24 177.3
R536 VSS.n270 VSS.n195 122.906
R537 VSS.n666 VSS.n6 122.906
R538 VSS.n333 VSS.n195 98.3245
R539 VSS.n333 VSS.n196 98.3245
R540 VSS.n341 VSS.n184 98.3245
R541 VSS.n349 VSS.n184 98.3245
R542 VSS.n358 VSS.n178 98.3245
R543 VSS.n358 VSS.n357 98.3245
R544 VSS.n366 VSS.n167 98.3245
R545 VSS.n374 VSS.n167 98.3245
R546 VSS.n382 VSS.n161 98.3245
R547 VSS.n382 VSS.n155 98.3245
R548 VSS.n390 VSS.n155 98.3245
R549 VSS.n390 VSS.n149 98.3245
R550 VSS.n398 VSS.n149 98.3245
R551 VSS.n407 VSS.n127 98.3245
R552 VSS.n415 VSS.n121 98.3245
R553 VSS.n415 VSS.n115 98.3245
R554 VSS.n424 VSS.n115 98.3245
R555 VSS.n424 VSS.n423 98.3245
R556 VSS.n432 VSS.n104 98.3245
R557 VSS.n441 VSS.n104 98.3245
R558 VSS.n441 VSS.n440 98.3245
R559 VSS.n449 VSS.n93 98.3245
R560 VSS.n457 VSS.n93 98.3245
R561 VSS.n457 VSS.n87 98.3245
R562 VSS.n465 VSS.n87 98.3245
R563 VSS.n490 VSS.n81 98.3245
R564 VSS.n498 VSS.n75 98.3245
R565 VSS.n498 VSS.n69 98.3245
R566 VSS.n506 VSS.n69 98.3245
R567 VSS.n506 VSS.n63 98.3245
R568 VSS.n514 VSS.n63 98.3245
R569 VSS.n523 VSS.n57 98.3245
R570 VSS.n523 VSS.n522 98.3245
R571 VSS.n531 VSS.n46 98.3245
R572 VSS.n539 VSS.n46 98.3245
R573 VSS.n548 VSS.n37 98.3245
R574 VSS.n548 VSS.n38 98.3245
R575 VSS.n557 VSS.n31 98.3245
R576 VSS.n557 VSS.n6 98.3245
R577 VSS.t12 VSS.n161 91.4965
R578 VSS.n514 VSS.t8 91.4965
R579 VSS.t10 VSS.n127 88.7652
R580 VSS.n490 VSS.t4 88.7652
R581 VSS.n407 VSS.t9 86.034
R582 VSS.t3 VSS.n81 86.034
R583 VSS.n563 VSS.n23 76.985
R584 VSS.n565 VSS.n22 76.985
R585 VSS.n569 VSS.n21 76.985
R586 VSS.n571 VSS.n20 76.985
R587 VSS.n575 VSS.n19 76.985
R588 VSS.n577 VSS.n18 76.985
R589 VSS.n581 VSS.n17 76.985
R590 VSS.n583 VSS.n16 76.985
R591 VSS.n587 VSS.n15 76.985
R592 VSS.n589 VSS.n14 76.985
R593 VSS.n593 VSS.n13 76.985
R594 VSS.n595 VSS.n12 76.985
R595 VSS.n599 VSS.n11 76.985
R596 VSS.n601 VSS.n10 76.985
R597 VSS.n605 VSS.n9 76.985
R598 VSS.n607 VSS.n8 76.985
R599 VSS.n611 VSS.n7 76.985
R600 VSS.n668 VSS.n667 76.985
R601 VSS.n269 VSS.n200 76.985
R602 VSS.n246 VSS.n245 76.985
R603 VSS.n247 VSS.n206 76.985
R604 VSS.n249 VSS.n248 76.985
R605 VSS.n250 VSS.n211 76.985
R606 VSS.n252 VSS.n251 76.985
R607 VSS.n253 VSS.n216 76.985
R608 VSS.n255 VSS.n254 76.985
R609 VSS.n256 VSS.n221 76.985
R610 VSS.n258 VSS.n257 76.985
R611 VSS.n259 VSS.n226 76.985
R612 VSS.n261 VSS.n260 76.985
R613 VSS.n262 VSS.n231 76.985
R614 VSS.n264 VSS.n263 76.985
R615 VSS.n265 VSS.n236 76.985
R616 VSS.n267 VSS.n266 76.985
R617 VSS.n268 VSS.n241 76.985
R618 VSS.n271 VSS.n244 76.985
R619 VSS.n667 VSS.n5 76.985
R620 VSS.n608 VSS.n7 76.985
R621 VSS.n606 VSS.n8 76.985
R622 VSS.n602 VSS.n9 76.985
R623 VSS.n600 VSS.n10 76.985
R624 VSS.n596 VSS.n11 76.985
R625 VSS.n594 VSS.n12 76.985
R626 VSS.n590 VSS.n13 76.985
R627 VSS.n588 VSS.n14 76.985
R628 VSS.n584 VSS.n15 76.985
R629 VSS.n582 VSS.n16 76.985
R630 VSS.n578 VSS.n17 76.985
R631 VSS.n576 VSS.n18 76.985
R632 VSS.n572 VSS.n19 76.985
R633 VSS.n570 VSS.n20 76.985
R634 VSS.n566 VSS.n21 76.985
R635 VSS.n564 VSS.n22 76.985
R636 VSS.n25 VSS.n23 76.985
R637 VSS.n269 VSS.n201 76.985
R638 VSS.n246 VSS.n205 76.985
R639 VSS.n247 VSS.n207 76.985
R640 VSS.n249 VSS.n210 76.985
R641 VSS.n250 VSS.n212 76.985
R642 VSS.n252 VSS.n215 76.985
R643 VSS.n253 VSS.n217 76.985
R644 VSS.n255 VSS.n220 76.985
R645 VSS.n256 VSS.n222 76.985
R646 VSS.n258 VSS.n225 76.985
R647 VSS.n259 VSS.n227 76.985
R648 VSS.n261 VSS.n230 76.985
R649 VSS.n262 VSS.n232 76.985
R650 VSS.n264 VSS.n235 76.985
R651 VSS.n265 VSS.n237 76.985
R652 VSS.n267 VSS.n240 76.985
R653 VSS.n268 VSS.n242 76.985
R654 VSS.n272 VSS.n271 76.985
R655 VSS.n196 VSS.t15 72.3779
R656 VSS.t1 VSS.n31 72.3779
R657 VSS.n366 VSS.t14 69.6467
R658 VSS.n522 VSS.t2 69.6467
R659 VSS.n137 VSS.n132 50.6672
R660 VSS.n477 VSS.n472 50.6672
R661 VSS.n349 VSS.t13 50.5281
R662 VSS.n432 VSS.t7 50.5281
R663 VSS.n440 VSS.t6 50.5281
R664 VSS.t0 VSS.n37 50.5281
R665 VSS.t13 VSS.n178 47.7969
R666 VSS.n423 VSS.t7 47.7969
R667 VSS.n449 VSS.t6 47.7969
R668 VSS.n539 VSS.t0 47.7969
R669 VSS.n327 VSS.n198 30.7205
R670 VSS.n664 VSS.n26 30.7205
R671 VSS.n670 VSS.n669 30.7205
R672 VSS.n273 VSS.n193 30.7205
R673 VSS.n357 VSS.t14 28.6783
R674 VSS.n531 VSS.t2 28.6783
R675 VSS.n341 VSS.t15 25.9471
R676 VSS.n38 VSS.t1 25.9471
R677 VSS.n144 VSS.n131 17.8167
R678 VSS.n484 VSS.n471 17.8167
R679 VSS.n145 VSS.n144 15.8839
R680 VSS.n485 VSS.n484 15.8839
R681 VSS.n135 VSS.n133 13.1884
R682 VSS.n475 VSS.n473 13.1884
R683 VSS.n136 VSS.n135 13.1662
R684 VSS.n138 VSS.n136 13.1662
R685 VSS.n139 VSS.n134 13.1662
R686 VSS.n143 VSS.n142 13.1662
R687 VSS.n476 VSS.n475 13.1662
R688 VSS.n478 VSS.n476 13.1662
R689 VSS.n479 VSS.n474 13.1662
R690 VSS.n483 VSS.n482 13.1662
R691 VSS.t9 VSS.n121 12.291
R692 VSS.n465 VSS.t3 12.291
R693 VSS.n331 VSS.n198 11.5205
R694 VSS.n331 VSS.n188 11.5205
R695 VSS.n343 VSS.n188 11.5205
R696 VSS.n343 VSS.n186 11.5205
R697 VSS.n347 VSS.n186 11.5205
R698 VSS.n347 VSS.n176 11.5205
R699 VSS.n360 VSS.n176 11.5205
R700 VSS.n360 VSS.n174 11.5205
R701 VSS.n364 VSS.n174 11.5205
R702 VSS.n364 VSS.n165 11.5205
R703 VSS.n376 VSS.n165 11.5205
R704 VSS.n376 VSS.n163 11.5205
R705 VSS.n380 VSS.n163 11.5205
R706 VSS.n380 VSS.n153 11.5205
R707 VSS.n392 VSS.n153 11.5205
R708 VSS.n392 VSS.n151 11.5205
R709 VSS.n396 VSS.n151 11.5205
R710 VSS.n396 VSS.n125 11.5205
R711 VSS.n409 VSS.n125 11.5205
R712 VSS.n409 VSS.n123 11.5205
R713 VSS.n413 VSS.n123 11.5205
R714 VSS.n413 VSS.n113 11.5205
R715 VSS.n426 VSS.n113 11.5205
R716 VSS.n426 VSS.n111 11.5205
R717 VSS.n430 VSS.n111 11.5205
R718 VSS.n430 VSS.n102 11.5205
R719 VSS.n443 VSS.n102 11.5205
R720 VSS.n443 VSS.n100 11.5205
R721 VSS.n447 VSS.n100 11.5205
R722 VSS.n447 VSS.n91 11.5205
R723 VSS.n459 VSS.n91 11.5205
R724 VSS.n459 VSS.n89 11.5205
R725 VSS.n463 VSS.n89 11.5205
R726 VSS.n463 VSS.n79 11.5205
R727 VSS.n492 VSS.n79 11.5205
R728 VSS.n492 VSS.n77 11.5205
R729 VSS.n496 VSS.n77 11.5205
R730 VSS.n496 VSS.n67 11.5205
R731 VSS.n508 VSS.n67 11.5205
R732 VSS.n508 VSS.n65 11.5205
R733 VSS.n512 VSS.n65 11.5205
R734 VSS.n512 VSS.n55 11.5205
R735 VSS.n525 VSS.n55 11.5205
R736 VSS.n525 VSS.n53 11.5205
R737 VSS.n529 VSS.n53 11.5205
R738 VSS.n529 VSS.n44 11.5205
R739 VSS.n541 VSS.n44 11.5205
R740 VSS.n541 VSS.n41 11.5205
R741 VSS.n546 VSS.n41 11.5205
R742 VSS.n546 VSS.n42 11.5205
R743 VSS.n42 VSS.n29 11.5205
R744 VSS.n559 VSS.n29 11.5205
R745 VSS.n559 VSS.n26 11.5205
R746 VSS.n664 VSS.n27 11.5205
R747 VSS.n660 VSS.n27 11.5205
R748 VSS.n660 VSS.n659 11.5205
R749 VSS.n659 VSS.n658 11.5205
R750 VSS.n658 VSS.n567 11.5205
R751 VSS.n654 VSS.n567 11.5205
R752 VSS.n654 VSS.n653 11.5205
R753 VSS.n653 VSS.n652 11.5205
R754 VSS.n652 VSS.n573 11.5205
R755 VSS.n648 VSS.n573 11.5205
R756 VSS.n648 VSS.n647 11.5205
R757 VSS.n647 VSS.n646 11.5205
R758 VSS.n646 VSS.n579 11.5205
R759 VSS.n642 VSS.n579 11.5205
R760 VSS.n642 VSS.n641 11.5205
R761 VSS.n641 VSS.n640 11.5205
R762 VSS.n640 VSS.n585 11.5205
R763 VSS.n636 VSS.n585 11.5205
R764 VSS.n636 VSS.n635 11.5205
R765 VSS.n635 VSS.n634 11.5205
R766 VSS.n634 VSS.n591 11.5205
R767 VSS.n630 VSS.n591 11.5205
R768 VSS.n630 VSS.n629 11.5205
R769 VSS.n629 VSS.n628 11.5205
R770 VSS.n628 VSS.n597 11.5205
R771 VSS.n624 VSS.n597 11.5205
R772 VSS.n624 VSS.n623 11.5205
R773 VSS.n623 VSS.n622 11.5205
R774 VSS.n622 VSS.n603 11.5205
R775 VSS.n618 VSS.n603 11.5205
R776 VSS.n618 VSS.n617 11.5205
R777 VSS.n617 VSS.n616 11.5205
R778 VSS.n616 VSS.n609 11.5205
R779 VSS.n612 VSS.n609 11.5205
R780 VSS.n612 VSS.n4 11.5205
R781 VSS.n669 VSS.n4 11.5205
R782 VSS.n335 VSS.n193 11.5205
R783 VSS.n335 VSS.n191 11.5205
R784 VSS.n339 VSS.n191 11.5205
R785 VSS.n339 VSS.n182 11.5205
R786 VSS.n351 VSS.n182 11.5205
R787 VSS.n351 VSS.n180 11.5205
R788 VSS.n355 VSS.n180 11.5205
R789 VSS.n355 VSS.n171 11.5205
R790 VSS.n368 VSS.n171 11.5205
R791 VSS.n368 VSS.n169 11.5205
R792 VSS.n372 VSS.n169 11.5205
R793 VSS.n372 VSS.n159 11.5205
R794 VSS.n384 VSS.n159 11.5205
R795 VSS.n384 VSS.n157 11.5205
R796 VSS.n388 VSS.n157 11.5205
R797 VSS.n388 VSS.n147 11.5205
R798 VSS.n400 VSS.n147 11.5205
R799 VSS.n400 VSS.n129 11.5205
R800 VSS.n405 VSS.n129 11.5205
R801 VSS.n405 VSS.n119 11.5205
R802 VSS.n417 VSS.n119 11.5205
R803 VSS.n417 VSS.n117 11.5205
R804 VSS.n421 VSS.n117 11.5205
R805 VSS.n421 VSS.n108 11.5205
R806 VSS.n434 VSS.n108 11.5205
R807 VSS.n434 VSS.n106 11.5205
R808 VSS.n438 VSS.n106 11.5205
R809 VSS.n438 VSS.n97 11.5205
R810 VSS.n451 VSS.n97 11.5205
R811 VSS.n451 VSS.n95 11.5205
R812 VSS.n455 VSS.n95 11.5205
R813 VSS.n455 VSS.n85 11.5205
R814 VSS.n467 VSS.n85 11.5205
R815 VSS.n467 VSS.n83 11.5205
R816 VSS.n488 VSS.n83 11.5205
R817 VSS.n488 VSS.n73 11.5205
R818 VSS.n500 VSS.n73 11.5205
R819 VSS.n500 VSS.n71 11.5205
R820 VSS.n504 VSS.n71 11.5205
R821 VSS.n504 VSS.n61 11.5205
R822 VSS.n516 VSS.n61 11.5205
R823 VSS.n516 VSS.n59 11.5205
R824 VSS.n520 VSS.n59 11.5205
R825 VSS.n520 VSS.n50 11.5205
R826 VSS.n533 VSS.n50 11.5205
R827 VSS.n533 VSS.n48 11.5205
R828 VSS.n537 VSS.n48 11.5205
R829 VSS.n537 VSS.n35 11.5205
R830 VSS.n550 VSS.n35 11.5205
R831 VSS.n550 VSS.n33 11.5205
R832 VSS.n554 VSS.n33 11.5205
R833 VSS.n554 VSS.n2 11.5205
R834 VSS.n670 VSS.n2 11.5205
R835 VSS.n327 VSS.n326 11.5205
R836 VSS.n326 VSS.n325 11.5205
R837 VSS.n325 VSS.n203 11.5205
R838 VSS.n321 VSS.n203 11.5205
R839 VSS.n321 VSS.n320 11.5205
R840 VSS.n320 VSS.n319 11.5205
R841 VSS.n319 VSS.n208 11.5205
R842 VSS.n315 VSS.n208 11.5205
R843 VSS.n315 VSS.n314 11.5205
R844 VSS.n314 VSS.n313 11.5205
R845 VSS.n313 VSS.n213 11.5205
R846 VSS.n309 VSS.n213 11.5205
R847 VSS.n309 VSS.n308 11.5205
R848 VSS.n308 VSS.n307 11.5205
R849 VSS.n307 VSS.n218 11.5205
R850 VSS.n303 VSS.n218 11.5205
R851 VSS.n303 VSS.n302 11.5205
R852 VSS.n302 VSS.n301 11.5205
R853 VSS.n301 VSS.n223 11.5205
R854 VSS.n297 VSS.n223 11.5205
R855 VSS.n297 VSS.n296 11.5205
R856 VSS.n296 VSS.n295 11.5205
R857 VSS.n295 VSS.n228 11.5205
R858 VSS.n291 VSS.n228 11.5205
R859 VSS.n291 VSS.n290 11.5205
R860 VSS.n290 VSS.n289 11.5205
R861 VSS.n289 VSS.n233 11.5205
R862 VSS.n285 VSS.n233 11.5205
R863 VSS.n285 VSS.n284 11.5205
R864 VSS.n284 VSS.n283 11.5205
R865 VSS.n283 VSS.n238 11.5205
R866 VSS.n279 VSS.n238 11.5205
R867 VSS.n279 VSS.n278 11.5205
R868 VSS.n278 VSS.n277 11.5205
R869 VSS.n277 VSS.n243 11.5205
R870 VSS.n273 VSS.n243 11.5205
R871 VSS.n398 VSS.t10 9.55978
R872 VSS.t4 VSS.n75 9.55978
R873 VSS.n143 VSS.n130 9.3005
R874 VSS.n142 VSS.n141 9.3005
R875 VSS.n142 VSS.n131 9.3005
R876 VSS.n140 VSS.n139 9.3005
R877 VSS.n139 VSS.n138 9.3005
R878 VSS.n136 VSS.n134 9.3005
R879 VSS.n483 VSS.n470 9.3005
R880 VSS.n482 VSS.n481 9.3005
R881 VSS.n482 VSS.n471 9.3005
R882 VSS.n480 VSS.n479 9.3005
R883 VSS.n479 VSS.n478 9.3005
R884 VSS.n476 VSS.n474 9.3005
R885 VSS.n328 VSS.n327 9.3005
R886 VSS.n326 VSS.n199 9.3005
R887 VSS.n325 VSS.n324 9.3005
R888 VSS.n323 VSS.n203 9.3005
R889 VSS.n322 VSS.n321 9.3005
R890 VSS.n320 VSS.n204 9.3005
R891 VSS.n319 VSS.n318 9.3005
R892 VSS.n317 VSS.n208 9.3005
R893 VSS.n316 VSS.n315 9.3005
R894 VSS.n314 VSS.n209 9.3005
R895 VSS.n313 VSS.n312 9.3005
R896 VSS.n311 VSS.n213 9.3005
R897 VSS.n310 VSS.n309 9.3005
R898 VSS.n308 VSS.n214 9.3005
R899 VSS.n307 VSS.n306 9.3005
R900 VSS.n305 VSS.n218 9.3005
R901 VSS.n304 VSS.n303 9.3005
R902 VSS.n302 VSS.n219 9.3005
R903 VSS.n301 VSS.n300 9.3005
R904 VSS.n299 VSS.n223 9.3005
R905 VSS.n298 VSS.n297 9.3005
R906 VSS.n296 VSS.n224 9.3005
R907 VSS.n295 VSS.n294 9.3005
R908 VSS.n293 VSS.n228 9.3005
R909 VSS.n292 VSS.n291 9.3005
R910 VSS.n290 VSS.n229 9.3005
R911 VSS.n289 VSS.n288 9.3005
R912 VSS.n287 VSS.n233 9.3005
R913 VSS.n286 VSS.n285 9.3005
R914 VSS.n284 VSS.n234 9.3005
R915 VSS.n283 VSS.n282 9.3005
R916 VSS.n281 VSS.n238 9.3005
R917 VSS.n280 VSS.n279 9.3005
R918 VSS.n278 VSS.n239 9.3005
R919 VSS.n277 VSS.n276 9.3005
R920 VSS.n275 VSS.n243 9.3005
R921 VSS.n274 VSS.n273 9.3005
R922 VSS.n329 VSS.n198 9.3005
R923 VSS.n331 VSS.n330 9.3005
R924 VSS.n188 VSS.n187 9.3005
R925 VSS.n344 VSS.n343 9.3005
R926 VSS.n345 VSS.n186 9.3005
R927 VSS.n347 VSS.n346 9.3005
R928 VSS.n176 VSS.n175 9.3005
R929 VSS.n361 VSS.n360 9.3005
R930 VSS.n362 VSS.n174 9.3005
R931 VSS.n364 VSS.n363 9.3005
R932 VSS.n165 VSS.n164 9.3005
R933 VSS.n377 VSS.n376 9.3005
R934 VSS.n378 VSS.n163 9.3005
R935 VSS.n380 VSS.n379 9.3005
R936 VSS.n153 VSS.n152 9.3005
R937 VSS.n393 VSS.n392 9.3005
R938 VSS.n394 VSS.n151 9.3005
R939 VSS.n396 VSS.n395 9.3005
R940 VSS.n125 VSS.n124 9.3005
R941 VSS.n410 VSS.n409 9.3005
R942 VSS.n411 VSS.n123 9.3005
R943 VSS.n413 VSS.n412 9.3005
R944 VSS.n113 VSS.n112 9.3005
R945 VSS.n427 VSS.n426 9.3005
R946 VSS.n428 VSS.n111 9.3005
R947 VSS.n430 VSS.n429 9.3005
R948 VSS.n102 VSS.n101 9.3005
R949 VSS.n444 VSS.n443 9.3005
R950 VSS.n445 VSS.n100 9.3005
R951 VSS.n447 VSS.n446 9.3005
R952 VSS.n91 VSS.n90 9.3005
R953 VSS.n460 VSS.n459 9.3005
R954 VSS.n461 VSS.n89 9.3005
R955 VSS.n463 VSS.n462 9.3005
R956 VSS.n79 VSS.n78 9.3005
R957 VSS.n493 VSS.n492 9.3005
R958 VSS.n494 VSS.n77 9.3005
R959 VSS.n496 VSS.n495 9.3005
R960 VSS.n67 VSS.n66 9.3005
R961 VSS.n509 VSS.n508 9.3005
R962 VSS.n510 VSS.n65 9.3005
R963 VSS.n512 VSS.n511 9.3005
R964 VSS.n55 VSS.n54 9.3005
R965 VSS.n526 VSS.n525 9.3005
R966 VSS.n527 VSS.n53 9.3005
R967 VSS.n529 VSS.n528 9.3005
R968 VSS.n44 VSS.n43 9.3005
R969 VSS.n542 VSS.n541 9.3005
R970 VSS.n543 VSS.n41 9.3005
R971 VSS.n546 VSS.n545 9.3005
R972 VSS.n544 VSS.n42 9.3005
R973 VSS.n29 VSS.n28 9.3005
R974 VSS.n560 VSS.n559 9.3005
R975 VSS.n561 VSS.n26 9.3005
R976 VSS.n669 VSS.n0 9.3005
R977 VSS.n610 VSS.n4 9.3005
R978 VSS.n613 VSS.n612 9.3005
R979 VSS.n614 VSS.n609 9.3005
R980 VSS.n616 VSS.n615 9.3005
R981 VSS.n617 VSS.n604 9.3005
R982 VSS.n619 VSS.n618 9.3005
R983 VSS.n620 VSS.n603 9.3005
R984 VSS.n622 VSS.n621 9.3005
R985 VSS.n623 VSS.n598 9.3005
R986 VSS.n625 VSS.n624 9.3005
R987 VSS.n626 VSS.n597 9.3005
R988 VSS.n628 VSS.n627 9.3005
R989 VSS.n629 VSS.n592 9.3005
R990 VSS.n631 VSS.n630 9.3005
R991 VSS.n632 VSS.n591 9.3005
R992 VSS.n634 VSS.n633 9.3005
R993 VSS.n635 VSS.n586 9.3005
R994 VSS.n637 VSS.n636 9.3005
R995 VSS.n638 VSS.n585 9.3005
R996 VSS.n640 VSS.n639 9.3005
R997 VSS.n641 VSS.n580 9.3005
R998 VSS.n643 VSS.n642 9.3005
R999 VSS.n644 VSS.n579 9.3005
R1000 VSS.n646 VSS.n645 9.3005
R1001 VSS.n647 VSS.n574 9.3005
R1002 VSS.n649 VSS.n648 9.3005
R1003 VSS.n650 VSS.n573 9.3005
R1004 VSS.n652 VSS.n651 9.3005
R1005 VSS.n653 VSS.n568 9.3005
R1006 VSS.n655 VSS.n654 9.3005
R1007 VSS.n656 VSS.n567 9.3005
R1008 VSS.n658 VSS.n657 9.3005
R1009 VSS.n659 VSS.n562 9.3005
R1010 VSS.n661 VSS.n660 9.3005
R1011 VSS.n662 VSS.n27 9.3005
R1012 VSS.n664 VSS.n663 9.3005
R1013 VSS.n671 VSS.n670 9.3005
R1014 VSS.n2 VSS.n1 9.3005
R1015 VSS.n554 VSS.n553 9.3005
R1016 VSS.n552 VSS.n33 9.3005
R1017 VSS.n551 VSS.n550 9.3005
R1018 VSS.n35 VSS.n34 9.3005
R1019 VSS.n537 VSS.n536 9.3005
R1020 VSS.n535 VSS.n48 9.3005
R1021 VSS.n534 VSS.n533 9.3005
R1022 VSS.n50 VSS.n49 9.3005
R1023 VSS.n520 VSS.n519 9.3005
R1024 VSS.n518 VSS.n59 9.3005
R1025 VSS.n517 VSS.n516 9.3005
R1026 VSS.n61 VSS.n60 9.3005
R1027 VSS.n504 VSS.n503 9.3005
R1028 VSS.n502 VSS.n71 9.3005
R1029 VSS.n501 VSS.n500 9.3005
R1030 VSS.n73 VSS.n72 9.3005
R1031 VSS.n488 VSS.n487 9.3005
R1032 VSS.n469 VSS.n83 9.3005
R1033 VSS.n468 VSS.n467 9.3005
R1034 VSS.n85 VSS.n84 9.3005
R1035 VSS.n455 VSS.n454 9.3005
R1036 VSS.n453 VSS.n95 9.3005
R1037 VSS.n452 VSS.n451 9.3005
R1038 VSS.n97 VSS.n96 9.3005
R1039 VSS.n438 VSS.n437 9.3005
R1040 VSS.n436 VSS.n106 9.3005
R1041 VSS.n435 VSS.n434 9.3005
R1042 VSS.n108 VSS.n107 9.3005
R1043 VSS.n421 VSS.n420 9.3005
R1044 VSS.n419 VSS.n117 9.3005
R1045 VSS.n418 VSS.n417 9.3005
R1046 VSS.n119 VSS.n118 9.3005
R1047 VSS.n405 VSS.n404 9.3005
R1048 VSS.n403 VSS.n129 9.3005
R1049 VSS.n401 VSS.n400 9.3005
R1050 VSS.n147 VSS.n146 9.3005
R1051 VSS.n388 VSS.n387 9.3005
R1052 VSS.n386 VSS.n157 9.3005
R1053 VSS.n385 VSS.n384 9.3005
R1054 VSS.n159 VSS.n158 9.3005
R1055 VSS.n372 VSS.n371 9.3005
R1056 VSS.n370 VSS.n169 9.3005
R1057 VSS.n369 VSS.n368 9.3005
R1058 VSS.n171 VSS.n170 9.3005
R1059 VSS.n355 VSS.n354 9.3005
R1060 VSS.n353 VSS.n180 9.3005
R1061 VSS.n352 VSS.n351 9.3005
R1062 VSS.n182 VSS.n181 9.3005
R1063 VSS.n339 VSS.n338 9.3005
R1064 VSS.n337 VSS.n191 9.3005
R1065 VSS.n336 VSS.n335 9.3005
R1066 VSS.n193 VSS.n192 9.3005
R1067 VSS.n135 VSS.t11 7.13193
R1068 VSS.n475 VSS.t5 7.13193
R1069 VSS.n374 VSS.t12 6.82856
R1070 VSS.t8 VSS.n57 6.82856
R1071 VSS.n137 VSS.n131 6.76621
R1072 VSS.n142 VSS.n132 6.76621
R1073 VSS.n477 VSS.n471 6.76621
R1074 VSS.n482 VSS.n472 6.76621
R1075 VSS.n138 VSS.n137 6.4005
R1076 VSS.n139 VSS.n132 6.4005
R1077 VSS.n478 VSS.n477 6.4005
R1078 VSS.n479 VSS.n472 6.4005
R1079 VSS.n134 VSS.n133 3.8419
R1080 VSS.n474 VSS.n473 3.8419
R1081 VSS.n140 VSS.n133 2.85946
R1082 VSS.n480 VSS.n473 2.85946
R1083 VSS.n144 VSS.n143 2.72607
R1084 VSS.n484 VSS.n483 2.72607
R1085 VSS.n402 VSS.n145 0.745813
R1086 VSS.n486 VSS.n485 0.745813
R1087 VSS.n673 VSS 0.333833
R1088 VSS.n329 VSS.n328 0.3005
R1089 VSS.n663 VSS.n561 0.3005
R1090 VSS.n274 VSS.n192 0.195031
R1091 VSS.n672 VSS.n0 0.159875
R1092 VSS.n141 VSS.n140 0.113
R1093 VSS.n141 VSS.n130 0.113
R1094 VSS.n145 VSS.n130 0.113
R1095 VSS.n481 VSS.n480 0.113
R1096 VSS.n481 VSS.n470 0.113
R1097 VSS.n485 VSS.n470 0.113
R1098 VSS.n328 VSS.n199 0.113
R1099 VSS.n324 VSS.n199 0.113
R1100 VSS.n324 VSS.n323 0.113
R1101 VSS.n323 VSS.n322 0.113
R1102 VSS.n322 VSS.n204 0.113
R1103 VSS.n318 VSS.n204 0.113
R1104 VSS.n318 VSS.n317 0.113
R1105 VSS.n317 VSS.n316 0.113
R1106 VSS.n316 VSS.n209 0.113
R1107 VSS.n312 VSS.n209 0.113
R1108 VSS.n312 VSS.n311 0.113
R1109 VSS.n311 VSS.n310 0.113
R1110 VSS.n310 VSS.n214 0.113
R1111 VSS.n306 VSS.n214 0.113
R1112 VSS.n306 VSS.n305 0.113
R1113 VSS.n305 VSS.n304 0.113
R1114 VSS.n304 VSS.n219 0.113
R1115 VSS.n300 VSS.n219 0.113
R1116 VSS.n300 VSS.n299 0.113
R1117 VSS.n299 VSS.n298 0.113
R1118 VSS.n298 VSS.n224 0.113
R1119 VSS.n294 VSS.n224 0.113
R1120 VSS.n294 VSS.n293 0.113
R1121 VSS.n293 VSS.n292 0.113
R1122 VSS.n292 VSS.n229 0.113
R1123 VSS.n288 VSS.n229 0.113
R1124 VSS.n288 VSS.n287 0.113
R1125 VSS.n287 VSS.n286 0.113
R1126 VSS.n286 VSS.n234 0.113
R1127 VSS.n282 VSS.n234 0.113
R1128 VSS.n282 VSS.n281 0.113
R1129 VSS.n281 VSS.n280 0.113
R1130 VSS.n280 VSS.n239 0.113
R1131 VSS.n276 VSS.n239 0.113
R1132 VSS.n276 VSS.n275 0.113
R1133 VSS.n275 VSS.n274 0.113
R1134 VSS.n330 VSS.n329 0.113
R1135 VSS.n330 VSS.n187 0.113
R1136 VSS.n344 VSS.n187 0.113
R1137 VSS.n345 VSS.n344 0.113
R1138 VSS.n346 VSS.n345 0.113
R1139 VSS.n346 VSS.n175 0.113
R1140 VSS.n361 VSS.n175 0.113
R1141 VSS.n362 VSS.n361 0.113
R1142 VSS.n363 VSS.n362 0.113
R1143 VSS.n363 VSS.n164 0.113
R1144 VSS.n377 VSS.n164 0.113
R1145 VSS.n378 VSS.n377 0.113
R1146 VSS.n379 VSS.n378 0.113
R1147 VSS.n379 VSS.n152 0.113
R1148 VSS.n393 VSS.n152 0.113
R1149 VSS.n394 VSS.n393 0.113
R1150 VSS.n395 VSS.n394 0.113
R1151 VSS.n395 VSS.n124 0.113
R1152 VSS.n410 VSS.n124 0.113
R1153 VSS.n411 VSS.n410 0.113
R1154 VSS.n412 VSS.n411 0.113
R1155 VSS.n412 VSS.n112 0.113
R1156 VSS.n427 VSS.n112 0.113
R1157 VSS.n428 VSS.n427 0.113
R1158 VSS.n429 VSS.n428 0.113
R1159 VSS.n429 VSS.n101 0.113
R1160 VSS.n444 VSS.n101 0.113
R1161 VSS.n445 VSS.n444 0.113
R1162 VSS.n446 VSS.n445 0.113
R1163 VSS.n446 VSS.n90 0.113
R1164 VSS.n460 VSS.n90 0.113
R1165 VSS.n461 VSS.n460 0.113
R1166 VSS.n462 VSS.n461 0.113
R1167 VSS.n462 VSS.n78 0.113
R1168 VSS.n493 VSS.n78 0.113
R1169 VSS.n494 VSS.n493 0.113
R1170 VSS.n495 VSS.n494 0.113
R1171 VSS.n495 VSS.n66 0.113
R1172 VSS.n509 VSS.n66 0.113
R1173 VSS.n510 VSS.n509 0.113
R1174 VSS.n511 VSS.n510 0.113
R1175 VSS.n511 VSS.n54 0.113
R1176 VSS.n526 VSS.n54 0.113
R1177 VSS.n527 VSS.n526 0.113
R1178 VSS.n528 VSS.n527 0.113
R1179 VSS.n528 VSS.n43 0.113
R1180 VSS.n542 VSS.n43 0.113
R1181 VSS.n543 VSS.n542 0.113
R1182 VSS.n545 VSS.n543 0.113
R1183 VSS.n545 VSS.n544 0.113
R1184 VSS.n544 VSS.n28 0.113
R1185 VSS.n560 VSS.n28 0.113
R1186 VSS.n561 VSS.n560 0.113
R1187 VSS.n663 VSS.n662 0.113
R1188 VSS.n662 VSS.n661 0.113
R1189 VSS.n661 VSS.n562 0.113
R1190 VSS.n657 VSS.n562 0.113
R1191 VSS.n657 VSS.n656 0.113
R1192 VSS.n656 VSS.n655 0.113
R1193 VSS.n655 VSS.n568 0.113
R1194 VSS.n651 VSS.n568 0.113
R1195 VSS.n651 VSS.n650 0.113
R1196 VSS.n650 VSS.n649 0.113
R1197 VSS.n649 VSS.n574 0.113
R1198 VSS.n645 VSS.n574 0.113
R1199 VSS.n645 VSS.n644 0.113
R1200 VSS.n644 VSS.n643 0.113
R1201 VSS.n643 VSS.n580 0.113
R1202 VSS.n639 VSS.n580 0.113
R1203 VSS.n639 VSS.n638 0.113
R1204 VSS.n638 VSS.n637 0.113
R1205 VSS.n637 VSS.n586 0.113
R1206 VSS.n633 VSS.n586 0.113
R1207 VSS.n633 VSS.n632 0.113
R1208 VSS.n632 VSS.n631 0.113
R1209 VSS.n631 VSS.n592 0.113
R1210 VSS.n627 VSS.n592 0.113
R1211 VSS.n627 VSS.n626 0.113
R1212 VSS.n626 VSS.n625 0.113
R1213 VSS.n625 VSS.n598 0.113
R1214 VSS.n621 VSS.n598 0.113
R1215 VSS.n621 VSS.n620 0.113
R1216 VSS.n620 VSS.n619 0.113
R1217 VSS.n619 VSS.n604 0.113
R1218 VSS.n615 VSS.n604 0.113
R1219 VSS.n615 VSS.n614 0.113
R1220 VSS.n614 VSS.n613 0.113
R1221 VSS.n613 VSS.n610 0.113
R1222 VSS.n610 VSS.n0 0.113
R1223 VSS.n672 VSS.n671 0.0356562
R1224 VSS.n336 VSS.n192 0.028625
R1225 VSS.n337 VSS.n336 0.028625
R1226 VSS.n338 VSS.n337 0.028625
R1227 VSS.n338 VSS.n181 0.028625
R1228 VSS.n352 VSS.n181 0.028625
R1229 VSS.n353 VSS.n352 0.028625
R1230 VSS.n354 VSS.n353 0.028625
R1231 VSS.n354 VSS.n170 0.028625
R1232 VSS.n369 VSS.n170 0.028625
R1233 VSS.n370 VSS.n369 0.028625
R1234 VSS.n371 VSS.n370 0.028625
R1235 VSS.n371 VSS.n158 0.028625
R1236 VSS.n385 VSS.n158 0.028625
R1237 VSS.n386 VSS.n385 0.028625
R1238 VSS.n387 VSS.n386 0.028625
R1239 VSS.n387 VSS.n146 0.028625
R1240 VSS.n401 VSS.n146 0.028625
R1241 VSS.n404 VSS.n403 0.028625
R1242 VSS.n404 VSS.n118 0.028625
R1243 VSS.n418 VSS.n118 0.028625
R1244 VSS.n419 VSS.n418 0.028625
R1245 VSS.n420 VSS.n419 0.028625
R1246 VSS.n420 VSS.n107 0.028625
R1247 VSS.n435 VSS.n107 0.028625
R1248 VSS.n436 VSS.n435 0.028625
R1249 VSS.n437 VSS.n436 0.028625
R1250 VSS.n437 VSS.n96 0.028625
R1251 VSS.n452 VSS.n96 0.028625
R1252 VSS.n453 VSS.n452 0.028625
R1253 VSS.n454 VSS.n453 0.028625
R1254 VSS.n454 VSS.n84 0.028625
R1255 VSS.n468 VSS.n84 0.028625
R1256 VSS.n469 VSS.n468 0.028625
R1257 VSS.n487 VSS.n469 0.028625
R1258 VSS.n501 VSS.n72 0.028625
R1259 VSS.n502 VSS.n501 0.028625
R1260 VSS.n503 VSS.n502 0.028625
R1261 VSS.n503 VSS.n60 0.028625
R1262 VSS.n517 VSS.n60 0.028625
R1263 VSS.n518 VSS.n517 0.028625
R1264 VSS.n519 VSS.n518 0.028625
R1265 VSS.n519 VSS.n49 0.028625
R1266 VSS.n534 VSS.n49 0.028625
R1267 VSS.n535 VSS.n534 0.028625
R1268 VSS.n536 VSS.n535 0.028625
R1269 VSS.n536 VSS.n34 0.028625
R1270 VSS.n551 VSS.n34 0.028625
R1271 VSS.n552 VSS.n551 0.028625
R1272 VSS.n553 VSS.n552 0.028625
R1273 VSS.n553 VSS.n1 0.028625
R1274 VSS.n671 VSS.n1 0.028625
R1275 VSS.n403 VSS.n402 0.0258906
R1276 VSS.n487 VSS.n486 0.0258906
R1277 VSS VSS.n673 0.0180781
R1278 VSS.n673 VSS.n672 0.016125
R1279 VSS.n402 VSS.n401 0.00323437
R1280 VSS.n486 VSS.n72 0.00323437
C0 a_3159_2520# gn 0.01648f
C1 vb a_2525_2072# 0
C2 inn vb 0.0231f
C3 a_3159_2520# inn 0.23832f
C4 inp sp 0.00597f
C5 sp sn 0.02715f
C6 out sp 0.12177f
C7 a_1371_2072# vb 0
C8 gp sp 0.10741f
C9 sp gn 0.00452f
C10 a_3359_760# vb 0.27686f
C11 out inp 0.00115f
C12 out sn 0.12524f
C13 a_3159_2520# a_3359_760# 0.00386f
C14 inp a_737_2520# 0.23832f
C15 a_537_760# vb 0.27686f
C16 gp inp 1.80296f
C17 gp sn 0.00452f
C18 gn sn 0.10741f
C19 inp a_337_2520# 0.19105f
C20 out gp 0.06286f
C21 out gn 0.06401f
C22 gp a_737_2520# 0.01648f
C23 inp a_2525_2072# 0.00164f
C24 sn a_2525_2072# 0.00573f
C25 a_737_2520# gn 0.00326f
C26 inp inn 0.00614f
C27 a_737_2520# a_337_2520# 0.25114f
C28 inn sn 0.00597f
C29 a_3559_2520# gn 0.00355f
C30 a_1371_2072# sp 0.00573f
C31 gp gn 1.26112f
C32 gp a_337_2520# 0.00355f
C33 out inn 0.00115f
C34 inn a_737_2520# 0.0013f
C35 gp a_2525_2072# 0.00496f
C36 a_3559_2520# inn 0.19105f
C37 gn a_2525_2072# 0.00905f
C38 inn gn 1.80296f
C39 sp vb 0.02148f
C40 a_1371_2072# inp 0.25855f
C41 inn a_2525_2072# 0.25855f
C42 gp a_1371_2072# 0.00905f
C43 out a_3359_760# 0.00317f
C44 a_1371_2072# gn 0.00496f
C45 inp vb 0.0231f
C46 inp a_537_760# 0.03363f
C47 vb sn 0.02148f
C48 a_3559_2520# a_3359_760# 0.00386f
C49 a_3159_2520# inp 0.0013f
C50 out vb 1.90355f
C51 out a_537_760# 0.00317f
C52 a_1371_2072# a_2525_2072# 0.04448f
C53 a_3359_760# gn 0.27995f
C54 a_1371_2072# inn 0.00164f
C55 a_537_760# a_737_2520# 0.00386f
C56 a_3559_2520# vb 0.00386f
C57 gp vb 0.05814f
C58 gp a_537_760# 0.27995f
C59 gn vb 0.05814f
C60 a_337_2520# vb 0.00386f
C61 a_537_760# a_337_2520# 0.00386f
C62 a_3159_2520# a_3559_2520# 0.25114f
C63 gp a_3159_2520# 0.00326f
C64 a_3359_760# inn 0.03363f
C65 inn VSS 2.20098f
C66 inp VSS 2.20098f
C67 out VSS 3.709f
C68 vb VSS 2.60419f
C69 a_3559_2520# VSS 0.69343f
C70 a_3359_760# VSS 0.48369f
C71 sn VSS 0.70104f
C72 gn VSS 1.8366f
C73 a_2525_2072# VSS 0.80433f
C74 sp VSS 0.70433f
C75 a_1371_2072# VSS 0.80411f
C76 gp VSS 1.83721f
C77 a_3159_2520# VSS 0.68759f
C78 a_737_2520# VSS 0.68759f
C79 a_537_760# VSS 0.48369f
C80 a_337_2520# VSS 0.69609f
C81 vb.n0 VSS 0.02709f
C82 vb.n1 VSS 0.02673f
C83 vb.n2 VSS 0.01185f
C84 vb.n3 VSS 0.01965f
C85 vb.n4 VSS 0.0237f
C86 vb.t1 VSS 0.00642f
C87 vb.n5 VSS 0.02564f
C88 vb.n6 VSS 0.0237f
C89 vb.n7 VSS 0.01185f
C90 vb.n8 VSS 0.01761f
C91 vb.n9 VSS 0.01761f
C92 vb.n10 VSS 0.07669f
C93 vb.n11 VSS 0.02709f
C94 vb.n12 VSS 0.01794f
C95 vb.n13 VSS 0.0237f
C96 vb.n14 VSS 0.04719f
C97 vb.n15 VSS 0.13675f
C98 vb.n16 VSS 0.69869f
C99 vb.n17 VSS 0.02709f
C100 vb.n18 VSS 0.02673f
C101 vb.n19 VSS 0.01185f
C102 vb.n20 VSS 0.01965f
C103 vb.n21 VSS 0.0237f
C104 vb.t0 VSS 0.00642f
C105 vb.n22 VSS 0.02564f
C106 vb.n23 VSS 0.0237f
C107 vb.n24 VSS 0.01185f
C108 vb.n25 VSS 0.01761f
C109 vb.n26 VSS 0.01761f
C110 vb.n27 VSS 0.07669f
C111 vb.n28 VSS 0.02709f
C112 vb.n29 VSS 0.01794f
C113 vb.n30 VSS 0.0237f
C114 vb.n31 VSS 0.04719f
C115 vb.n32 VSS 0.13675f
C116 vb.n33 VSS 0.7298f
C117 out.t1 VSS 0.05425f
C118 out.n0 VSS 0.64573f
C119 out.t0 VSS 0.05425f
C120 out.n1 VSS 0.6799f
C121 inp.t0 VSS 1.92328f
C122 inn.t0 VSS 1.92328f
.ends
