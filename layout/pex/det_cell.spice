* det_cell: magic R+C extraction of layout/det_cell.gds (layout/pex.sh)
.subckt det_cell inp inn vb out VSS
X0 a_2585_2072# sn VSS.t8 sky130_fd_pr__res_high_po_0p35 l=4.54
X1 a_337_2520# vb VSS.t1 sky130_fd_pr__res_xhigh_po_0p35 l=6.78
X2 a_737_2520# a_537_760# VSS.t2 sky130_fd_pr__res_xhigh_po_0p35 l=6.78
X3 a_1311_2072# sp VSS.t3 sky130_fd_pr__res_high_po_0p35 l=4.54
X4 a_3159_2520# a_3359_760# VSS.t12 sky130_fd_pr__res_xhigh_po_0p35 l=6.78
X5 out gp sp VSS.t5 sky130_fd_pr__nfet_01v8 ad=0.3 pd=2.6 as=0.3 ps=2.6 w=1 l=0.15
X6 a_3559_2520# vb VSS.t13 sky130_fd_pr__res_xhigh_po_0p35 l=6.78
X7 sn gn out VSS.t6 sky130_fd_pr__nfet_01v8 ad=0.3 pd=2.6 as=0.3 ps=2.6 w=1 l=0.15
X8 a_2585_2072# VSS VSS.t9 sky130_fd_pr__res_high_po_0p35 l=4.54
X9 gn inn sky130_fd_pr__cap_mim_m3_1 l=6.965 w=6.965
X10 a_337_2520# a_537_760# VSS.t0 sky130_fd_pr__res_xhigh_po_0p35 l=6.78
X11 a_737_2520# gp VSS.t7 sky130_fd_pr__res_xhigh_po_0p35 l=6.78
X12 a_1311_2072# VSS VSS.t4 sky130_fd_pr__res_high_po_0p35 l=4.54
X13 a_3159_2520# gn VSS.t10 sky130_fd_pr__res_xhigh_po_0p35 l=6.78
X14 a_3559_2520# a_3359_760# VSS.t11 sky130_fd_pr__res_xhigh_po_0p35 l=6.78
X15 gp inp sky130_fd_pr__cap_mim_m3_1 l=6.965 w=6.965
R0 VSS.n314 VSS.n313 585
R1 VSS.n286 VSS.n285 585
R2 VSS.n311 VSS.n284 585
R3 VSS.n315 VSS.n284 585
R4 VSS.n316 VSS.n283 585
R5 VSS.n317 VSS.n282 585
R6 VSS.n295 VSS.n281 585
R7 VSS.n318 VSS.n280 585
R8 VSS.n319 VSS.n279 585
R9 VSS.n320 VSS.n278 585
R10 VSS.n292 VSS.n277 585
R11 VSS.n321 VSS.n276 585
R12 VSS.n322 VSS.n275 585
R13 VSS.n323 VSS.n274 585
R14 VSS.n298 VSS.n273 585
R15 VSS.n324 VSS.n272 585
R16 VSS.n325 VSS.n271 585
R17 VSS.n326 VSS.n270 585
R18 VSS.n311 VSS.n289 585
R19 VSS.n289 VSS.n269 585
R20 VSS.n327 VSS.n268 585
R21 VSS.n328 VSS.n267 585
R22 VSS.n329 VSS.n266 585
R23 VSS.n301 VSS.n265 585
R24 VSS.n330 VSS.n264 585
R25 VSS.n331 VSS.n263 585
R26 VSS.n332 VSS.n262 585
R27 VSS.n303 VSS.n261 585
R28 VSS.n333 VSS.n260 585
R29 VSS.n334 VSS.n259 585
R30 VSS.n335 VSS.n258 585
R31 VSS.n306 VSS.n257 585
R32 VSS.n336 VSS.n256 585
R33 VSS.n337 VSS.n255 585
R34 VSS.n338 VSS.n254 585
R35 VSS.n308 VSS.n253 585
R36 VSS.n311 VSS.n252 585
R37 VSS.n339 VSS.n252 585
R38 VSS.n340 VSS.n251 585
R39 VSS.n341 VSS.n250 585
R40 VSS.n246 VSS.n245 585
R41 VSS.n245 VSS.n244 585
R42 VSS.n345 VSS.n344 585
R43 VSS.n346 VSS.n345 585
R44 VSS.n247 VSS.n242 585
R45 VSS.n243 VSS.n242 585
R46 VSS.n349 VSS.n348 585
R47 VSS.n348 VSS.n347 585
R48 VSS.n237 VSS.n236 585
R49 VSS.n236 VSS.n235 585
R50 VSS.n355 VSS.n354 585
R51 VSS.n356 VSS.n355 585
R52 VSS.n233 VSS.n232 585
R53 VSS.n234 VSS.n233 585
R54 VSS.n360 VSS.n358 585
R55 VSS.n358 VSS.n357 585
R56 VSS.n359 VSS.n227 585
R57 VSS.n227 VSS.n226 585
R58 VSS.n366 VSS.n365 585
R59 VSS.n367 VSS.n366 585
R60 VSS.n224 VSS.n223 585
R61 VSS.n225 VSS.n224 585
R62 VSS.n370 VSS.n369 585
R63 VSS.n369 VSS.n368 585
R64 VSS.n218 VSS.n217 585
R65 VSS.n217 VSS.n216 585
R66 VSS.n376 VSS.n375 585
R67 VSS.n377 VSS.n376 585
R68 VSS.n214 VSS.n213 585
R69 VSS.n215 VSS.n214 585
R70 VSS.n381 VSS.n379 585
R71 VSS.n379 VSS.n378 585
R72 VSS.n380 VSS.n208 585
R73 VSS.n208 VSS.n207 585
R74 VSS.n387 VSS.n386 585
R75 VSS.n388 VSS.n387 585
R76 VSS.n206 VSS.n205 585
R77 VSS.n89 VSS.n206 585
R78 VSS.n391 VSS.n390 585
R79 VSS.n390 VSS.n389 585
R80 VSS.n200 VSS.n199 585
R81 VSS.n199 VSS.n198 585
R82 VSS.n397 VSS.n396 585
R83 VSS.n398 VSS.n397 585
R84 VSS.n196 VSS.n195 585
R85 VSS.n197 VSS.n196 585
R86 VSS.n402 VSS.n400 585
R87 VSS.n400 VSS.n399 585
R88 VSS.n401 VSS.n190 585
R89 VSS.n190 VSS.n189 585
R90 VSS.n408 VSS.n407 585
R91 VSS.n409 VSS.n408 585
R92 VSS.n187 VSS.n186 585
R93 VSS.n188 VSS.n187 585
R94 VSS.n413 VSS.n411 585
R95 VSS.n411 VSS.n410 585
R96 VSS.n412 VSS.n181 585
R97 VSS.n181 VSS.n180 585
R98 VSS.n419 VSS.n418 585
R99 VSS.n420 VSS.n419 585
R100 VSS.n178 VSS.n177 585
R101 VSS.n179 VSS.n178 585
R102 VSS.n423 VSS.n422 585
R103 VSS.n422 VSS.n421 585
R104 VSS.n172 VSS.n171 585
R105 VSS.n171 VSS.n170 585
R106 VSS.n429 VSS.n428 585
R107 VSS.n430 VSS.n429 585
R108 VSS.n168 VSS.n167 585
R109 VSS.n169 VSS.n168 585
R110 VSS.n434 VSS.n432 585
R111 VSS.n432 VSS.n431 585
R112 VSS.n433 VSS.n162 585
R113 VSS.n162 VSS.n161 585
R114 VSS.n440 VSS.n439 585
R115 VSS.n441 VSS.n440 585
R116 VSS.n160 VSS.n159 585
R117 VSS.n80 VSS.n160 585
R118 VSS.n444 VSS.n443 585
R119 VSS.n443 VSS.n442 585
R120 VSS.n154 VSS.n153 585
R121 VSS.n153 VSS.n152 585
R122 VSS.n450 VSS.n449 585
R123 VSS.n451 VSS.n450 585
R124 VSS.n150 VSS.n149 585
R125 VSS.n151 VSS.n150 585
R126 VSS.n455 VSS.n453 585
R127 VSS.n453 VSS.n452 585
R128 VSS.n454 VSS.n144 585
R129 VSS.n144 VSS.n143 585
R130 VSS.n461 VSS.n460 585
R131 VSS.n462 VSS.n461 585
R132 VSS.n141 VSS.n140 585
R133 VSS.n142 VSS.n141 585
R134 VSS.n465 VSS.n464 585
R135 VSS.n464 VSS.n463 585
R136 VSS.n132 VSS.n131 585
R137 VSS.n131 VSS.n130 585
R138 VSS.n471 VSS.n470 585
R139 VSS.n472 VSS.n471 585
R140 VSS.n133 VSS.n128 585
R141 VSS.n129 VSS.n128 585
R142 VSS.n474 VSS.n127 585
R143 VSS.n474 VSS.n473 585
R144 VSS.n476 VSS.n475 585
R145 VSS.n475 VSS.n100 585
R146 VSS.n104 VSS.n101 585
R147 VSS.n551 VSS.n101 585
R148 VSS.n547 VSS.n546 585
R149 VSS.n546 VSS.n545 585
R150 VSS.n124 VSS.n123 585
R151 VSS.n544 VSS.n479 585
R152 VSS.n543 VSS.n480 585
R153 VSS.n542 VSS.n481 585
R154 VSS.n483 VSS.n482 585
R155 VSS.n541 VSS.n484 585
R156 VSS.n540 VSS.n485 585
R157 VSS.n539 VSS.n486 585
R158 VSS.n488 VSS.n487 585
R159 VSS.n538 VSS.n489 585
R160 VSS.n537 VSS.n490 585
R161 VSS.n536 VSS.n491 585
R162 VSS.n493 VSS.n492 585
R163 VSS.n535 VSS.n494 585
R164 VSS.n534 VSS.n495 585
R165 VSS.n533 VSS.n496 585
R166 VSS.n498 VSS.n497 585
R167 VSS.n532 VSS.n499 585
R168 VSS.n531 VSS.n500 585
R169 VSS.n530 VSS.n501 585
R170 VSS.n503 VSS.n502 585
R171 VSS.n529 VSS.n504 585
R172 VSS.n528 VSS.n505 585
R173 VSS.n527 VSS.n506 585
R174 VSS.n508 VSS.n507 585
R175 VSS.n526 VSS.n509 585
R176 VSS.n525 VSS.n510 585
R177 VSS.n524 VSS.n511 585
R178 VSS.n513 VSS.n512 585
R179 VSS.n523 VSS.n514 585
R180 VSS.n522 VSS.n515 585
R181 VSS.n521 VSS.n516 585
R182 VSS.n518 VSS.n517 585
R183 VSS.n520 VSS.n519 585
R184 VSS.n103 VSS.n102 585
R185 VSS.n550 VSS.n549 585
R186 VSS.n122 VSS.n104 585
R187 VSS.n27 VSS.n122 585
R188 VSS.n477 VSS.n476 585
R189 VSS.n478 VSS.n477 585
R190 VSS.n127 VSS.n126 585
R191 VSS.n126 VSS.n125 585
R192 VSS.n135 VSS.n133 585
R193 VSS.n137 VSS.n135 585
R194 VSS.n470 VSS.n469 585
R195 VSS.n469 VSS.n468 585
R196 VSS.n134 VSS.n132 585
R197 VSS.n136 VSS.n134 585
R198 VSS.n466 VSS.n465 585
R199 VSS.n467 VSS.n466 585
R200 VSS.n140 VSS.n139 585
R201 VSS.n139 VSS.n138 585
R202 VSS.n460 VSS.n459 585
R203 VSS.n459 VSS.n458 585
R204 VSS.n454 VSS.n145 585
R205 VSS.n146 VSS.n145 585
R206 VSS.n456 VSS.n455 585
R207 VSS.n457 VSS.n456 585
R208 VSS.n149 VSS.n148 585
R209 VSS.n148 VSS.n147 585
R210 VSS.n449 VSS.n448 585
R211 VSS.n448 VSS.n447 585
R212 VSS.n155 VSS.n154 585
R213 VSS.n156 VSS.n155 585
R214 VSS.n445 VSS.n444 585
R215 VSS.n446 VSS.n445 585
R216 VSS.n159 VSS.n158 585
R217 VSS.n158 VSS.n157 585
R218 VSS.n439 VSS.n438 585
R219 VSS.n438 VSS.n437 585
R220 VSS.n433 VSS.n163 585
R221 VSS.n164 VSS.n163 585
R222 VSS.n435 VSS.n434 585
R223 VSS.n436 VSS.n435 585
R224 VSS.n167 VSS.n166 585
R225 VSS.n166 VSS.n165 585
R226 VSS.n428 VSS.n427 585
R227 VSS.n427 VSS.n426 585
R228 VSS.n173 VSS.n172 585
R229 VSS.n174 VSS.n173 585
R230 VSS.n424 VSS.n423 585
R231 VSS.n425 VSS.n424 585
R232 VSS.n177 VSS.n176 585
R233 VSS.n176 VSS.n175 585
R234 VSS.n418 VSS.n417 585
R235 VSS.n417 VSS.n416 585
R236 VSS.n412 VSS.n182 585
R237 VSS.n183 VSS.n182 585
R238 VSS.n414 VSS.n413 585
R239 VSS.n415 VSS.n414 585
R240 VSS.n186 VSS.n185 585
R241 VSS.n185 VSS.n184 585
R242 VSS.n407 VSS.n406 585
R243 VSS.n406 VSS.n405 585
R244 VSS.n401 VSS.n191 585
R245 VSS.n192 VSS.n191 585
R246 VSS.n403 VSS.n402 585
R247 VSS.n404 VSS.n403 585
R248 VSS.n195 VSS.n194 585
R249 VSS.n194 VSS.n193 585
R250 VSS.n396 VSS.n395 585
R251 VSS.n395 VSS.n394 585
R252 VSS.n201 VSS.n200 585
R253 VSS.n202 VSS.n201 585
R254 VSS.n392 VSS.n391 585
R255 VSS.n393 VSS.n392 585
R256 VSS.n205 VSS.n204 585
R257 VSS.n204 VSS.n203 585
R258 VSS.n386 VSS.n385 585
R259 VSS.n385 VSS.n384 585
R260 VSS.n380 VSS.n209 585
R261 VSS.n210 VSS.n209 585
R262 VSS.n382 VSS.n381 585
R263 VSS.n383 VSS.n382 585
R264 VSS.n213 VSS.n212 585
R265 VSS.n212 VSS.n211 585
R266 VSS.n375 VSS.n374 585
R267 VSS.n374 VSS.n373 585
R268 VSS.n219 VSS.n218 585
R269 VSS.n220 VSS.n219 585
R270 VSS.n371 VSS.n370 585
R271 VSS.n372 VSS.n371 585
R272 VSS.n223 VSS.n222 585
R273 VSS.n222 VSS.n221 585
R274 VSS.n365 VSS.n364 585
R275 VSS.n364 VSS.n363 585
R276 VSS.n359 VSS.n228 585
R277 VSS.n229 VSS.n228 585
R278 VSS.n361 VSS.n360 585
R279 VSS.n362 VSS.n361 585
R280 VSS.n232 VSS.n231 585
R281 VSS.n231 VSS.n230 585
R282 VSS.n354 VSS.n353 585
R283 VSS.n353 VSS.n352 585
R284 VSS.n238 VSS.n237 585
R285 VSS.n239 VSS.n238 585
R286 VSS.n350 VSS.n349 585
R287 VSS.n351 VSS.n350 585
R288 VSS.n247 VSS.n241 585
R289 VSS.n241 VSS.n240 585
R290 VSS.n344 VSS.n343 585
R291 VSS.n343 VSS.n342 585
R292 VSS.n248 VSS.n246 585
R293 VSS.n249 VSS.n248 585
R294 VSS.n250 VSS.n248 472.8
R295 VSS.n313 VSS.n245 472.8
R296 VSS.n549 VSS.n101 472.8
R297 VSS.n546 VSS.n122 472.8
R298 VSS.n312 VSS.n311 254.01
R299 VSS.n311 VSS.n297 254.01
R300 VSS.n311 VSS.n296 254.01
R301 VSS.n311 VSS.n294 254.01
R302 VSS.n311 VSS.n293 254.01
R303 VSS.n311 VSS.n291 254.01
R304 VSS.n311 VSS.n299 254.01
R305 VSS.n311 VSS.n290 254.01
R306 VSS.n311 VSS.n300 254.01
R307 VSS.n311 VSS.n302 254.01
R308 VSS.n311 VSS.n288 254.01
R309 VSS.n311 VSS.n304 254.01
R310 VSS.n311 VSS.n305 254.01
R311 VSS.n311 VSS.n307 254.01
R312 VSS.n311 VSS.n287 254.01
R313 VSS.n311 VSS.n309 254.01
R314 VSS.n311 VSS.n310 254.01
R315 VSS.n547 VSS.n121 254.01
R316 VSS.n547 VSS.n120 254.01
R317 VSS.n547 VSS.n119 254.01
R318 VSS.n547 VSS.n118 254.01
R319 VSS.n547 VSS.n117 254.01
R320 VSS.n547 VSS.n116 254.01
R321 VSS.n547 VSS.n115 254.01
R322 VSS.n547 VSS.n114 254.01
R323 VSS.n547 VSS.n113 254.01
R324 VSS.n547 VSS.n112 254.01
R325 VSS.n547 VSS.n111 254.01
R326 VSS.n547 VSS.n110 254.01
R327 VSS.n547 VSS.n109 254.01
R328 VSS.n547 VSS.n108 254.01
R329 VSS.n547 VSS.n107 254.01
R330 VSS.n547 VSS.n106 254.01
R331 VSS.n547 VSS.n105 254.01
R332 VSS.n548 VSS.n547 254.01
R333 VSS.n477 VSS.n122 177.3
R334 VSS.n477 VSS.n126 177.3
R335 VSS.n135 VSS.n126 177.3
R336 VSS.n469 VSS.n135 177.3
R337 VSS.n469 VSS.n134 177.3
R338 VSS.n466 VSS.n134 177.3
R339 VSS.n466 VSS.n139 177.3
R340 VSS.n459 VSS.n139 177.3
R341 VSS.n459 VSS.n145 177.3
R342 VSS.n456 VSS.n145 177.3
R343 VSS.n456 VSS.n148 177.3
R344 VSS.n448 VSS.n148 177.3
R345 VSS.n448 VSS.n155 177.3
R346 VSS.n445 VSS.n155 177.3
R347 VSS.n445 VSS.n158 177.3
R348 VSS.n438 VSS.n158 177.3
R349 VSS.n438 VSS.n163 177.3
R350 VSS.n435 VSS.n163 177.3
R351 VSS.n435 VSS.n166 177.3
R352 VSS.n427 VSS.n166 177.3
R353 VSS.n427 VSS.n173 177.3
R354 VSS.n424 VSS.n173 177.3
R355 VSS.n424 VSS.n176 177.3
R356 VSS.n417 VSS.n176 177.3
R357 VSS.n417 VSS.n182 177.3
R358 VSS.n414 VSS.n182 177.3
R359 VSS.n414 VSS.n185 177.3
R360 VSS.n406 VSS.n185 177.3
R361 VSS.n406 VSS.n191 177.3
R362 VSS.n403 VSS.n191 177.3
R363 VSS.n403 VSS.n194 177.3
R364 VSS.n395 VSS.n194 177.3
R365 VSS.n395 VSS.n201 177.3
R366 VSS.n392 VSS.n201 177.3
R367 VSS.n392 VSS.n204 177.3
R368 VSS.n385 VSS.n204 177.3
R369 VSS.n385 VSS.n209 177.3
R370 VSS.n382 VSS.n209 177.3
R371 VSS.n382 VSS.n212 177.3
R372 VSS.n374 VSS.n212 177.3
R373 VSS.n374 VSS.n219 177.3
R374 VSS.n371 VSS.n219 177.3
R375 VSS.n371 VSS.n222 177.3
R376 VSS.n364 VSS.n222 177.3
R377 VSS.n364 VSS.n228 177.3
R378 VSS.n361 VSS.n228 177.3
R379 VSS.n361 VSS.n231 177.3
R380 VSS.n353 VSS.n231 177.3
R381 VSS.n353 VSS.n238 177.3
R382 VSS.n350 VSS.n238 177.3
R383 VSS.n350 VSS.n241 177.3
R384 VSS.n343 VSS.n241 177.3
R385 VSS.n343 VSS.n248 177.3
R386 VSS.n286 VSS.n284 177.3
R387 VSS.n284 VSS.n283 177.3
R388 VSS.n295 VSS.n282 177.3
R389 VSS.n280 VSS.n279 177.3
R390 VSS.n292 VSS.n278 177.3
R391 VSS.n276 VSS.n275 177.3
R392 VSS.n298 VSS.n274 177.3
R393 VSS.n272 VSS.n271 177.3
R394 VSS.n289 VSS.n270 177.3
R395 VSS.n289 VSS.n268 177.3
R396 VSS.n267 VSS.n266 177.3
R397 VSS.n301 VSS.n264 177.3
R398 VSS.n263 VSS.n262 177.3
R399 VSS.n303 VSS.n260 177.3
R400 VSS.n259 VSS.n258 177.3
R401 VSS.n306 VSS.n256 177.3
R402 VSS.n255 VSS.n254 177.3
R403 VSS.n308 VSS.n252 177.3
R404 VSS.n252 VSS.n251 177.3
R405 VSS.n475 VSS.n101 177.3
R406 VSS.n475 VSS.n474 177.3
R407 VSS.n474 VSS.n128 177.3
R408 VSS.n471 VSS.n128 177.3
R409 VSS.n471 VSS.n131 177.3
R410 VSS.n464 VSS.n131 177.3
R411 VSS.n464 VSS.n141 177.3
R412 VSS.n461 VSS.n141 177.3
R413 VSS.n461 VSS.n144 177.3
R414 VSS.n453 VSS.n144 177.3
R415 VSS.n453 VSS.n150 177.3
R416 VSS.n450 VSS.n150 177.3
R417 VSS.n450 VSS.n153 177.3
R418 VSS.n443 VSS.n153 177.3
R419 VSS.n443 VSS.n160 177.3
R420 VSS.n440 VSS.n160 177.3
R421 VSS.n440 VSS.n162 177.3
R422 VSS.n432 VSS.n162 177.3
R423 VSS.n432 VSS.n168 177.3
R424 VSS.n429 VSS.n168 177.3
R425 VSS.n429 VSS.n171 177.3
R426 VSS.n422 VSS.n171 177.3
R427 VSS.n422 VSS.n178 177.3
R428 VSS.n419 VSS.n178 177.3
R429 VSS.n419 VSS.n181 177.3
R430 VSS.n411 VSS.n181 177.3
R431 VSS.n411 VSS.n187 177.3
R432 VSS.n408 VSS.n187 177.3
R433 VSS.n408 VSS.n190 177.3
R434 VSS.n400 VSS.n190 177.3
R435 VSS.n400 VSS.n196 177.3
R436 VSS.n397 VSS.n196 177.3
R437 VSS.n397 VSS.n199 177.3
R438 VSS.n390 VSS.n199 177.3
R439 VSS.n390 VSS.n206 177.3
R440 VSS.n387 VSS.n206 177.3
R441 VSS.n387 VSS.n208 177.3
R442 VSS.n379 VSS.n208 177.3
R443 VSS.n379 VSS.n214 177.3
R444 VSS.n376 VSS.n214 177.3
R445 VSS.n376 VSS.n217 177.3
R446 VSS.n369 VSS.n217 177.3
R447 VSS.n369 VSS.n224 177.3
R448 VSS.n366 VSS.n224 177.3
R449 VSS.n366 VSS.n227 177.3
R450 VSS.n358 VSS.n227 177.3
R451 VSS.n358 VSS.n233 177.3
R452 VSS.n355 VSS.n233 177.3
R453 VSS.n355 VSS.n236 177.3
R454 VSS.n348 VSS.n236 177.3
R455 VSS.n348 VSS.n242 177.3
R456 VSS.n345 VSS.n242 177.3
R457 VSS.n345 VSS.n245 177.3
R458 VSS.n519 VSS.n103 177.3
R459 VSS.n517 VSS.n516 177.3
R460 VSS.n515 VSS.n514 177.3
R461 VSS.n512 VSS.n511 177.3
R462 VSS.n510 VSS.n509 177.3
R463 VSS.n507 VSS.n506 177.3
R464 VSS.n505 VSS.n504 177.3
R465 VSS.n502 VSS.n501 177.3
R466 VSS.n500 VSS.n499 177.3
R467 VSS.n497 VSS.n496 177.3
R468 VSS.n495 VSS.n494 177.3
R469 VSS.n492 VSS.n491 177.3
R470 VSS.n490 VSS.n489 177.3
R471 VSS.n487 VSS.n486 177.3
R472 VSS.n485 VSS.n484 177.3
R473 VSS.n482 VSS.n481 177.3
R474 VSS.n480 VSS.n479 177.3
R475 VSS.n546 VSS.n123 177.3
R476 VSS.n547 VSS.n104 122.906
R477 VSS.n311 VSS.n246 122.906
R478 VSS.n476 VSS.n104 98.3245
R479 VSS.n476 VSS.n127 98.3245
R480 VSS.n470 VSS.n133 98.3245
R481 VSS.n470 VSS.n132 98.3245
R482 VSS.n465 VSS.n140 98.3245
R483 VSS.n460 VSS.n140 98.3245
R484 VSS.n455 VSS.n454 98.3245
R485 VSS.n455 VSS.n149 98.3245
R486 VSS.n449 VSS.n154 98.3245
R487 VSS.n444 VSS.n154 98.3245
R488 VSS.n444 VSS.n159 98.3245
R489 VSS.n439 VSS.n159 98.3245
R490 VSS.n434 VSS.n433 98.3245
R491 VSS.n434 VSS.n167 98.3245
R492 VSS.n428 VSS.n172 98.3245
R493 VSS.n423 VSS.n172 98.3245
R494 VSS.n423 VSS.n177 98.3245
R495 VSS.n418 VSS.n177 98.3245
R496 VSS.n413 VSS.n412 98.3245
R497 VSS.n413 VSS.n186 98.3245
R498 VSS.n407 VSS.n186 98.3245
R499 VSS.n402 VSS.n401 98.3245
R500 VSS.n402 VSS.n195 98.3245
R501 VSS.n396 VSS.n195 98.3245
R502 VSS.n396 VSS.n200 98.3245
R503 VSS.n391 VSS.n205 98.3245
R504 VSS.n386 VSS.n205 98.3245
R505 VSS.n381 VSS.n380 98.3245
R506 VSS.n381 VSS.n213 98.3245
R507 VSS.n375 VSS.n213 98.3245
R508 VSS.n375 VSS.n218 98.3245
R509 VSS.n370 VSS.n223 98.3245
R510 VSS.n365 VSS.n223 98.3245
R511 VSS.n360 VSS.n359 98.3245
R512 VSS.n360 VSS.n232 98.3245
R513 VSS.n354 VSS.n237 98.3245
R514 VSS.n349 VSS.n237 98.3245
R515 VSS.n344 VSS.n247 98.3245
R516 VSS.n344 VSS.n246 98.3245
R517 VSS.n428 VSS.t3 94.2277
R518 VSS.t8 VSS.n200 94.2277
R519 VSS.n449 VSS.t7 91.4965
R520 VSS.t10 VSS.n218 91.4965
R521 VSS.n312 VSS.n286 76.985
R522 VSS.n297 VSS.n282 76.985
R523 VSS.n296 VSS.n280 76.985
R524 VSS.n294 VSS.n278 76.985
R525 VSS.n293 VSS.n276 76.985
R526 VSS.n291 VSS.n274 76.985
R527 VSS.n299 VSS.n298 76.985
R528 VSS.n290 VSS.n270 76.985
R529 VSS.n300 VSS.n267 76.985
R530 VSS.n302 VSS.n301 76.985
R531 VSS.n288 VSS.n264 76.985
R532 VSS.n304 VSS.n303 76.985
R533 VSS.n305 VSS.n259 76.985
R534 VSS.n307 VSS.n306 76.985
R535 VSS.n287 VSS.n256 76.985
R536 VSS.n309 VSS.n308 76.985
R537 VSS.n310 VSS.n251 76.985
R538 VSS.n123 VSS.n121 76.985
R539 VSS.n480 VSS.n120 76.985
R540 VSS.n482 VSS.n119 76.985
R541 VSS.n485 VSS.n118 76.985
R542 VSS.n487 VSS.n117 76.985
R543 VSS.n490 VSS.n116 76.985
R544 VSS.n492 VSS.n115 76.985
R545 VSS.n495 VSS.n114 76.985
R546 VSS.n497 VSS.n113 76.985
R547 VSS.n500 VSS.n112 76.985
R548 VSS.n502 VSS.n111 76.985
R549 VSS.n505 VSS.n110 76.985
R550 VSS.n507 VSS.n109 76.985
R551 VSS.n510 VSS.n108 76.985
R552 VSS.n512 VSS.n107 76.985
R553 VSS.n515 VSS.n106 76.985
R554 VSS.n517 VSS.n105 76.985
R555 VSS.n548 VSS.n103 76.985
R556 VSS.n313 VSS.n312 76.985
R557 VSS.n297 VSS.n283 76.985
R558 VSS.n296 VSS.n295 76.985
R559 VSS.n294 VSS.n279 76.985
R560 VSS.n293 VSS.n292 76.985
R561 VSS.n291 VSS.n275 76.985
R562 VSS.n299 VSS.n272 76.985
R563 VSS.n290 VSS.n271 76.985
R564 VSS.n300 VSS.n268 76.985
R565 VSS.n302 VSS.n266 76.985
R566 VSS.n288 VSS.n263 76.985
R567 VSS.n304 VSS.n262 76.985
R568 VSS.n305 VSS.n260 76.985
R569 VSS.n307 VSS.n258 76.985
R570 VSS.n287 VSS.n255 76.985
R571 VSS.n309 VSS.n254 76.985
R572 VSS.n310 VSS.n250 76.985
R573 VSS.n549 VSS.n548 76.985
R574 VSS.n519 VSS.n105 76.985
R575 VSS.n516 VSS.n106 76.985
R576 VSS.n514 VSS.n107 76.985
R577 VSS.n511 VSS.n108 76.985
R578 VSS.n509 VSS.n109 76.985
R579 VSS.n506 VSS.n110 76.985
R580 VSS.n504 VSS.n111 76.985
R581 VSS.n501 VSS.n112 76.985
R582 VSS.n499 VSS.n113 76.985
R583 VSS.n496 VSS.n114 76.985
R584 VSS.n494 VSS.n115 76.985
R585 VSS.n491 VSS.n116 76.985
R586 VSS.n489 VSS.n117 76.985
R587 VSS.n486 VSS.n118 76.985
R588 VSS.n484 VSS.n119 76.985
R589 VSS.n481 VSS.n120 76.985
R590 VSS.n479 VSS.n121 76.985
R591 VSS.t1 VSS.n127 72.3779
R592 VSS.n433 VSS.t4 72.3779
R593 VSS.n386 VSS.t9 72.3779
R594 VSS.n247 VSS.t13 72.3779
R595 VSS.n454 VSS.t2 69.6467
R596 VSS.n365 VSS.t12 69.6467
R597 VSS.t0 VSS.n132 50.5281
R598 VSS.n412 VSS.t5 50.5281
R599 VSS.n407 VSS.t6 50.5281
R600 VSS.n354 VSS.t11 50.5281
R601 VSS.n465 VSS.t0 47.7969
R602 VSS.n418 VSS.t5 47.7969
R603 VSS.n401 VSS.t6 47.7969
R604 VSS.t11 VSS.n232 47.7969
R605 VSS.n314 VSS.n244 30.7205
R606 VSS.n551 VSS.n550 30.7205
R607 VSS.n545 VSS.n27 30.7205
R608 VSS.n341 VSS.n249 30.7205
R609 VSS.n460 VSS.t2 28.6783
R610 VSS.n359 VSS.t12 28.6783
R611 VSS.n133 VSS.t1 25.9471
R612 VSS.n439 VSS.t4 25.9471
R613 VSS.n380 VSS.t9 25.9471
R614 VSS.n349 VSS.t13 25.9471
R615 VSS.n314 VSS.n285 11.5205
R616 VSS.n315 VSS.n55 3.55797
R617 VSS.n316 VSS.n315 11.5205
R618 VSS.n317 VSS.n56 3.55797
R619 VSS.n317 VSS.n281 11.5205
R620 VSS.n318 VSS.n57 3.55797
R621 VSS.n319 VSS.n318 11.5205
R622 VSS.n320 VSS.n58 3.55797
R623 VSS.n320 VSS.n277 11.5205
R624 VSS.n321 VSS.n59 3.55797
R625 VSS.n322 VSS.n321 11.5205
R626 VSS.n323 VSS.n60 3.55797
R627 VSS.n323 VSS.n273 11.5205
R628 VSS.n324 VSS.n61 3.55797
R629 VSS.n325 VSS.n324 11.5205
R630 VSS.n326 VSS.n62 3.55797
R631 VSS.n326 VSS.n269 11.5205
R632 VSS.n327 VSS.n63 3.55797
R633 VSS.n328 VSS.n327 11.5205
R634 VSS.n329 VSS.n64 3.55797
R635 VSS.n329 VSS.n265 11.5205
R636 VSS.n330 VSS.n65 3.55797
R637 VSS.n331 VSS.n330 11.5205
R638 VSS.n332 VSS.n66 3.55797
R639 VSS.n332 VSS.n261 11.5205
R640 VSS.n333 VSS.n67 3.55797
R641 VSS.n334 VSS.n333 11.5205
R642 VSS.n335 VSS.n68 3.55797
R643 VSS.n335 VSS.n257 11.5205
R644 VSS.n336 VSS.n69 3.55797
R645 VSS.n337 VSS.n336 11.5205
R646 VSS.n338 VSS.n70 3.55797
R647 VSS.n338 VSS.n253 11.5205
R648 VSS.n339 VSS.n71 3.55797
R649 VSS.n340 VSS.n339 11.5205
R650 VSS.n341 VSS.n72 3.55797
R651 VSS.n551 VSS.n100 11.5205
R652 VSS.n473 VSS.n73 3.55797
R653 VSS.n473 VSS.n129 11.5205
R654 VSS.n472 VSS.n74 3.55797
R655 VSS.n472 VSS.n130 11.5205
R656 VSS.n463 VSS.n75 3.55797
R657 VSS.n463 VSS.n142 11.5205
R658 VSS.n462 VSS.n76 3.55797
R659 VSS.n462 VSS.n143 11.5205
R660 VSS.n452 VSS.n77 3.55797
R661 VSS.n452 VSS.n151 11.5205
R662 VSS.n451 VSS.n78 3.55797
R663 VSS.n451 VSS.n152 11.5205
R664 VSS.n442 VSS.n79 3.55797
R665 VSS.n442 VSS.n80 11.5205
R666 VSS.n441 VSS.n80 11.5205
R667 VSS.n441 VSS.n99 3.55797
R668 VSS.n431 VSS.n161 11.5205
R669 VSS.n431 VSS.n169 11.5205
R670 VSS.n430 VSS.n81 3.55797
R671 VSS.n430 VSS.n170 11.5205
R672 VSS.n421 VSS.n82 3.55797
R673 VSS.n421 VSS.n179 11.5205
R674 VSS.n420 VSS.n83 3.55797
R675 VSS.n420 VSS.n180 11.5205
R676 VSS.n410 VSS.n84 3.55797
R677 VSS.n410 VSS.n188 11.5205
R678 VSS.n409 VSS.n85 3.55797
R679 VSS.n409 VSS.n189 11.5205
R680 VSS.n399 VSS.n86 3.55797
R681 VSS.n399 VSS.n197 11.5205
R682 VSS.n398 VSS.n87 3.55797
R683 VSS.n398 VSS.n198 11.5205
R684 VSS.n389 VSS.n88 3.55797
R685 VSS.n389 VSS.n89 11.5205
R686 VSS.n388 VSS.n89 11.5205
R687 VSS.n388 VSS.n98 3.55797
R688 VSS.n378 VSS.n207 11.5205
R689 VSS.n90 VSS.n215 3.55797
R690 VSS.n377 VSS.n215 11.5205
R691 VSS.n91 VSS.n216 3.55797
R692 VSS.n368 VSS.n216 11.5205
R693 VSS.n92 VSS.n225 3.55797
R694 VSS.n367 VSS.n225 11.5205
R695 VSS.n93 VSS.n226 3.55797
R696 VSS.n357 VSS.n226 11.5205
R697 VSS.n94 VSS.n234 3.55797
R698 VSS.n356 VSS.n234 11.5205
R699 VSS.n95 VSS.n235 3.55797
R700 VSS.n347 VSS.n235 11.5205
R701 VSS.n96 VSS.n243 3.55797
R702 VSS.n346 VSS.n243 11.5205
R703 VSS.n97 VSS.n244 3.55797
R704 VSS.n550 VSS.n102 11.5205
R705 VSS.n520 VSS.n9 3.55797
R706 VSS.n520 VSS.n518 11.5205
R707 VSS.n521 VSS.n10 3.55797
R708 VSS.n522 VSS.n521 11.5205
R709 VSS.n523 VSS.n11 3.55797
R710 VSS.n523 VSS.n513 11.5205
R711 VSS.n524 VSS.n12 3.55797
R712 VSS.n525 VSS.n524 11.5205
R713 VSS.n526 VSS.n13 3.55797
R714 VSS.n526 VSS.n508 11.5205
R715 VSS.n527 VSS.n14 3.55797
R716 VSS.n528 VSS.n527 11.5205
R717 VSS.n529 VSS.n15 3.55797
R718 VSS.n529 VSS.n503 11.5205
R719 VSS.n530 VSS.n16 3.55797
R720 VSS.n531 VSS.n530 11.5205
R721 VSS.n532 VSS.n17 3.55797
R722 VSS.n532 VSS.n498 11.5205
R723 VSS.n533 VSS.n18 3.55797
R724 VSS.n534 VSS.n533 11.5205
R725 VSS.n535 VSS.n19 3.55797
R726 VSS.n535 VSS.n493 11.5205
R727 VSS.n536 VSS.n20 3.55797
R728 VSS.n537 VSS.n536 11.5205
R729 VSS.n538 VSS.n21 3.55797
R730 VSS.n538 VSS.n488 11.5205
R731 VSS.n539 VSS.n22 3.55797
R732 VSS.n540 VSS.n539 11.5205
R733 VSS.n541 VSS.n23 3.55797
R734 VSS.n541 VSS.n483 11.5205
R735 VSS.n542 VSS.n24 3.55797
R736 VSS.n543 VSS.n542 11.5205
R737 VSS.n544 VSS.n25 3.55797
R738 VSS.n544 VSS.n124 11.5205
R739 VSS.n545 VSS.n26 3.55797
R740 VSS.n28 VSS.n27 3.55797
R741 VSS.n478 VSS.n125 11.5205
R742 VSS.n137 VSS.n29 3.55797
R743 VSS.n468 VSS.n137 11.5205
R744 VSS.n30 VSS.n136 3.55797
R745 VSS.n467 VSS.n136 11.5205
R746 VSS.n31 VSS.n138 3.55797
R747 VSS.n458 VSS.n138 11.5205
R748 VSS.n32 VSS.n146 3.55797
R749 VSS.n457 VSS.n146 11.5205
R750 VSS.n33 VSS.n147 3.55797
R751 VSS.n447 VSS.n147 11.5205
R752 VSS.n34 VSS.n156 3.55797
R753 VSS.n446 VSS.n156 11.5205
R754 VSS.n35 VSS.n157 3.55797
R755 VSS.n437 VSS.n157 11.5205
R756 VSS.n36 VSS.n164 3.55797
R757 VSS.n436 VSS.n164 11.5205
R758 VSS.n37 VSS.n165 3.55797
R759 VSS.n426 VSS.n165 11.5205
R760 VSS.n38 VSS.n174 3.55797
R761 VSS.n425 VSS.n174 11.5205
R762 VSS.n39 VSS.n175 3.55797
R763 VSS.n416 VSS.n175 11.5205
R764 VSS.n40 VSS.n183 3.55797
R765 VSS.n415 VSS.n183 11.5205
R766 VSS.n41 VSS.n184 3.55797
R767 VSS.n405 VSS.n184 11.5205
R768 VSS.n42 VSS.n192 3.55797
R769 VSS.n404 VSS.n192 11.5205
R770 VSS.n43 VSS.n193 3.55797
R771 VSS.n394 VSS.n193 11.5205
R772 VSS.n44 VSS.n202 3.55797
R773 VSS.n393 VSS.n202 11.5205
R774 VSS.n45 VSS.n203 3.55797
R775 VSS.n384 VSS.n203 11.5205
R776 VSS.n46 VSS.n210 3.55797
R777 VSS.n383 VSS.n210 11.5205
R778 VSS.n47 VSS.n211 3.55797
R779 VSS.n373 VSS.n211 11.5205
R780 VSS.n48 VSS.n220 3.55797
R781 VSS.n372 VSS.n220 11.5205
R782 VSS.n49 VSS.n221 3.55797
R783 VSS.n363 VSS.n221 11.5205
R784 VSS.n50 VSS.n229 3.55797
R785 VSS.n362 VSS.n229 11.5205
R786 VSS.n51 VSS.n230 3.55797
R787 VSS.n352 VSS.n230 11.5205
R788 VSS.n52 VSS.n239 3.55797
R789 VSS.n351 VSS.n239 11.5205
R790 VSS.n53 VSS.n240 3.55797
R791 VSS.n342 VSS.n240 11.5205
R792 VSS.n54 VSS.n249 3.55797
R793 VSS.n97 VSS.n7 2.87251
R794 VSS.n97 VSS.n346 3.55797
R795 VSS.n7 VSS.n96 2.87251
R796 VSS.n347 VSS.n96 3.55797
R797 VSS.n95 VSS.n7 2.87251
R798 VSS.n95 VSS.n356 3.55797
R799 VSS.n7 VSS.n94 2.87251
R800 VSS.n357 VSS.n94 3.55797
R801 VSS.n93 VSS.n7 2.87251
R802 VSS.n93 VSS.n367 3.55797
R803 VSS.n7 VSS.n92 2.87251
R804 VSS.n368 VSS.n92 3.55797
R805 VSS.n91 VSS 2.87251
R806 VSS.n91 VSS.n377 3.55797
R807 VSS VSS.n90 2.87251
R808 VSS.n378 VSS.n90 3.55797
R809 VSS.n98 VSS.n207 3.55797
R810 VSS VSS.n98 2.87251
R811 VSS VSS.n89 9.3005
R812 VSS.n88 VSS 2.87251
R813 VSS.n198 VSS.n88 3.55797
R814 VSS VSS.n87 2.87251
R815 VSS.n87 VSS.n197 3.55797
R816 VSS.n86 VSS 2.87251
R817 VSS.n189 VSS.n86 3.55797
R818 VSS VSS.n85 2.87251
R819 VSS.n85 VSS.n188 3.55797
R820 VSS.n84 VSS 2.87251
R821 VSS.n180 VSS.n84 3.55797
R822 VSS VSS.n83 2.87251
R823 VSS.n83 VSS.n179 3.55797
R824 VSS.n82 VSS 2.87251
R825 VSS.n170 VSS.n82 3.55797
R826 VSS VSS.n81 2.87251
R827 VSS.n81 VSS.n169 3.55797
R828 VSS.n431 VSS 9.3005
R829 VSS.n99 VSS.n161 3.55797
R830 VSS VSS.n99 2.87251
R831 VSS VSS.n80 9.3005
R832 VSS.n79 VSS 2.87251
R833 VSS.n152 VSS.n79 3.55797
R834 VSS VSS.n78 2.87251
R835 VSS.n78 VSS.n151 3.55797
R836 VSS.n77 VSS 2.87251
R837 VSS.n143 VSS.n77 3.55797
R838 VSS VSS.n76 2.87251
R839 VSS.n76 VSS.n142 3.55797
R840 VSS.n75 VSS 2.87251
R841 VSS.n130 VSS.n75 3.55797
R842 VSS VSS.n74 2.87251
R843 VSS.n74 VSS.n129 3.55797
R844 VSS.n73 VSS 2.87251
R845 VSS.n100 VSS.n73 3.55797
R846 VSS VSS.n551 9.3005
R847 VSS.n26 VSS.n8 2.87251
R848 VSS.n26 VSS.n124 3.55797
R849 VSS.n8 VSS.n25 2.87251
R850 VSS.n543 VSS.n25 3.55797
R851 VSS.n24 VSS.n8 2.87251
R852 VSS.n24 VSS.n483 3.55797
R853 VSS.n8 VSS.n23 2.87251
R854 VSS.n540 VSS.n23 3.55797
R855 VSS.n22 VSS.n5 2.87251
R856 VSS.n22 VSS.n488 3.55797
R857 VSS.n5 VSS.n21 2.87251
R858 VSS.n537 VSS.n21 3.55797
R859 VSS.n20 VSS.n5 2.87251
R860 VSS.n20 VSS.n493 3.55797
R861 VSS.n5 VSS.n19 2.87251
R862 VSS.n534 VSS.n19 3.55797
R863 VSS.n18 VSS.n6 2.87251
R864 VSS.n18 VSS.n498 3.55797
R865 VSS.n6 VSS.n17 2.87251
R866 VSS.n531 VSS.n17 3.55797
R867 VSS.n16 VSS.n6 2.87251
R868 VSS.n16 VSS.n503 3.55797
R869 VSS.n6 VSS.n15 2.87251
R870 VSS.n528 VSS.n15 3.55797
R871 VSS.n14 VSS.n6 2.87251
R872 VSS.n14 VSS.n508 3.55797
R873 VSS.n6 VSS.n13 2.87251
R874 VSS.n525 VSS.n13 3.55797
R875 VSS.n12 VSS.n6 2.87251
R876 VSS.n12 VSS.n513 3.55797
R877 VSS.n6 VSS.n11 2.87251
R878 VSS.n522 VSS.n11 3.55797
R879 VSS.n10 VSS 2.87251
R880 VSS.n10 VSS.n518 3.55797
R881 VSS VSS.n9 2.87251
R882 VSS.n9 VSS.n102 3.55797
R883 VSS.n550 VSS 9.3005
R884 VSS.n8 VSS.n28 2.87251
R885 VSS.n28 VSS.n478 3.55797
R886 VSS.n125 VSS.n29 3.55797
R887 VSS.n8 VSS.n29 2.87251
R888 VSS.n468 VSS.n30 3.55797
R889 VSS.n8 VSS.n30 2.87251
R890 VSS.n31 VSS.n467 3.55797
R891 VSS.n31 VSS.n4 2.87251
R892 VSS.n458 VSS.n32 3.55797
R893 VSS.n4 VSS.n32 2.87251
R894 VSS.n33 VSS.n457 3.55797
R895 VSS.n33 VSS.n4 2.87251
R896 VSS.n447 VSS.n34 3.55797
R897 VSS.n4 VSS.n34 2.87251
R898 VSS.n35 VSS.n446 3.55797
R899 VSS.n35 VSS.n4 2.87251
R900 VSS.n437 VSS.n36 3.55797
R901 VSS.n4 VSS.n36 2.87251
R902 VSS.n37 VSS.n436 3.55797
R903 VSS.n37 VSS.n4 2.87251
R904 VSS.n426 VSS.n38 3.55797
R905 VSS.n4 VSS.n38 2.87251
R906 VSS.n39 VSS.n425 3.55797
R907 VSS.n39 VSS.n3 2.87251
R908 VSS.n416 VSS.n40 3.55797
R909 VSS.n3 VSS.n40 2.87251
R910 VSS.n41 VSS.n415 3.55797
R911 VSS.n41 VSS.n3 2.87251
R912 VSS.n405 VSS.n42 3.55797
R913 VSS.n3 VSS.n42 2.87251
R914 VSS.n43 VSS.n404 3.55797
R915 VSS.n43 VSS.n3 2.87251
R916 VSS.n394 VSS.n44 3.55797
R917 VSS.n3 VSS.n44 2.87251
R918 VSS.n45 VSS.n393 3.55797
R919 VSS.n45 VSS.n3 2.87251
R920 VSS.n384 VSS.n46 3.55797
R921 VSS.n3 VSS.n46 2.87251
R922 VSS.n47 VSS.n383 3.55797
R923 VSS.n47 VSS.n2 2.87251
R924 VSS.n373 VSS.n48 3.55797
R925 VSS.n2 VSS.n48 2.87251
R926 VSS.n49 VSS.n372 3.55797
R927 VSS.n49 VSS.n2 2.87251
R928 VSS.n363 VSS.n50 3.55797
R929 VSS.n2 VSS.n50 2.87251
R930 VSS.n51 VSS.n362 3.55797
R931 VSS.n51 VSS.n0 2.87251
R932 VSS.n352 VSS.n52 3.55797
R933 VSS.n0 VSS.n52 2.87251
R934 VSS.n53 VSS.n351 3.55797
R935 VSS.n53 VSS.n0 2.87251
R936 VSS.n342 VSS.n54 3.55797
R937 VSS.n0 VSS.n54 2.87251
R938 VSS.n7 VSS.n314 9.3005
R939 VSS.n55 VSS.n285 3.55797
R940 VSS.n55 VSS.n7 2.87251
R941 VSS.n316 VSS.n56 3.55797
R942 VSS.n7 VSS.n56 2.87251
R943 VSS.n57 VSS.n281 3.55797
R944 VSS.n57 VSS.n7 2.87251
R945 VSS.n319 VSS.n58 3.55797
R946 VSS.n1 VSS.n58 2.87251
R947 VSS.n59 VSS.n277 3.55797
R948 VSS.n59 VSS.n1 2.87251
R949 VSS.n322 VSS.n60 3.55797
R950 VSS.n1 VSS.n60 2.87251
R951 VSS.n61 VSS.n273 3.55797
R952 VSS.n61 VSS.n1 2.87251
R953 VSS.n325 VSS.n62 3.55797
R954 VSS.n1 VSS.n62 2.87251
R955 VSS.n63 VSS.n269 3.55797
R956 VSS.n63 VSS.n1 2.87251
R957 VSS.n328 VSS.n64 3.55797
R958 VSS.n1 VSS.n64 2.87251
R959 VSS.n65 VSS.n265 3.55797
R960 VSS.n65 VSS.n1 2.87251
R961 VSS.n331 VSS.n66 3.55797
R962 VSS.n0 VSS.n66 2.87251
R963 VSS.n67 VSS.n261 3.55797
R964 VSS.n67 VSS.n0 2.87251
R965 VSS.n334 VSS.n68 3.55797
R966 VSS.n0 VSS.n68 2.87251
R967 VSS.n69 VSS.n257 3.55797
R968 VSS.n69 VSS.n0 2.87251
R969 VSS.n337 VSS.n70 3.55797
R970 VSS.n0 VSS.n70 2.87251
R971 VSS.n71 VSS.n253 3.55797
R972 VSS.n71 VSS.n0 2.87251
R973 VSS.n340 VSS.n72 3.55797
R974 VSS.n0 VSS.n72 2.87251
R975 VSS.t7 VSS.n149 6.82856
R976 VSS.n370 VSS.t10 6.82856
R977 VSS.t3 VSS.n167 4.09733
R978 VSS.n391 VSS.t8 4.09733
R979 VSS.n2 VSS.n0 2.3255
R980 VSS.n6 VSS.n5 1.8005
R981 VSS.n4 VSS.n3 1.8005
R982 VSS.n3 VSS.n2 1.8005
R983 VSS.n1 VSS.n0 1.8005
R984 VSS.n7 VSS.n1 1.71378
R985 VSS.n5 VSS.n8 1.4255
R986 VSS VSS.n6 1.28487
R987 VSS.n8 VSS.n4 1.238
R988 VSS.n7 VSS 1.04112
C0 out gp 0.04959f
C1 sn out 0.06629f
C2 sp a_1311_2072# 0.00288f
C3 a_1311_2072# inn 0.00259f
C4 gn sp 0.00399f
C5 gn inn 1.56795f
C6 a_337_2520# gp 0.00355f
C7 a_3559_2520# gn 0.00355f
C8 a_337_2520# a_737_2520# 0.12642f
C9 vb out 1.02293f
C10 inp gp 1.56795f
C11 inp a_737_2520# 0.23832f
C12 a_3559_2520# inn 0.19105f
C13 vb a_337_2520# 0.00194f
C14 a_3359_760# out 0.00317f
C15 vb inp 0.02303f
C16 a_1311_2072# gp 0.00784f
C17 a_3159_2520# inp 0.0013f
C18 gn gp 0.62284f
C19 gn a_737_2520# 0.00326f
C20 sn gn 0.09364f
C21 gp a_537_760# 0.15159f
C22 a_737_2520# a_537_760# 0.00194f
C23 sp gp 0.09364f
C24 vb a_1311_2072# 0
C25 inn a_737_2520# 0.0013f
C26 sn sp 0.01233f
C27 sn inn 0.00735f
C28 vb gn 0.03787f
C29 vb a_537_760# 0.15214f
C30 gn a_3159_2520# 0.01456f
C31 inp a_2585_2072# 0.00259f
C32 vb sp 0.0242f
C33 vb inn 0.02303f
C34 a_3159_2520# inn 0.23832f
C35 a_3559_2520# vb 0.00194f
C36 a_3359_760# gn 0.15159f
C37 a_3559_2520# a_3159_2520# 0.12642f
C38 a_1311_2072# a_2585_2072# 0.01969f
C39 gn a_2585_2072# 0.00784f
C40 a_3359_760# inn 0.03363f
C41 a_737_2520# gp 0.01456f
C42 sn gp 0.00399f
C43 a_3559_2520# a_3359_760# 0.00194f
C44 inp out 0.00115f
C45 inn a_2585_2072# 0.26679f
C46 vb gp 0.03787f
C47 vb sn 0.0242f
C48 a_337_2520# inp 0.19105f
C49 a_3159_2520# gp 0.00326f
C50 gn out 0.04959f
C51 out a_537_760# 0.00317f
C52 sp out 0.06629f
C53 inn out 0.00115f
C54 a_2585_2072# gp 0.00426f
C55 a_337_2520# a_537_760# 0.00194f
C56 sn a_2585_2072# 0.00288f
C57 a_1311_2072# inp 0.26679f
C58 vb a_3359_760# 0.15214f
C59 inp a_537_760# 0.03363f
C60 a_3359_760# a_3159_2520# 0.00194f
C61 vb a_2585_2072# 0
C62 sp inp 0.00735f
C63 inn inp 0.00307f
C64 gn a_1311_2072# 0.00426f
C65 inn VSS 1.54118f
C66 inp VSS 1.54118f
C67 out VSS 3.91364f
C68 vb VSS 2.22782f
C69 a_3559_2520# VSS 0.59643f
C70 a_3359_760# VSS 0.46749f
C71 sn VSS 1.44759f
C72 a_2585_2072# VSS 0.78338f
C73 sp VSS 1.44759f
C74 a_1311_2072# VSS 0.78315f
C75 a_3159_2520# VSS 0.64971f
C76 a_737_2520# VSS 0.64971f
C77 a_537_760# VSS 0.46749f
C78 a_337_2520# VSS 0.59909f
.ends
