* dbg_tg: magic R+C extraction of layout/dbg_tg.gds (layout/pex.sh)
.subckt dbg_tg a en b VDD VSS
X0 enb en.t1 VSS.t1 VSS.t0 sky130_fd_pr__nfet_01v8 ad=0.15 pd=1.6 as=0.15 ps=1.6 w=0.5 l=0.15
X1 b.t0 en.t0 a.t0 VSS.t2 sky130_fd_pr__nfet_01v8 ad=0.6 pd=4.6 as=0.6 ps=4.6 w=2 l=0.15
X2 b.t1 enb a.t1 VDD.t2 sky130_fd_pr__pfet_01v8 ad=1.2 pd=8.6 as=1.2 ps=8.6 w=4 l=0.15
X3 enb en.t2 VDD.t1 VDD.t0 sky130_fd_pr__pfet_01v8 ad=0.3 pd=2.6 as=0.3 ps=2.6 w=1 l=0.15
R0 b.n0 b.t1 71.289
R1 b.n0 b.t0 53.137
R2 b b.n0 1.10675
R3 en.n1 en.t0 584.894
R4 en.n0 en.t2 421.483
R5 en.n0 en.t1 340.483
R6 en en.n0 3.54962
R7 en en.n1 0.17534
R8 en.n1 en 0.01648
R9 a.n0 a.t1 67.2821
R10 a.n0 a.t0 54.1048
R11 a a.n0 3.4998
R12 VDD.n149 VDD.t1 358.048
R13 VDD.n10 VDD.n9 285
R14 VDD.n120 VDD.n25 285
R15 VDD.n118 VDD.n34 285
R16 VDD.n60 VDD.n57 285
R17 VDD.n70 VDD.n60 185
R18 VDD.n66 VDD.n60 185
R19 VDD.n69 VDD.n68 185
R20 VDD.n61 VDD.n2 185
R21 VDD.n154 VDD.n3 185
R22 VDD.n153 VDD.n4 185
R23 VDD.n152 VDD.n5 185
R24 VDD.n63 VDD.n6 185
R25 VDD.n147 VDD.n8 185
R26 VDD.n146 VDD.n9 185
R27 VDD.n58 VDD.n57 185
R28 VDD.n57 VDD.n55 185
R29 VDD.n75 VDD.n74 185
R30 VDD.n76 VDD.n75 185
R31 VDD.n54 VDD.n53 185
R32 VDD.n77 VDD.n54 185
R33 VDD.n80 VDD.n79 185
R34 VDD.n79 VDD.n78 185
R35 VDD.n51 VDD.n50 185
R36 VDD.n50 VDD.n48 185
R37 VDD.n85 VDD.n84 185
R38 VDD.n86 VDD.n85 185
R39 VDD.n47 VDD.n46 185
R40 VDD.n87 VDD.n47 185
R41 VDD.n90 VDD.n89 185
R42 VDD.n89 VDD.n88 185
R43 VDD.n44 VDD.n43 185
R44 VDD.n43 VDD.n41 185
R45 VDD.n95 VDD.n94 185
R46 VDD.n96 VDD.n95 185
R47 VDD.n40 VDD.n39 185
R48 VDD.n97 VDD.n40 185
R49 VDD.n100 VDD.n99 185
R50 VDD.n99 VDD.n98 185
R51 VDD.n36 VDD.n34 185
R52 VDD.n34 VDD.n30 185
R53 VDD.n120 VDD.n26 185
R54 VDD.n123 VDD.n122 185
R55 VDD.n29 VDD.n28 185
R56 VDD.n108 VDD.n107 185
R57 VDD.n111 VDD.n106 185
R58 VDD.n112 VDD.n105 185
R59 VDD.n113 VDD.n104 185
R60 VDD.n37 VDD.n35 185
R61 VDD.n118 VDD.n117 185
R62 VDD.n119 VDD.n118 185
R63 VDD.n127 VDD.n25 185
R64 VDD.n30 VDD.n25 185
R65 VDD.n128 VDD.n24 185
R66 VDD.n98 VDD.n24 185
R67 VDD.n129 VDD.n23 185
R68 VDD.n97 VDD.n23 185
R69 VDD.n42 VDD.n21 185
R70 VDD.n96 VDD.n42 185
R71 VDD.n133 VDD.n20 185
R72 VDD.n41 VDD.n20 185
R73 VDD.n134 VDD.n19 185
R74 VDD.n88 VDD.n19 185
R75 VDD.n135 VDD.n18 185
R76 VDD.n87 VDD.n18 185
R77 VDD.n49 VDD.n16 185
R78 VDD.n86 VDD.n49 185
R79 VDD.n139 VDD.n15 185
R80 VDD.n48 VDD.n15 185
R81 VDD.n140 VDD.n14 185
R82 VDD.n78 VDD.n14 185
R83 VDD.n141 VDD.n13 185
R84 VDD.n77 VDD.n13 185
R85 VDD.n56 VDD.n11 185
R86 VDD.n76 VDD.n56 185
R87 VDD.n145 VDD.n10 185
R88 VDD.n55 VDD.n10 185
R89 VDD.n66 VDD.n55 137.844
R90 VDD.n119 VDD.n30 137.844
R91 VDD.n56 VDD.n10 108.001
R92 VDD.n56 VDD.n13 108.001
R93 VDD.n14 VDD.n13 108.001
R94 VDD.n15 VDD.n14 108.001
R95 VDD.n49 VDD.n15 108.001
R96 VDD.n49 VDD.n18 108.001
R97 VDD.n19 VDD.n18 108.001
R98 VDD.n20 VDD.n19 108.001
R99 VDD.n42 VDD.n20 108.001
R100 VDD.n42 VDD.n23 108.001
R101 VDD.n24 VDD.n23 108.001
R102 VDD.n25 VDD.n24 108.001
R103 VDD.n118 VDD.n35 108.001
R104 VDD.n105 VDD.n104 108.001
R105 VDD.n107 VDD.n106 108.001
R106 VDD.n122 VDD.n29 108.001
R107 VDD.n75 VDD.n57 108.001
R108 VDD.n75 VDD.n54 108.001
R109 VDD.n79 VDD.n54 108.001
R110 VDD.n79 VDD.n50 108.001
R111 VDD.n85 VDD.n50 108.001
R112 VDD.n85 VDD.n47 108.001
R113 VDD.n89 VDD.n47 108.001
R114 VDD.n89 VDD.n43 108.001
R115 VDD.n95 VDD.n43 108.001
R116 VDD.n95 VDD.n40 108.001
R117 VDD.n99 VDD.n40 108.001
R118 VDD.n99 VDD.n34 108.001
R119 VDD.n68 VDD.n60 108.001
R120 VDD.n61 VDD.n3 108.001
R121 VDD.n5 VDD.n4 108.001
R122 VDD.n63 VDD.n8 108.001
R123 VDD.n67 VDD.n66 71.6014
R124 VDD.n66 VDD.n62 71.6014
R125 VDD.n66 VDD.n64 71.6014
R126 VDD.n66 VDD.n65 71.6014
R127 VDD.n121 VDD.n119 71.6014
R128 VDD.n119 VDD.n31 71.6014
R129 VDD.n119 VDD.n32 71.6014
R130 VDD.n119 VDD.n33 71.6014
R131 VDD.n76 VDD.n55 67.0593
R132 VDD.n77 VDD.n76 67.0593
R133 VDD.n78 VDD.n77 67.0593
R134 VDD.n78 VDD.n48 67.0593
R135 VDD.n86 VDD.n48 67.0593
R136 VDD.n88 VDD.n87 67.0593
R137 VDD.n88 VDD.n41 67.0593
R138 VDD.n96 VDD.n41 67.0593
R139 VDD.n98 VDD.n97 67.0593
R140 VDD.n98 VDD.n30 67.0593
R141 VDD.n87 VDD.t2 42.8436
R142 VDD.n104 VDD.n33 41.8002
R143 VDD.n106 VDD.n32 41.8002
R144 VDD.n31 VDD.n29 41.8002
R145 VDD.n121 VDD.n120 41.8002
R146 VDD.n68 VDD.n67 41.8002
R147 VDD.n62 VDD.n3 41.8002
R148 VDD.n64 VDD.n5 41.8002
R149 VDD.n65 VDD.n8 41.8002
R150 VDD.n67 VDD.n61 41.8002
R151 VDD.n62 VDD.n4 41.8002
R152 VDD.n64 VDD.n63 41.8002
R153 VDD.n65 VDD.n9 41.8002
R154 VDD.n122 VDD.n121 41.8002
R155 VDD.n107 VDD.n31 41.8002
R156 VDD.n105 VDD.n32 41.8002
R157 VDD.n35 VDD.n33 41.8002
R158 VDD.t0 VDD.n96 35.3927
R159 VDD.n97 VDD.t0 31.6672
R160 VDD.n70 VDD.n58 30.4005
R161 VDD.n146 VDD.n145 30.4005
R162 VDD.n117 VDD.n36 30.4005
R163 VDD.n127 VDD.n26 30.4005
R164 VDD.t2 VDD.n86 24.2162
R165 VDD.n70 VDD.n69 11.5205
R166 VDD.n69 VDD.n2 11.5205
R167 VDD.n154 VDD.n2 11.5205
R168 VDD.n154 VDD.n153 11.5205
R169 VDD.n153 VDD.n152 11.5205
R170 VDD.n152 VDD.n6 11.5205
R171 VDD.n147 VDD.n6 11.5205
R172 VDD.n147 VDD.n146 11.5205
R173 VDD.n74 VDD.n58 11.5205
R174 VDD.n74 VDD.n53 11.5205
R175 VDD.n80 VDD.n53 11.5205
R176 VDD.n80 VDD.n51 11.5205
R177 VDD.n84 VDD.n51 11.5205
R178 VDD.n84 VDD.n46 11.5205
R179 VDD.n90 VDD.n46 11.5205
R180 VDD.n90 VDD.n44 11.5205
R181 VDD.n94 VDD.n44 11.5205
R182 VDD.n94 VDD.n39 11.5205
R183 VDD.n100 VDD.n39 11.5205
R184 VDD.n100 VDD.n36 11.5205
R185 VDD.n117 VDD.n37 11.5205
R186 VDD.n113 VDD.n37 11.5205
R187 VDD.n113 VDD.n112 11.5205
R188 VDD.n112 VDD.n111 11.5205
R189 VDD.n111 VDD.n108 11.5205
R190 VDD.n108 VDD.n28 11.5205
R191 VDD.n123 VDD.n28 11.5205
R192 VDD.n123 VDD.n26 11.5205
R193 VDD.n145 VDD.n11 11.5205
R194 VDD.n141 VDD.n11 11.5205
R195 VDD.n141 VDD.n140 11.5205
R196 VDD.n140 VDD.n139 11.5205
R197 VDD.n139 VDD.n16 11.5205
R198 VDD.n135 VDD.n16 11.5205
R199 VDD.n135 VDD.n134 11.5205
R200 VDD.n134 VDD.n133 11.5205
R201 VDD.n133 VDD.n21 11.5205
R202 VDD.n129 VDD.n21 11.5205
R203 VDD.n129 VDD.n128 11.5205
R204 VDD.n128 VDD.n127 11.5205
R205 VDD.n127 VDD.n126 9.3005
R206 VDD.n128 VDD.n22 9.3005
R207 VDD.n130 VDD.n129 9.3005
R208 VDD.n131 VDD.n21 9.3005
R209 VDD.n133 VDD.n132 9.3005
R210 VDD.n134 VDD.n17 9.3005
R211 VDD.n136 VDD.n135 9.3005
R212 VDD.n137 VDD.n16 9.3005
R213 VDD.n139 VDD.n138 9.3005
R214 VDD.n140 VDD.n12 9.3005
R215 VDD.n142 VDD.n141 9.3005
R216 VDD.n143 VDD.n11 9.3005
R217 VDD.n145 VDD.n144 9.3005
R218 VDD.n125 VDD.n26 9.3005
R219 VDD.n124 VDD.n123 9.3005
R220 VDD.n28 VDD.n27 9.3005
R221 VDD.n109 VDD.n108 9.3005
R222 VDD.n111 VDD.n110 9.3005
R223 VDD.n112 VDD.n103 9.3005
R224 VDD.n114 VDD.n113 9.3005
R225 VDD.n115 VDD.n37 9.3005
R226 VDD.n117 VDD.n116 9.3005
R227 VDD.n72 VDD.n58 9.3005
R228 VDD.n74 VDD.n73 9.3005
R229 VDD.n53 VDD.n52 9.3005
R230 VDD.n81 VDD.n80 9.3005
R231 VDD.n82 VDD.n51 9.3005
R232 VDD.n84 VDD.n83 9.3005
R233 VDD.n46 VDD.n45 9.3005
R234 VDD.n91 VDD.n90 9.3005
R235 VDD.n92 VDD.n44 9.3005
R236 VDD.n94 VDD.n93 9.3005
R237 VDD.n39 VDD.n38 9.3005
R238 VDD.n101 VDD.n100 9.3005
R239 VDD.n102 VDD.n36 9.3005
R240 VDD.n71 VDD.n70 9.3005
R241 VDD.n69 VDD.n59 9.3005
R242 VDD.n2 VDD.n0 9.3005
R243 VDD.n155 VDD.n154 9.3005
R244 VDD.n153 VDD.n1 9.3005
R245 VDD.n152 VDD.n151 9.3005
R246 VDD.n150 VDD.n6 9.3005
R247 VDD.n148 VDD.n147 9.3005
R248 VDD.n146 VDD.n7 9.3005
R249 VDD.n144 VDD.n7 0.297375
R250 VDD.n126 VDD.n125 0.297375
R251 VDD.n116 VDD.n102 0.297375
R252 VDD.n72 VDD.n71 0.297375
R253 VDD VDD.n156 0.195114
R254 VDD.n144 VDD.n143 0.113
R255 VDD.n143 VDD.n142 0.113
R256 VDD.n142 VDD.n12 0.113
R257 VDD.n138 VDD.n12 0.113
R258 VDD.n138 VDD.n137 0.113
R259 VDD.n137 VDD.n136 0.113
R260 VDD.n136 VDD.n17 0.113
R261 VDD.n132 VDD.n17 0.113
R262 VDD.n132 VDD.n131 0.113
R263 VDD.n131 VDD.n130 0.113
R264 VDD.n130 VDD.n22 0.113
R265 VDD.n126 VDD.n22 0.113
R266 VDD.n116 VDD.n115 0.113
R267 VDD.n115 VDD.n114 0.113
R268 VDD.n114 VDD.n103 0.113
R269 VDD.n110 VDD.n103 0.113
R270 VDD.n110 VDD.n109 0.113
R271 VDD.n109 VDD.n27 0.113
R272 VDD.n124 VDD.n27 0.113
R273 VDD.n125 VDD.n124 0.113
R274 VDD.n73 VDD.n72 0.113
R275 VDD.n73 VDD.n52 0.113
R276 VDD.n81 VDD.n52 0.113
R277 VDD.n82 VDD.n81 0.113
R278 VDD.n83 VDD.n82 0.113
R279 VDD.n83 VDD.n45 0.113
R280 VDD.n91 VDD.n45 0.113
R281 VDD.n92 VDD.n91 0.113
R282 VDD.n93 VDD.n92 0.113
R283 VDD.n93 VDD.n38 0.113
R284 VDD.n101 VDD.n38 0.113
R285 VDD.n102 VDD.n101 0.113
R286 VDD.n71 VDD.n59 0.113
R287 VDD.n59 VDD.n0 0.113
R288 VDD.n155 VDD.n1 0.113
R289 VDD.n151 VDD.n1 0.113
R290 VDD.n151 VDD.n150 0.113
R291 VDD.n148 VDD.n7 0.113
R292 VDD.n150 VDD.n149 0.103625
R293 VDD.n156 VDD.n155 0.0989375
R294 VDD.n156 VDD.n0 0.0145625
R295 VDD.n149 VDD.n148 0.009875
R296 VSS.n69 VSS.n68 585
R297 VSS.n70 VSS.n69 585
R298 VSS.n43 VSS.n41 585
R299 VSS.n41 VSS.n39 585
R300 VSS.n31 VSS.n30 585
R301 VSS.n32 VSS.n31 585
R302 VSS.n81 VSS.n80 585
R303 VSS.n80 VSS.n79 585
R304 VSS.n27 VSS.n26 585
R305 VSS.n26 VSS.n25 585
R306 VSS.n88 VSS.n87 585
R307 VSS.n89 VSS.n88 585
R308 VSS.n28 VSS.n23 585
R309 VSS.n90 VSS.n23 585
R310 VSS.n93 VSS.n24 585
R311 VSS.n93 VSS.n92 585
R312 VSS.n94 VSS.n22 585
R313 VSS.n94 VSS.n14 585
R314 VSS.n114 VSS.n10 585
R315 VSS.n108 VSS.n9 585
R316 VSS.n110 VSS.n109 585
R317 VSS.n17 VSS.n12 585
R318 VSS.n104 VSS.n103 585
R319 VSS.n18 VSS.n16 585
R320 VSS.n97 VSS.n96 585
R321 VSS.n98 VSS.n95 585
R322 VSS.n115 VSS.n8 585
R323 VSS.n14 VSS.n8 585
R324 VSS.n91 VSS.n6 585
R325 VSS.n92 VSS.n91 585
R326 VSS.n120 VSS.n5 585
R327 VSS.n90 VSS.n5 585
R328 VSS.n121 VSS.n4 585
R329 VSS.n89 VSS.n4 585
R330 VSS.n122 VSS.n3 585
R331 VSS.n25 VSS.n3 585
R332 VSS.n78 VSS.n2 585
R333 VSS.n79 VSS.n78 585
R334 VSS.n77 VSS.n76 585
R335 VSS.n77 VSS.n32 585
R336 VSS.n34 VSS.n33 585
R337 VSS.n39 VSS.n33 585
R338 VSS.n72 VSS.n71 585
R339 VSS.n71 VSS.n70 585
R340 VSS.n42 VSS.n40 585
R341 VSS.n63 VSS.n46 585
R342 VSS.n62 VSS.n47 585
R343 VSS.n47 VSS.n38 585
R344 VSS.n61 VSS.n48 585
R345 VSS.n52 VSS.n49 585
R346 VSS.n57 VSS.n53 585
R347 VSS.n56 VSS.n55 585
R348 VSS.n37 VSS.n36 585
R349 VSS.n38 VSS.n37 585
R350 VSS.n95 VSS.n94 418.625
R351 VSS.n10 VSS.n8 418.625
R352 VSS.n71 VSS.n37 418.625
R353 VSS.n69 VSS.n40 418.625
R354 VSS.n107 VSS.n106 254.01
R355 VSS.n106 VSS.n13 254.01
R356 VSS.n106 VSS.n105 254.01
R357 VSS.n106 VSS.n15 254.01
R358 VSS.n45 VSS.n38 254.01
R359 VSS.n51 VSS.n38 254.01
R360 VSS.n54 VSS.n38 254.01
R361 VSS.n118 VSS.t1 231.323
R362 VSS.n70 VSS.n38 225.5
R363 VSS.n106 VSS.n14 225.5
R364 VSS.n70 VSS.n39 198
R365 VSS.n79 VSS.n32 198
R366 VSS.n79 VSS.n25 198
R367 VSS.n89 VSS.n25 198
R368 VSS.n90 VSS.n89 198
R369 VSS.n92 VSS.n14 198
R370 VSS.n96 VSS.n16 177.3
R371 VSS.n104 VSS.n17 177.3
R372 VSS.n109 VSS.n108 177.3
R373 VSS.n71 VSS.n33 177.3
R374 VSS.n77 VSS.n33 177.3
R375 VSS.n78 VSS.n77 177.3
R376 VSS.n78 VSS.n3 177.3
R377 VSS.n4 VSS.n3 177.3
R378 VSS.n5 VSS.n4 177.3
R379 VSS.n91 VSS.n5 177.3
R380 VSS.n91 VSS.n8 177.3
R381 VSS.n47 VSS.n46 177.3
R382 VSS.n48 VSS.n47 177.3
R383 VSS.n53 VSS.n52 177.3
R384 VSS.n55 VSS.n37 177.3
R385 VSS.n69 VSS.n41 177.3
R386 VSS.n41 VSS.n31 177.3
R387 VSS.n80 VSS.n31 177.3
R388 VSS.n80 VSS.n26 177.3
R389 VSS.n88 VSS.n26 177.3
R390 VSS.n88 VSS.n23 177.3
R391 VSS.n93 VSS.n23 177.3
R392 VSS.n94 VSS.n93 177.3
R393 VSS.n39 VSS.t2 140.25
R394 VSS.n92 VSS.t0 140.25
R395 VSS.n96 VSS.n15 76.985
R396 VSS.n105 VSS.n104 76.985
R397 VSS.n109 VSS.n13 76.985
R398 VSS.n107 VSS.n10 76.985
R399 VSS.n45 VSS.n40 76.985
R400 VSS.n51 VSS.n48 76.985
R401 VSS.n54 VSS.n53 76.985
R402 VSS.n108 VSS.n107 76.985
R403 VSS.n17 VSS.n13 76.985
R404 VSS.n105 VSS.n16 76.985
R405 VSS.n95 VSS.n15 76.985
R406 VSS.n46 VSS.n45 76.985
R407 VSS.n52 VSS.n51 76.985
R408 VSS.n55 VSS.n54 76.985
R409 VSS.t2 VSS.n32 57.7505
R410 VSS.t0 VSS.n90 57.7505
R411 VSS.n68 VSS.n42 27.2005
R412 VSS.n98 VSS.n22 27.2005
R413 VSS.n115 VSS.n114 27.2005
R414 VSS.n72 VSS.n36 27.2005
R415 VSS.n68 VSS.n43 11.5205
R416 VSS.n43 VSS.n30 11.5205
R417 VSS.n81 VSS.n30 11.5205
R418 VSS.n81 VSS.n27 11.5205
R419 VSS.n87 VSS.n27 11.5205
R420 VSS.n87 VSS.n28 11.5205
R421 VSS.n28 VSS.n24 11.5205
R422 VSS.n24 VSS.n22 11.5205
R423 VSS.n98 VSS.n97 11.5205
R424 VSS.n97 VSS.n18 11.5205
R425 VSS.n103 VSS.n18 11.5205
R426 VSS.n103 VSS.n12 11.5205
R427 VSS.n110 VSS.n12 11.5205
R428 VSS.n110 VSS.n9 11.5205
R429 VSS.n114 VSS.n9 11.5205
R430 VSS.n72 VSS.n34 11.5205
R431 VSS.n76 VSS.n34 11.5205
R432 VSS.n76 VSS.n2 11.5205
R433 VSS.n122 VSS.n2 11.5205
R434 VSS.n122 VSS.n121 11.5205
R435 VSS.n121 VSS.n120 11.5205
R436 VSS.n120 VSS.n6 11.5205
R437 VSS.n115 VSS.n6 11.5205
R438 VSS.n63 VSS.n42 11.5205
R439 VSS.n63 VSS.n62 11.5205
R440 VSS.n62 VSS.n61 11.5205
R441 VSS.n61 VSS.n49 11.5205
R442 VSS.n57 VSS.n49 11.5205
R443 VSS.n57 VSS.n56 11.5205
R444 VSS.n56 VSS.n36 11.5205
R445 VSS.n114 VSS.n113 9.3005
R446 VSS.n112 VSS.n9 9.3005
R447 VSS.n111 VSS.n110 9.3005
R448 VSS.n12 VSS.n11 9.3005
R449 VSS.n103 VSS.n102 9.3005
R450 VSS.n19 VSS.n18 9.3005
R451 VSS.n97 VSS.n21 9.3005
R452 VSS.n99 VSS.n98 9.3005
R453 VSS.n65 VSS.n42 9.3005
R454 VSS.n64 VSS.n63 9.3005
R455 VSS.n62 VSS.n44 9.3005
R456 VSS.n61 VSS.n60 9.3005
R457 VSS.n59 VSS.n49 9.3005
R458 VSS.n58 VSS.n57 9.3005
R459 VSS.n56 VSS.n50 9.3005
R460 VSS.n36 VSS.n35 9.3005
R461 VSS.n68 VSS.n67 9.3005
R462 VSS.n66 VSS.n43 9.3005
R463 VSS.n30 VSS.n29 9.3005
R464 VSS.n82 VSS.n81 9.3005
R465 VSS.n83 VSS.n27 9.3005
R466 VSS.n87 VSS.n86 9.3005
R467 VSS.n85 VSS.n28 9.3005
R468 VSS.n84 VSS.n24 9.3005
R469 VSS.n22 VSS.n20 9.3005
R470 VSS.n116 VSS.n115 9.3005
R471 VSS.n117 VSS.n6 9.3005
R472 VSS.n120 VSS.n119 9.3005
R473 VSS.n121 VSS.n1 9.3005
R474 VSS.n123 VSS.n122 9.3005
R475 VSS.n2 VSS.n0 9.3005
R476 VSS.n76 VSS.n75 9.3005
R477 VSS.n74 VSS.n34 9.3005
R478 VSS.n73 VSS.n72 9.3005
R479 VSS.n101 VSS.n100 1.41717
R480 VSS.n101 VSS.n7 1.41717
R481 VSS.n100 VSS.n99 0.343937
R482 VSS.n113 VSS.n7 0.325188
R483 VSS.n67 VSS.n65 0.266125
R484 VSS VSS.n124 0.201215
R485 VSS.n99 VSS.n21 0.1805
R486 VSS.n21 VSS.n19 0.1805
R487 VSS.n102 VSS.n19 0.1805
R488 VSS.n111 VSS.n11 0.1805
R489 VSS.n112 VSS.n111 0.1805
R490 VSS.n113 VSS.n112 0.1805
R491 VSS.n73 VSS.n35 0.163625
R492 VSS.n65 VSS.n64 0.113
R493 VSS.n64 VSS.n44 0.113
R494 VSS.n60 VSS.n44 0.113
R495 VSS.n60 VSS.n59 0.113
R496 VSS.n59 VSS.n58 0.113
R497 VSS.n58 VSS.n50 0.113
R498 VSS.n50 VSS.n35 0.113
R499 VSS.n67 VSS.n66 0.113
R500 VSS.n66 VSS.n29 0.113
R501 VSS.n82 VSS.n29 0.113
R502 VSS.n83 VSS.n82 0.113
R503 VSS.n86 VSS.n83 0.113
R504 VSS.n86 VSS.n85 0.113
R505 VSS.n85 VSS.n84 0.113
R506 VSS.n84 VSS.n20 0.113
R507 VSS.n102 VSS.n101 0.0905
R508 VSS.n101 VSS.n11 0.0905
R509 VSS.n100 VSS.n20 0.0895625
R510 VSS.n74 VSS.n73 0.023
R511 VSS.n75 VSS.n74 0.023
R512 VSS.n75 VSS.n0 0.023
R513 VSS.n123 VSS.n1 0.023
R514 VSS.n119 VSS.n1 0.023
R515 VSS.n117 VSS.n116 0.023
R516 VSS.n119 VSS.n118 0.021125
R517 VSS.n116 VSS.n7 0.0183125
R518 VSS.n124 VSS.n123 0.0176875
R519 VSS.n124 VSS.n0 0.0058125
R520 VSS.n118 VSS.n117 0.002375
C0 enb b 0.13321f
C1 a en 0.46614f
C2 VDD a 0.60348f
C3 b en 0.16039f
C4 b VDD 0.96839f
C5 enb en 0.89772f
C6 b a 1.05784f
C7 enb VDD 0.64063f
C8 VDD en 0.39774f
C9 enb a 1.14486f
C10 b VSS 1.84371f
C11 en VSS 1.6418f
C12 a VSS 2.75381f
C13 VDD VSS 7.04782f
C14 enb VSS 0.36252f
C15 VDD.n0 VSS 0.00237f
C16 VDD.n1 VSS 0.00421f
C17 VDD.n2 VSS 0.00421f
C18 VDD.n3 VSS 0.00421f
C19 VDD.n4 VSS 0.00421f
C20 VDD.n5 VSS 0.00421f
C21 VDD.n6 VSS 0.00421f
C22 VDD.t1 VSS 0.00774f
C23 VDD.n7 VSS 0.00899f
C24 VDD.n8 VSS 0.00421f
C25 VDD.n9 VSS 0.00899f
C26 VDD.n10 VSS 0.00867f
C27 VDD.n11 VSS 0.00421f
C28 VDD.n12 VSS 0.00421f
C29 VDD.n13 VSS 0.00421f
C30 VDD.n14 VSS 0.00421f
C31 VDD.n15 VSS 0.00421f
C32 VDD.n16 VSS 0.00421f
C33 VDD.n17 VSS 0.00421f
C34 VDD.n18 VSS 0.00421f
C35 VDD.n19 VSS 0.00421f
C36 VDD.n20 VSS 0.00421f
C37 VDD.n21 VSS 0.00421f
C38 VDD.n22 VSS 0.00421f
C39 VDD.n23 VSS 0.00421f
C40 VDD.n24 VSS 0.00421f
C41 VDD.n25 VSS 0.00867f
C42 VDD.n26 VSS 0.00899f
C43 VDD.n27 VSS 0.00421f
C44 VDD.n28 VSS 0.00421f
C45 VDD.n29 VSS 0.00421f
C46 VDD.n30 VSS 0.08203f
C47 VDD.n34 VSS 0.00867f
C48 VDD.n35 VSS 0.00421f
C49 VDD.n36 VSS 0.00867f
C50 VDD.n37 VSS 0.00421f
C51 VDD.n38 VSS 0.00421f
C52 VDD.n39 VSS 0.00421f
C53 VDD.n40 VSS 0.00421f
C54 VDD.n41 VSS 0.05369f
C55 VDD.n42 VSS 0.00421f
C56 VDD.n43 VSS 0.00421f
C57 VDD.n44 VSS 0.00421f
C58 VDD.n45 VSS 0.00421f
C59 VDD.n46 VSS 0.00421f
C60 VDD.n47 VSS 0.00421f
C61 VDD.n48 VSS 0.05369f
C62 VDD.n49 VSS 0.00421f
C63 VDD.n50 VSS 0.00421f
C64 VDD.n51 VSS 0.00421f
C65 VDD.n52 VSS 0.00421f
C66 VDD.n53 VSS 0.00421f
C67 VDD.n54 VSS 0.00421f
C68 VDD.n55 VSS 0.08203f
C69 VDD.n56 VSS 0.00421f
C70 VDD.n57 VSS 0.00867f
C71 VDD.n58 VSS 0.00867f
C72 VDD.n59 VSS 0.00421f
C73 VDD.n60 VSS 0.00899f
C74 VDD.n61 VSS 0.00421f
C75 VDD.n63 VSS 0.00421f
C76 VDD.n66 VSS 0.15958f
C77 VDD.n68 VSS 0.00421f
C78 VDD.n69 VSS 0.00421f
C79 VDD.n70 VSS 0.00899f
C80 VDD.n71 VSS 0.01631f
C81 VDD.n72 VSS 0.01422f
C82 VDD.n73 VSS 0.00421f
C83 VDD.n74 VSS 0.00421f
C84 VDD.n75 VSS 0.00421f
C85 VDD.n76 VSS 0.05369f
C86 VDD.n77 VSS 0.05369f
C87 VDD.n78 VSS 0.05369f
C88 VDD.n79 VSS 0.00421f
C89 VDD.n80 VSS 0.00421f
C90 VDD.n81 VSS 0.00421f
C91 VDD.n82 VSS 0.00421f
C92 VDD.n83 VSS 0.00421f
C93 VDD.n84 VSS 0.00421f
C94 VDD.n85 VSS 0.00421f
C95 VDD.n86 VSS 0.03654f
C96 VDD.t2 VSS 0.02685f
C97 VDD.n87 VSS 0.044f
C98 VDD.n88 VSS 0.05369f
C99 VDD.n89 VSS 0.00421f
C100 VDD.n90 VSS 0.00421f
C101 VDD.n91 VSS 0.00421f
C102 VDD.n92 VSS 0.00421f
C103 VDD.n93 VSS 0.00421f
C104 VDD.n94 VSS 0.00421f
C105 VDD.n95 VSS 0.00421f
C106 VDD.n96 VSS 0.04101f
C107 VDD.t0 VSS 0.02685f
C108 VDD.n97 VSS 0.03952f
C109 VDD.n98 VSS 0.05369f
C110 VDD.n99 VSS 0.00421f
C111 VDD.n100 VSS 0.00421f
C112 VDD.n101 VSS 0.00421f
C113 VDD.n102 VSS 0.00867f
C114 VDD.n103 VSS 0.00421f
C115 VDD.n104 VSS 0.00421f
C116 VDD.n105 VSS 0.00421f
C117 VDD.n106 VSS 0.00421f
C118 VDD.n107 VSS 0.00421f
C119 VDD.n108 VSS 0.00421f
C120 VDD.n109 VSS 0.00421f
C121 VDD.n110 VSS 0.00421f
C122 VDD.n111 VSS 0.00421f
C123 VDD.n112 VSS 0.00421f
C124 VDD.n113 VSS 0.00421f
C125 VDD.n114 VSS 0.00421f
C126 VDD.n115 VSS 0.00421f
C127 VDD.n116 VSS 0.00899f
C128 VDD.n117 VSS 0.00899f
C129 VDD.n118 VSS 0.00899f
C130 VDD.n119 VSS 0.15958f
C131 VDD.n120 VSS 0.00899f
C132 VDD.n122 VSS 0.00421f
C133 VDD.n123 VSS 0.00421f
C134 VDD.n124 VSS 0.00421f
C135 VDD.n125 VSS 0.00899f
C136 VDD.n126 VSS 0.00867f
C137 VDD.n127 VSS 0.00867f
C138 VDD.n128 VSS 0.00421f
C139 VDD.n129 VSS 0.00421f
C140 VDD.n130 VSS 0.00421f
C141 VDD.n131 VSS 0.00421f
C142 VDD.n132 VSS 0.00421f
C143 VDD.n133 VSS 0.00421f
C144 VDD.n134 VSS 0.00421f
C145 VDD.n135 VSS 0.00421f
C146 VDD.n136 VSS 0.00421f
C147 VDD.n137 VSS 0.00421f
C148 VDD.n138 VSS 0.00421f
C149 VDD.n139 VSS 0.00421f
C150 VDD.n140 VSS 0.00421f
C151 VDD.n141 VSS 0.00421f
C152 VDD.n142 VSS 0.00421f
C153 VDD.n143 VSS 0.00421f
C154 VDD.n144 VSS 0.00867f
C155 VDD.n145 VSS 0.00867f
C156 VDD.n146 VSS 0.00899f
C157 VDD.n147 VSS 0.00421f
C158 VDD.n148 VSS 0.00228f
C159 VDD.n149 VSS 0.04048f
C160 VDD.n150 VSS 0.00404f
C161 VDD.n151 VSS 0.00421f
C162 VDD.n152 VSS 0.00421f
C163 VDD.n153 VSS 0.00421f
C164 VDD.n154 VSS 0.00421f
C165 VDD.n155 VSS 0.00395f
C166 VDD.n156 VSS 0.4504f
C167 a.t1 VSS 0.34709f
C168 a.t0 VSS 0.17727f
C169 a.n0 VSS 1.2645f
C170 en.t2 VSS 0.05766f
C171 en.t1 VSS 0.03894f
C172 en.n0 VSS 0.68712f
C173 en.t0 VSS 0.09655f
C174 en.n1 VSS 0.4782f
C175 b.t1 VSS 0.3505f
C176 b.t0 VSS 0.14344f
C177 b.n0 VSS 1.73289f
.ends
