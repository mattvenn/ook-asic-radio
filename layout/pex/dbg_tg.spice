* dbg_tg: magic R+C extraction of layout/dbg_tg.gds (layout/pex.sh)
.subckt dbg_tg a en b VDD VSS
X0 enb en VSS VSS.t0 sky130_fd_pr__nfet_01v8 ad=0.15 pd=1.6 as=0.15 ps=1.6 w=0.5 l=0.15
X1 b en a VSS.t1 sky130_fd_pr__nfet_01v8 ad=0.6 pd=4.6 as=0.6 ps=4.6 w=2 l=0.15
X2 b enb a VDD sky130_fd_pr__pfet_01v8 ad=1.2 pd=8.6 as=1.2 ps=8.6 w=4 l=0.15
X3 enb en VDD VDD sky130_fd_pr__pfet_01v8 ad=0.3 pd=2.6 as=0.3 ps=2.6 w=1 l=0.15
R0 VSS.n46 VSS.n45 585
R1 VSS.n45 VSS.n44 585
R2 VSS.n60 VSS.n59 585
R3 VSS.n61 VSS.n57 585
R4 VSS.n56 VSS.n11 585
R5 VSS.n62 VSS.n54 585
R6 VSS.n53 VSS.n46 585
R7 VSS.n63 VSS.n53 585
R8 VSS.n64 VSS.n52 585
R9 VSS.n14 VSS.n48 585
R10 VSS.n68 VSS.n67 585
R11 VSS.n69 VSS.n68 585
R12 VSS.n47 VSS.n42 585
R13 VSS.n43 VSS.n42 585
R14 VSS.n71 VSS.n41 585
R15 VSS.n71 VSS.n70 585
R16 VSS.n73 VSS.n72 585
R17 VSS.n72 VSS.n19 585
R18 VSS.n35 VSS.n20 585
R19 VSS.n100 VSS.n20 585
R20 VSS.n78 VSS.n21 585
R21 VSS.n99 VSS.n21 585
R22 VSS.n79 VSS.n22 585
R23 VSS.n98 VSS.n22 585
R24 VSS.n81 VSS.n80 585
R25 VSS.n80 VSS.n23 585
R26 VSS.n29 VSS.n24 585
R27 VSS.n97 VSS.n24 585
R28 VSS.n87 VSS.n84 585
R29 VSS.n86 VSS.n85 585
R30 VSS.n2 VSS.n31 585
R31 VSS.n89 VSS.n88 585
R32 VSS.n32 VSS.n27 585
R33 VSS.n95 VSS.n94 585
R34 VSS.n93 VSS.n25 585
R35 VSS.n96 VSS.n26 585
R36 VSS.n83 VSS.n29 585
R37 VSS.n83 VSS.n33 585
R38 VSS.n82 VSS.n81 585
R39 VSS.n82 VSS.n5 585
R40 VSS.n79 VSS.n34 585
R41 VSS.n38 VSS.n34 585
R42 VSS.n78 VSS.n77 585
R43 VSS.n77 VSS.n76 585
R44 VSS.n36 VSS.n35 585
R45 VSS.n37 VSS.n36 585
R46 VSS.n74 VSS.n73 585
R47 VSS.n75 VSS.n74 585
R48 VSS.n41 VSS.n40 585
R49 VSS.n40 VSS.n39 585
R50 VSS.n49 VSS.n47 585
R51 VSS.n50 VSS.n49 585
R52 VSS.n67 VSS.n66 585
R53 VSS.n66 VSS.n65 585
R54 VSS.n66 VSS.n48 418.625
R55 VSS.n68 VSS.n45 418.625
R56 VSS.n26 VSS.n24 418.625
R57 VSS.n84 VSS.n83 418.625
R58 VSS.n58 VSS.n46 254.01
R59 VSS.n55 VSS.n46 254.01
R60 VSS.n51 VSS.n46 254.01
R61 VSS.n91 VSS.n30 254.01
R62 VSS.n91 VSS.n90 254.01
R63 VSS.n91 VSS.n28 254.01
R64 VSS.n92 VSS.n91 254.01
R65 VSS.n91 VSS.n29 225.5
R66 VSS.n67 VSS.n46 225.5
R67 VSS.n81 VSS.n29 198
R68 VSS.n79 VSS.n78 198
R69 VSS.n78 VSS.n35 198
R70 VSS.n73 VSS.n35 198
R71 VSS.n73 VSS.n41 198
R72 VSS.n67 VSS.n47 198
R73 VSS.n83 VSS.n82 177.3
R74 VSS.n82 VSS.n34 177.3
R75 VSS.n77 VSS.n34 177.3
R76 VSS.n77 VSS.n36 177.3
R77 VSS.n74 VSS.n36 177.3
R78 VSS.n74 VSS.n40 177.3
R79 VSS.n49 VSS.n40 177.3
R80 VSS.n66 VSS.n49 177.3
R81 VSS.n59 VSS.n45 177.3
R82 VSS.n57 VSS.n56 177.3
R83 VSS.n54 VSS.n53 177.3
R84 VSS.n53 VSS.n52 177.3
R85 VSS.n80 VSS.n24 177.3
R86 VSS.n80 VSS.n22 177.3
R87 VSS.n22 VSS.n21 177.3
R88 VSS.n21 VSS.n20 177.3
R89 VSS.n72 VSS.n20 177.3
R90 VSS.n72 VSS.n71 177.3
R91 VSS.n71 VSS.n42 177.3
R92 VSS.n68 VSS.n42 177.3
R93 VSS.n94 VSS.n93 177.3
R94 VSS.n89 VSS.n32 177.3
R95 VSS.n85 VSS.n31 177.3
R96 VSS.n81 VSS.t0 140.25
R97 VSS.n47 VSS.t1 140.25
R98 VSS.n59 VSS.n58 76.985
R99 VSS.n56 VSS.n55 76.985
R100 VSS.n52 VSS.n51 76.985
R101 VSS.n84 VSS.n30 76.985
R102 VSS.n90 VSS.n31 76.985
R103 VSS.n32 VSS.n28 76.985
R104 VSS.n93 VSS.n92 76.985
R105 VSS.n58 VSS.n57 76.985
R106 VSS.n55 VSS.n54 76.985
R107 VSS.n51 VSS.n48 76.985
R108 VSS.n92 VSS.n26 76.985
R109 VSS.n94 VSS.n28 76.985
R110 VSS.n90 VSS.n89 76.985
R111 VSS.n85 VSS.n30 76.985
R112 VSS.t0 VSS.n79 57.7505
R113 VSS.t1 VSS.n41 57.7505
R114 VSS.n69 VSS.n44 27.2005
R115 VSS.n97 VSS.n96 27.2005
R116 VSS.n87 VSS.n33 27.2005
R117 VSS.n65 VSS.n14 27.2005
R118 VSS.n60 VSS.n10 3.55797
R119 VSS.n61 VSS.n60 11.5205
R120 VSS.n12 VSS.n11 3.55797
R121 VSS.n62 VSS.n11 11.5205
R122 VSS.n63 VSS.n13 3.55797
R123 VSS.n64 VSS.n63 11.5205
R124 VSS.n15 VSS.n14 3.55797
R125 VSS.n97 VSS.n23 11.5205
R126 VSS.n17 VSS.n23 3.55797
R127 VSS.n99 VSS.n98 11.5205
R128 VSS.n100 VSS.n99 11.5205
R129 VSS.n100 VSS.n18 3.55797
R130 VSS.n70 VSS.n19 11.5205
R131 VSS.n70 VSS.n43 11.5205
R132 VSS.n69 VSS.n16 3.55797
R133 VSS.n1 VSS.n25 3.55797
R134 VSS.n95 VSS.n25 11.5205
R135 VSS.n95 VSS.n27 11.5205
R136 VSS.n4 VSS.n27 3.55797
R137 VSS.n88 VSS.n2 11.5205
R138 VSS.n86 VSS.n2 11.5205
R139 VSS.n87 VSS.n3 3.55797
R140 VSS.n5 VSS.n33 11.5205
R141 VSS.n38 VSS.n6 3.55797
R142 VSS.n76 VSS.n38 11.5205
R143 VSS.n7 VSS.n37 3.55797
R144 VSS.n75 VSS.n37 11.5205
R145 VSS.n8 VSS.n39 3.55797
R146 VSS.n50 VSS.n39 11.5205
R147 VSS.n65 VSS.n9 3.55797
R148 VSS VSS.n16 2.87251
R149 VSS.n16 VSS.n43 3.55797
R150 VSS.n70 VSS 9.3005
R151 VSS.n19 VSS.n18 3.55797
R152 VSS VSS.n18 2.87251
R153 VSS.n99 VSS 9.3005
R154 VSS.n98 VSS.n17 3.55797
R155 VSS VSS.n17 2.87251
R156 VSS VSS.n97 9.3005
R157 VSS.n33 VSS.n0 9.3005
R158 VSS.n6 VSS.n5 3.55797
R159 VSS.n0 VSS.n6 2.87251
R160 VSS.n76 VSS.n7 3.55797
R161 VSS.n0 VSS.n7 2.87251
R162 VSS.n8 VSS.n75 3.55797
R163 VSS.n8 VSS.n0 2.87251
R164 VSS.n9 VSS.n50 3.55797
R165 VSS.n9 VSS.n0 2.87251
R166 VSS.n44 VSS.n10 3.55797
R167 VSS.n10 VSS 2.87251
R168 VSS.n12 VSS.n61 3.55797
R169 VSS VSS.n12 2.87251
R170 VSS.n62 VSS.n13 3.55797
R171 VSS.n13 VSS.n0 2.87251
R172 VSS.n15 VSS.n64 3.55797
R173 VSS.n0 VSS.n15 2.87251
R174 VSS.n0 VSS.n3 2.87251
R175 VSS.n86 VSS.n3 3.55797
R176 VSS.n0 VSS.n2 9.3005
R177 VSS.n88 VSS.n4 3.55797
R178 VSS.n4 VSS.n0 2.87251
R179 VSS.n0 VSS.n95 9.3005
R180 VSS VSS.n1 2.95265
R181 VSS.n96 VSS.n1 3.55797
R182 VSS.n0 VSS 1.16067
C0 a enb 0.64834f
C1 b VDD 0.69099f
C2 a en 0.29711f
C3 VDD enb 0.54184f
C4 b enb 0.0981f
C5 VDD en 0.31248f
C6 b en 0.05875f
C7 en enb 0.50242f
C8 a VDD 0.4826f
C9 b a 0.56941f
C10 b VSS 1.46693f
C11 a VSS 0.71192f
C12 VDD VSS 6.66735f
.ends
