* tx_ls_en: magic R+C extraction of layout/tx_ls_en.gds (layout/pex.sh)
.subckt tx_ls_en in A B VDD VAPWR VSS
X0 A.t0 B.t2 VAPWR.t3 VAPWR.t2 sky130_fd_pr__pfet_g5v0d10v5 ad=0.126 pd=1.44 as=0.126 ps=1.44 w=0.42 l=0.5
X1 A.t1 ctrl VSS.t5 VSS.t4 sky130_fd_pr__nfet_g5v0d10v5 ad=0.126 pd=1.44 as=0.126 ps=1.44 w=0.42 l=0.5
X2 ctrl in.t1 VDD.t1 VDD.t0 sky130_fd_pr__pfet_01v8 ad=0.3 pd=2.6 as=0.3 ps=2.6 w=1 l=0.15
X3 B.t0 A.t2 VAPWR.t1 VAPWR.t0 sky130_fd_pr__pfet_g5v0d10v5 ad=0.126 pd=1.44 as=0.126 ps=1.44 w=0.42 l=0.5
X4 ctrl in.t0 VSS.t1 VSS.t0 sky130_fd_pr__nfet_01v8 ad=0.126 pd=1.44 as=0.126 ps=1.44 w=0.42 l=0.15
X5 B.t1 ctrl_n VSS.t3 VSS.t2 sky130_fd_pr__nfet_g5v0d10v5 ad=0.126 pd=1.44 as=0.126 ps=1.44 w=0.42 l=0.5
X6 ctrl_n ctrl VSS.t7 VSS.t6 sky130_fd_pr__nfet_01v8 ad=0.126 pd=1.44 as=0.126 ps=1.44 w=0.42 l=0.15
X7 ctrl_n ctrl VDD.t3 VDD.t2 sky130_fd_pr__pfet_01v8_hvt ad=0.3 pd=2.6 as=0.3 ps=2.6 w=1 l=0.15
R0 A.n0 A.t0 668.53
R1 A.n0 A.t1 240.696
R2 A.n1 A.t2 225.935
R3 A.n1 A.n0 3.55667
R4 A A.n1 0.11659
R5 B.n0 B.t0 667.864
R6 B.n0 B.t1 241.363
R7 B.n1 B.t2 225.499
R8 B.n1 B.n0 3.4105
R9 B B.n1 0.07476
R10 in.n0 in.t1 420.817
R11 in.n0 in.t0 328.63
R12 in in.n0 3.49886
R13 VAPWR.n7 VAPWR.t3 662.865
R14 VAPWR.n76 VAPWR.t1 662.865
R15 VAPWR.n97 VAPWR.n9 250.8
R16 VAPWR.n99 VAPWR.n14 250.8
R17 VAPWR.n48 VAPWR.n47 250.8
R18 VAPWR.n38 VAPWR.n35 250.8
R19 VAPWR.n36 VAPWR.n35 185
R20 VAPWR.n35 VAPWR.n34 185
R21 VAPWR.n61 VAPWR.n60 185
R22 VAPWR.n62 VAPWR.n61 185
R23 VAPWR.n28 VAPWR.n27 185
R24 VAPWR.n63 VAPWR.n28 185
R25 VAPWR.n74 VAPWR.n73 185
R26 VAPWR.n73 VAPWR.n72 185
R27 VAPWR.n25 VAPWR.n24 185
R28 VAPWR.n71 VAPWR.n24 185
R29 VAPWR.n80 VAPWR.n79 185
R30 VAPWR.n80 VAPWR.n22 185
R31 VAPWR.n81 VAPWR.n2 185
R32 VAPWR.n82 VAPWR.n81 185
R33 VAPWR.n113 VAPWR.n3 185
R34 VAPWR.n23 VAPWR.n3 185
R35 VAPWR.n112 VAPWR.n4 185
R36 VAPWR.n91 VAPWR.n4 185
R37 VAPWR.n111 VAPWR.n5 185
R38 VAPWR.n92 VAPWR.n5 185
R39 VAPWR.n97 VAPWR.n6 185
R40 VAPWR.n98 VAPWR.n97 185
R41 VAPWR.n56 VAPWR.n38 185
R42 VAPWR.n55 VAPWR.n39 185
R43 VAPWR.n54 VAPWR.n40 185
R44 VAPWR.n45 VAPWR.n40 185
R45 VAPWR.n43 VAPWR.n41 185
R46 VAPWR.n50 VAPWR.n47 185
R47 VAPWR.n100 VAPWR.n99 185
R48 VAPWR.n99 VAPWR.n98 185
R49 VAPWR.n16 VAPWR.n15 185
R50 VAPWR.n92 VAPWR.n16 185
R51 VAPWR.n90 VAPWR.n89 185
R52 VAPWR.n91 VAPWR.n90 185
R53 VAPWR.n18 VAPWR.n17 185
R54 VAPWR.n23 VAPWR.n17 185
R55 VAPWR.n84 VAPWR.n83 185
R56 VAPWR.n83 VAPWR.n82 185
R57 VAPWR.n21 VAPWR.n20 185
R58 VAPWR.n22 VAPWR.n21 185
R59 VAPWR.n70 VAPWR.n69 185
R60 VAPWR.n71 VAPWR.n70 185
R61 VAPWR.n30 VAPWR.n29 185
R62 VAPWR.n72 VAPWR.n29 185
R63 VAPWR.n65 VAPWR.n64 185
R64 VAPWR.n64 VAPWR.n63 185
R65 VAPWR.n33 VAPWR.n32 185
R66 VAPWR.n62 VAPWR.n33 185
R67 VAPWR.n49 VAPWR.n48 185
R68 VAPWR.n48 VAPWR.n34 185
R69 VAPWR.n101 VAPWR.n14 185
R70 VAPWR.n93 VAPWR.n12 185
R71 VAPWR.n105 VAPWR.n11 185
R72 VAPWR.n106 VAPWR.n10 185
R73 VAPWR.n107 VAPWR.n9 185
R74 VAPWR.n96 VAPWR.n9 185
R75 VAPWR.n10 VAPWR.n9 102.6
R76 VAPWR.n93 VAPWR.n11 102.6
R77 VAPWR.n48 VAPWR.n33 102.6
R78 VAPWR.n64 VAPWR.n33 102.6
R79 VAPWR.n64 VAPWR.n29 102.6
R80 VAPWR.n70 VAPWR.n29 102.6
R81 VAPWR.n70 VAPWR.n21 102.6
R82 VAPWR.n83 VAPWR.n21 102.6
R83 VAPWR.n83 VAPWR.n17 102.6
R84 VAPWR.n90 VAPWR.n17 102.6
R85 VAPWR.n90 VAPWR.n16 102.6
R86 VAPWR.n99 VAPWR.n16 102.6
R87 VAPWR.n40 VAPWR.n39 102.6
R88 VAPWR.n43 VAPWR.n40 102.6
R89 VAPWR.n61 VAPWR.n35 102.6
R90 VAPWR.n61 VAPWR.n28 102.6
R91 VAPWR.n73 VAPWR.n28 102.6
R92 VAPWR.n73 VAPWR.n24 102.6
R93 VAPWR.n80 VAPWR.n24 102.6
R94 VAPWR.n81 VAPWR.n80 102.6
R95 VAPWR.n81 VAPWR.n3 102.6
R96 VAPWR.n4 VAPWR.n3 102.6
R97 VAPWR.n5 VAPWR.n4 102.6
R98 VAPWR.n97 VAPWR.n5 102.6
R99 VAPWR.n45 VAPWR.n34 90.4767
R100 VAPWR.n98 VAPWR.n96 90.4767
R101 VAPWR.n62 VAPWR.n34 81.4291
R102 VAPWR.n63 VAPWR.n62 81.4291
R103 VAPWR.n72 VAPWR.n71 81.4291
R104 VAPWR.n71 VAPWR.n22 81.4291
R105 VAPWR.n82 VAPWR.n22 81.4291
R106 VAPWR.n82 VAPWR.n23 81.4291
R107 VAPWR.n92 VAPWR.n91 81.4291
R108 VAPWR.n98 VAPWR.n92 81.4291
R109 VAPWR.n45 VAPWR.n44 72.4195
R110 VAPWR.n46 VAPWR.n45 72.4195
R111 VAPWR.n96 VAPWR.n94 72.4195
R112 VAPWR.n96 VAPWR.n95 72.4195
R113 VAPWR.n72 VAPWR.t0 63.3338
R114 VAPWR.n23 VAPWR.t2 63.3338
R115 VAPWR.n95 VAPWR.n11 40.1639
R116 VAPWR.n94 VAPWR.n14 40.1639
R117 VAPWR.n44 VAPWR.n38 40.1639
R118 VAPWR.n46 VAPWR.n43 40.1639
R119 VAPWR.n44 VAPWR.n39 40.1639
R120 VAPWR.n47 VAPWR.n46 40.1639
R121 VAPWR.n94 VAPWR.n93 40.1639
R122 VAPWR.n95 VAPWR.n10 40.1639
R123 VAPWR.n56 VAPWR.n36 28.1605
R124 VAPWR.n107 VAPWR.n6 28.1605
R125 VAPWR.n50 VAPWR.n49 28.1605
R126 VAPWR.n101 VAPWR.n100 28.1605
R127 VAPWR.n63 VAPWR.t0 18.0957
R128 VAPWR.n91 VAPWR.t2 18.0957
R129 VAPWR.n60 VAPWR.n36 11.5205
R130 VAPWR.n60 VAPWR.n27 11.5205
R131 VAPWR.n74 VAPWR.n27 11.5205
R132 VAPWR.n74 VAPWR.n25 11.5205
R133 VAPWR.n79 VAPWR.n25 11.5205
R134 VAPWR.n79 VAPWR.n2 11.5205
R135 VAPWR.n113 VAPWR.n2 11.5205
R136 VAPWR.n113 VAPWR.n112 11.5205
R137 VAPWR.n112 VAPWR.n111 11.5205
R138 VAPWR.n111 VAPWR.n6 11.5205
R139 VAPWR.n56 VAPWR.n55 11.5205
R140 VAPWR.n55 VAPWR.n54 11.5205
R141 VAPWR.n54 VAPWR.n41 11.5205
R142 VAPWR.n50 VAPWR.n41 11.5205
R143 VAPWR.n49 VAPWR.n32 11.5205
R144 VAPWR.n65 VAPWR.n32 11.5205
R145 VAPWR.n65 VAPWR.n30 11.5205
R146 VAPWR.n69 VAPWR.n30 11.5205
R147 VAPWR.n69 VAPWR.n20 11.5205
R148 VAPWR.n84 VAPWR.n20 11.5205
R149 VAPWR.n84 VAPWR.n18 11.5205
R150 VAPWR.n89 VAPWR.n18 11.5205
R151 VAPWR.n89 VAPWR.n15 11.5205
R152 VAPWR.n100 VAPWR.n15 11.5205
R153 VAPWR.n107 VAPWR.n106 11.5205
R154 VAPWR.n106 VAPWR.n105 11.5205
R155 VAPWR.n105 VAPWR.n12 11.5205
R156 VAPWR.n101 VAPWR.n12 11.5205
R157 VAPWR.n102 VAPWR.n101 9.3005
R158 VAPWR.n103 VAPWR.n12 9.3005
R159 VAPWR.n105 VAPWR.n104 9.3005
R160 VAPWR.n106 VAPWR.n8 9.3005
R161 VAPWR.n108 VAPWR.n107 9.3005
R162 VAPWR.n100 VAPWR.n13 9.3005
R163 VAPWR.n87 VAPWR.n15 9.3005
R164 VAPWR.n89 VAPWR.n88 9.3005
R165 VAPWR.n86 VAPWR.n18 9.3005
R166 VAPWR.n85 VAPWR.n84 9.3005
R167 VAPWR.n20 VAPWR.n19 9.3005
R168 VAPWR.n69 VAPWR.n68 9.3005
R169 VAPWR.n67 VAPWR.n30 9.3005
R170 VAPWR.n66 VAPWR.n65 9.3005
R171 VAPWR.n32 VAPWR.n31 9.3005
R172 VAPWR.n49 VAPWR.n42 9.3005
R173 VAPWR.n57 VAPWR.n56 9.3005
R174 VAPWR.n55 VAPWR.n37 9.3005
R175 VAPWR.n54 VAPWR.n53 9.3005
R176 VAPWR.n52 VAPWR.n41 9.3005
R177 VAPWR.n51 VAPWR.n50 9.3005
R178 VAPWR.n58 VAPWR.n36 9.3005
R179 VAPWR.n60 VAPWR.n59 9.3005
R180 VAPWR.n27 VAPWR.n26 9.3005
R181 VAPWR.n75 VAPWR.n74 9.3005
R182 VAPWR.n77 VAPWR.n25 9.3005
R183 VAPWR.n79 VAPWR.n78 9.3005
R184 VAPWR.n2 VAPWR.n0 9.3005
R185 VAPWR.n114 VAPWR.n113 9.3005
R186 VAPWR.n112 VAPWR.n1 9.3005
R187 VAPWR.n111 VAPWR.n110 9.3005
R188 VAPWR.n109 VAPWR.n6 9.3005
R189 VAPWR.n102 VAPWR.n13 0.2755
R190 VAPWR.n51 VAPWR.n42 0.2755
R191 VAPWR.n109 VAPWR.n108 0.1755
R192 VAPWR.n58 VAPWR.n57 0.1755
R193 VAPWR VAPWR.n115 0.159465
R194 VAPWR.n108 VAPWR.n8 0.113
R195 VAPWR.n104 VAPWR.n8 0.113
R196 VAPWR.n104 VAPWR.n103 0.113
R197 VAPWR.n103 VAPWR.n102 0.113
R198 VAPWR.n42 VAPWR.n31 0.113
R199 VAPWR.n66 VAPWR.n31 0.113
R200 VAPWR.n67 VAPWR.n66 0.113
R201 VAPWR.n68 VAPWR.n67 0.113
R202 VAPWR.n68 VAPWR.n19 0.113
R203 VAPWR.n85 VAPWR.n19 0.113
R204 VAPWR.n86 VAPWR.n85 0.113
R205 VAPWR.n88 VAPWR.n86 0.113
R206 VAPWR.n88 VAPWR.n87 0.113
R207 VAPWR.n87 VAPWR.n13 0.113
R208 VAPWR.n57 VAPWR.n37 0.113
R209 VAPWR.n53 VAPWR.n37 0.113
R210 VAPWR.n53 VAPWR.n52 0.113
R211 VAPWR.n52 VAPWR.n51 0.113
R212 VAPWR.n59 VAPWR.n58 0.023
R213 VAPWR.n59 VAPWR.n26 0.023
R214 VAPWR.n75 VAPWR.n26 0.023
R215 VAPWR.n78 VAPWR.n77 0.023
R216 VAPWR.n78 VAPWR.n0 0.023
R217 VAPWR.n114 VAPWR.n1 0.023
R218 VAPWR.n110 VAPWR.n109 0.023
R219 VAPWR.n7 VAPWR.n1 0.0205
R220 VAPWR.n115 VAPWR.n114 0.017375
R221 VAPWR.n77 VAPWR.n76 0.0155
R222 VAPWR.n76 VAPWR.n75 0.008
R223 VAPWR.n115 VAPWR.n0 0.006125
R224 VAPWR.n110 VAPWR.n7 0.003
R225 VDD.n11 VDD.t1 356.659
R226 VDD.n1 VDD.t3 356.659
R227 VDD.n78 VDD.n14 267
R228 VDD.n80 VDD.n22 267
R229 VDD.n55 VDD.n33 267
R230 VDD.n53 VDD.n36 267
R231 VDD.n53 VDD.n52 185
R232 VDD.n54 VDD.n53 185
R233 VDD.n37 VDD.n2 185
R234 VDD.n37 VDD.n35 185
R235 VDD.n101 VDD.n3 185
R236 VDD.n62 VDD.n3 185
R237 VDD.n100 VDD.n4 185
R238 VDD.n63 VDD.n4 185
R239 VDD.n64 VDD.n5 185
R240 VDD.n65 VDD.n64 185
R241 VDD.n96 VDD.n7 185
R242 VDD.n23 VDD.n7 185
R243 VDD.n95 VDD.n8 185
R244 VDD.n73 VDD.n8 185
R245 VDD.n94 VDD.n9 185
R246 VDD.n74 VDD.n9 185
R247 VDD.n78 VDD.n10 185
R248 VDD.n79 VDD.n78 185
R249 VDD.n38 VDD.n36 185
R250 VDD.n48 VDD.n41 185
R251 VDD.n47 VDD.n42 185
R252 VDD.n42 VDD.n34 185
R253 VDD.n46 VDD.n44 185
R254 VDD.n33 VDD.n32 185
R255 VDD.n81 VDD.n80 185
R256 VDD.n80 VDD.n79 185
R257 VDD.n21 VDD.n20 185
R258 VDD.n74 VDD.n21 185
R259 VDD.n72 VDD.n71 185
R260 VDD.n73 VDD.n72 185
R261 VDD.n25 VDD.n24 185
R262 VDD.n24 VDD.n23 185
R263 VDD.n67 VDD.n66 185
R264 VDD.n66 VDD.n65 185
R265 VDD.n28 VDD.n27 185
R266 VDD.n63 VDD.n28 185
R267 VDD.n61 VDD.n60 185
R268 VDD.n62 VDD.n61 185
R269 VDD.n30 VDD.n29 185
R270 VDD.n35 VDD.n29 185
R271 VDD.n56 VDD.n55 185
R272 VDD.n55 VDD.n54 185
R273 VDD.n22 VDD.n18 185
R274 VDD.n86 VDD.n17 185
R275 VDD.n87 VDD.n16 185
R276 VDD.n88 VDD.n15 185
R277 VDD.n89 VDD.n14 185
R278 VDD.n77 VDD.n14 185
R279 VDD.n15 VDD.n14 108.001
R280 VDD.n17 VDD.n16 108.001
R281 VDD.n55 VDD.n29 108.001
R282 VDD.n61 VDD.n29 108.001
R283 VDD.n61 VDD.n28 108.001
R284 VDD.n66 VDD.n28 108.001
R285 VDD.n66 VDD.n24 108.001
R286 VDD.n72 VDD.n24 108.001
R287 VDD.n72 VDD.n21 108.001
R288 VDD.n80 VDD.n21 108.001
R289 VDD.n42 VDD.n41 108.001
R290 VDD.n44 VDD.n42 108.001
R291 VDD.n53 VDD.n37 108.001
R292 VDD.n37 VDD.n3 108.001
R293 VDD.n4 VDD.n3 108.001
R294 VDD.n64 VDD.n4 108.001
R295 VDD.n64 VDD.n7 108.001
R296 VDD.n8 VDD.n7 108.001
R297 VDD.n9 VDD.n8 108.001
R298 VDD.n78 VDD.n9 108.001
R299 VDD.n54 VDD.n34 92.7386
R300 VDD.n79 VDD.n77 92.7386
R301 VDD.n54 VDD.n35 81.4291
R302 VDD.n63 VDD.n62 81.4291
R303 VDD.n65 VDD.n63 81.4291
R304 VDD.n65 VDD.n23 81.4291
R305 VDD.n73 VDD.n23 81.4291
R306 VDD.n79 VDD.n74 81.4291
R307 VDD.n40 VDD.n34 71.6014
R308 VDD.n43 VDD.n34 71.6014
R309 VDD.n77 VDD.n75 71.6014
R310 VDD.n77 VDD.n76 71.6014
R311 VDD.n35 VDD.t2 57.6791
R312 VDD.n74 VDD.t0 57.6791
R313 VDD.n76 VDD.n16 41.8002
R314 VDD.n75 VDD.n22 41.8002
R315 VDD.n40 VDD.n36 41.8002
R316 VDD.n44 VDD.n43 41.8002
R317 VDD.n41 VDD.n40 41.8002
R318 VDD.n43 VDD.n33 41.8002
R319 VDD.n75 VDD.n17 41.8002
R320 VDD.n76 VDD.n15 41.8002
R321 VDD.n52 VDD.n38 28.4805
R322 VDD.n89 VDD.n10 28.4805
R323 VDD.n56 VDD.n32 28.4805
R324 VDD.n81 VDD.n18 28.4805
R325 VDD.n62 VDD.t2 23.7505
R326 VDD.t0 VDD.n73 23.7505
R327 VDD.n52 VDD.n2 11.5205
R328 VDD.n101 VDD.n2 11.5205
R329 VDD.n101 VDD.n100 11.5205
R330 VDD.n100 VDD.n5 11.5205
R331 VDD.n96 VDD.n5 11.5205
R332 VDD.n96 VDD.n95 11.5205
R333 VDD.n95 VDD.n94 11.5205
R334 VDD.n94 VDD.n10 11.5205
R335 VDD.n48 VDD.n38 11.5205
R336 VDD.n48 VDD.n47 11.5205
R337 VDD.n47 VDD.n46 11.5205
R338 VDD.n46 VDD.n32 11.5205
R339 VDD.n56 VDD.n30 11.5205
R340 VDD.n60 VDD.n30 11.5205
R341 VDD.n60 VDD.n27 11.5205
R342 VDD.n67 VDD.n27 11.5205
R343 VDD.n67 VDD.n25 11.5205
R344 VDD.n71 VDD.n25 11.5205
R345 VDD.n71 VDD.n20 11.5205
R346 VDD.n81 VDD.n20 11.5205
R347 VDD.n89 VDD.n88 11.5205
R348 VDD.n88 VDD.n87 11.5205
R349 VDD.n87 VDD.n86 11.5205
R350 VDD.n86 VDD.n18 11.5205
R351 VDD.n84 VDD.n18 9.3005
R352 VDD.n86 VDD.n85 9.3005
R353 VDD.n87 VDD.n12 9.3005
R354 VDD.n88 VDD.n13 9.3005
R355 VDD.n90 VDD.n89 9.3005
R356 VDD.n82 VDD.n81 9.3005
R357 VDD.n20 VDD.n19 9.3005
R358 VDD.n71 VDD.n70 9.3005
R359 VDD.n69 VDD.n25 9.3005
R360 VDD.n68 VDD.n67 9.3005
R361 VDD.n27 VDD.n26 9.3005
R362 VDD.n60 VDD.n59 9.3005
R363 VDD.n58 VDD.n30 9.3005
R364 VDD.n57 VDD.n56 9.3005
R365 VDD.n50 VDD.n38 9.3005
R366 VDD.n49 VDD.n48 9.3005
R367 VDD.n47 VDD.n39 9.3005
R368 VDD.n46 VDD.n45 9.3005
R369 VDD.n32 VDD.n31 9.3005
R370 VDD.n52 VDD.n51 9.3005
R371 VDD.n2 VDD.n0 9.3005
R372 VDD.n102 VDD.n101 9.3005
R373 VDD.n100 VDD.n99 9.3005
R374 VDD.n98 VDD.n5 9.3005
R375 VDD.n97 VDD.n96 9.3005
R376 VDD.n95 VDD.n6 9.3005
R377 VDD.n94 VDD.n93 9.3005
R378 VDD.n92 VDD.n10 9.3005
R379 VDD.n91 VDD.n12 1.0005
R380 VDD.n83 VDD.n12 1.0005
R381 VDD.n84 VDD.n83 0.363938
R382 VDD.n91 VDD.n90 0.345187
R383 VDD.n57 VDD.n31 0.278625
R384 VDD.n90 VDD.n13 0.1805
R385 VDD.n13 VDD.n12 0.1805
R386 VDD.n85 VDD.n12 0.1805
R387 VDD.n85 VDD.n84 0.1805
R388 VDD.n51 VDD.n50 0.176125
R389 VDD VDD.n103 0.166671
R390 VDD.n58 VDD.n57 0.113
R391 VDD.n59 VDD.n58 0.113
R392 VDD.n59 VDD.n26 0.113
R393 VDD.n68 VDD.n26 0.113
R394 VDD.n69 VDD.n68 0.113
R395 VDD.n70 VDD.n69 0.113
R396 VDD.n70 VDD.n19 0.113
R397 VDD.n82 VDD.n19 0.113
R398 VDD.n50 VDD.n49 0.113
R399 VDD.n49 VDD.n39 0.113
R400 VDD.n45 VDD.n39 0.113
R401 VDD.n45 VDD.n31 0.113
R402 VDD.n83 VDD.n82 0.0895625
R403 VDD.n51 VDD.n0 0.023
R404 VDD.n99 VDD.n98 0.023
R405 VDD.n98 VDD.n97 0.023
R406 VDD.n97 VDD.n6 0.023
R407 VDD.n93 VDD.n92 0.023
R408 VDD.n103 VDD.n0 0.0226875
R409 VDD.n11 VDD.n6 0.021125
R410 VDD.n92 VDD.n91 0.0183125
R411 VDD.n99 VDD.n1 0.0155
R412 VDD.n102 VDD.n1 0.008
R413 VDD.n93 VDD.n11 0.002375
R414 VDD.n103 VDD.n102 0.0008125
R415 VSS.n136 VSS.n135 2072.02
R416 VSS.n39 VSS.n37 585
R417 VSS.n37 VSS.n35 585
R418 VSS.n126 VSS.n125 585
R419 VSS.n127 VSS.n126 585
R420 VSS.n48 VSS.n47 585
R421 VSS.n47 VSS.n46 585
R422 VSS.n120 VSS.n119 585
R423 VSS.n119 VSS.n118 585
R424 VSS.n51 VSS.n50 585
R425 VSS.n52 VSS.n51 585
R426 VSS.n105 VSS.n104 585
R427 VSS.n106 VSS.n105 585
R428 VSS.n61 VSS.n60 585
R429 VSS.n60 VSS.n59 585
R430 VSS.n100 VSS.n99 585
R431 VSS.n99 VSS.n98 585
R432 VSS.n64 VSS.n63 585
R433 VSS.n71 VSS.n64 585
R434 VSS.n88 VSS.n87 585
R435 VSS.n89 VSS.n88 585
R436 VSS.n73 VSS.n72 585
R437 VSS.n72 VSS.n70 585
R438 VSS.n83 VSS.n82 585
R439 VSS.n76 VSS.n75 585
R440 VSS.n79 VSS.n78 585
R441 VSS.n80 VSS.n79 585
R442 VSS.n131 VSS.n130 585
R443 VSS.n132 VSS.n38 585
R444 VSS.n134 VSS.n133 585
R445 VSS.n135 VSS.n134 585
R446 VSS.n129 VSS.n43 585
R447 VSS.n129 VSS.n35 585
R448 VSS.n128 VSS.n45 585
R449 VSS.n128 VSS.n127 585
R450 VSS.n55 VSS.n44 585
R451 VSS.n46 VSS.n44 585
R452 VSS.n117 VSS.n116 585
R453 VSS.n118 VSS.n117 585
R454 VSS.n54 VSS.n53 585
R455 VSS.n53 VSS.n52 585
R456 VSS.n108 VSS.n107 585
R457 VSS.n107 VSS.n106 585
R458 VSS.n58 VSS.n57 585
R459 VSS.n59 VSS.n58 585
R460 VSS.n97 VSS.n96 585
R461 VSS.n98 VSS.n97 585
R462 VSS.n66 VSS.n65 585
R463 VSS.n71 VSS.n65 585
R464 VSS.n91 VSS.n90 585
R465 VSS.n90 VSS.n89 585
R466 VSS.n69 VSS.n68 585
R467 VSS.n70 VSS.n69 585
R468 VSS.n31 VSS.n30 585
R469 VSS.n30 VSS.n29 585
R470 VSS.n145 VSS.n144 585
R471 VSS.n146 VSS.n145 585
R472 VSS.n28 VSS.n27 585
R473 VSS.n147 VSS.n28 585
R474 VSS.n151 VSS.n150 585
R475 VSS.n150 VSS.n149 585
R476 VSS.n25 VSS.n24 585
R477 VSS.n24 VSS.n23 585
R478 VSS.n156 VSS.n155 585
R479 VSS.n157 VSS.n156 585
R480 VSS.n22 VSS.n21 585
R481 VSS.n158 VSS.n22 585
R482 VSS.n162 VSS.n161 585
R483 VSS.n161 VSS.n160 585
R484 VSS.n19 VSS.n18 585
R485 VSS.n18 VSS.n17 585
R486 VSS.n172 VSS.n171 585
R487 VSS.n16 VSS.n15 585
R488 VSS.n168 VSS.n167 585
R489 VSS.n169 VSS.n168 585
R490 VSS.n173 VSS.n14 585
R491 VSS.n17 VSS.n14 585
R492 VSS.n159 VSS.n12 585
R493 VSS.n160 VSS.n159 585
R494 VSS.n178 VSS.n11 585
R495 VSS.n158 VSS.n11 585
R496 VSS.n179 VSS.n10 585
R497 VSS.n157 VSS.n10 585
R498 VSS.n180 VSS.n9 585
R499 VSS.n23 VSS.n9 585
R500 VSS.n148 VSS.n7 585
R501 VSS.n149 VSS.n148 585
R502 VSS.n185 VSS.n6 585
R503 VSS.n147 VSS.n6 585
R504 VSS.n186 VSS.n5 585
R505 VSS.n146 VSS.n5 585
R506 VSS.n187 VSS.n4 585
R507 VSS.n29 VSS.n4 585
R508 VSS.n140 VSS.n33 585
R509 VSS.n139 VSS.n138 585
R510 VSS.n34 VSS.n3 585
R511 VSS.n136 VSS.n34 585
R512 VSS.n168 VSS.n18 472.8
R513 VSS.n171 VSS.n14 472.8
R514 VSS.n34 VSS.n4 472.8
R515 VSS.n33 VSS.n30 472.8
R516 VSS.n134 VSS.n37 453.625
R517 VSS.n130 VSS.n129 453.625
R518 VSS.n79 VSS.n69 453.625
R519 VSS.n82 VSS.n72 453.625
R520 VSS.n81 VSS.n80 255.031
R521 VSS.n135 VSS.n36 255.031
R522 VSS.n170 VSS.n169 254.01
R523 VSS.n137 VSS.n136 254.01
R524 VSS.n136 VSS.n29 249.862
R525 VSS.n169 VSS.n17 249.862
R526 VSS.n80 VSS.n70 243.768
R527 VSS.n135 VSS.n35 243.768
R528 VSS.n183 VSS.t7 237.468
R529 VSS.n176 VSS.t1 237.468
R530 VSS.n94 VSS.t3 235.203
R531 VSS.n113 VSS.t5 235.203
R532 VSS.n89 VSS.n70 219.392
R533 VSS.n89 VSS.n71 219.392
R534 VSS.n98 VSS.n59 219.392
R535 VSS.n106 VSS.n59 219.392
R536 VSS.n106 VSS.n52 219.392
R537 VSS.n118 VSS.n52 219.392
R538 VSS.n127 VSS.n46 219.392
R539 VSS.n127 VSS.n35 219.392
R540 VSS.n146 VSS.n29 219.392
R541 VSS.n149 VSS.n147 219.392
R542 VSS.n149 VSS.n23 219.392
R543 VSS.n157 VSS.n23 219.392
R544 VSS.n158 VSS.n157 219.392
R545 VSS.n160 VSS.n17 219.392
R546 VSS.n168 VSS.n16 177.3
R547 VSS.n5 VSS.n4 177.3
R548 VSS.n6 VSS.n5 177.3
R549 VSS.n148 VSS.n6 177.3
R550 VSS.n148 VSS.n9 177.3
R551 VSS.n10 VSS.n9 177.3
R552 VSS.n11 VSS.n10 177.3
R553 VSS.n159 VSS.n11 177.3
R554 VSS.n159 VSS.n14 177.3
R555 VSS.n138 VSS.n34 177.3
R556 VSS.n145 VSS.n30 177.3
R557 VSS.n145 VSS.n28 177.3
R558 VSS.n150 VSS.n28 177.3
R559 VSS.n150 VSS.n24 177.3
R560 VSS.n156 VSS.n24 177.3
R561 VSS.n156 VSS.n22 177.3
R562 VSS.n161 VSS.n22 177.3
R563 VSS.n161 VSS.n18 177.3
R564 VSS.n134 VSS.n38 171.9
R565 VSS.n90 VSS.n69 171.9
R566 VSS.n90 VSS.n65 171.9
R567 VSS.n97 VSS.n65 171.9
R568 VSS.n97 VSS.n58 171.9
R569 VSS.n107 VSS.n58 171.9
R570 VSS.n107 VSS.n53 171.9
R571 VSS.n117 VSS.n53 171.9
R572 VSS.n117 VSS.n44 171.9
R573 VSS.n128 VSS.n44 171.9
R574 VSS.n129 VSS.n128 171.9
R575 VSS.n79 VSS.n76 171.9
R576 VSS.n88 VSS.n72 171.9
R577 VSS.n88 VSS.n64 171.9
R578 VSS.n99 VSS.n64 171.9
R579 VSS.n99 VSS.n60 171.9
R580 VSS.n105 VSS.n60 171.9
R581 VSS.n105 VSS.n51 171.9
R582 VSS.n119 VSS.n51 171.9
R583 VSS.n119 VSS.n47 171.9
R584 VSS.n126 VSS.n47 171.9
R585 VSS.n126 VSS.n37 171.9
R586 VSS.n98 VSS.t2 170.637
R587 VSS.n118 VSS.t4 170.637
R588 VSS.t6 VSS.n146 155.403
R589 VSS.n160 VSS.t0 155.403
R590 VSS.n171 VSS.n170 76.985
R591 VSS.n137 VSS.n33 76.985
R592 VSS.n170 VSS.n16 76.985
R593 VSS.n138 VSS.n137 76.985
R594 VSS.n130 VSS.n36 74.9406
R595 VSS.n82 VSS.n81 74.9406
R596 VSS.n81 VSS.n76 74.9406
R597 VSS.n38 VSS.n36 74.9406
R598 VSS.n147 VSS.t6 63.9894
R599 VSS.t0 VSS.n158 63.9894
R600 VSS.n71 VSS.t2 48.754
R601 VSS.t4 VSS.n46 48.754
R602 VSS.n140 VSS.n31 30.7205
R603 VSS.n167 VSS.n19 30.7205
R604 VSS.n173 VSS.n172 30.7205
R605 VSS.n187 VSS.n3 30.7205
R606 VSS.n133 VSS.n39 30.4005
R607 VSS.n131 VSS.n43 30.4005
R608 VSS.n78 VSS.n68 30.4005
R609 VSS.n83 VSS.n73 30.4005
R610 VSS.n133 VSS.n132 11.5205
R611 VSS.n132 VSS.n131 11.5205
R612 VSS.n91 VSS.n68 11.5205
R613 VSS.n91 VSS.n66 11.5205
R614 VSS.n96 VSS.n66 11.5205
R615 VSS.n96 VSS.n57 11.5205
R616 VSS.n108 VSS.n57 11.5205
R617 VSS.n108 VSS.n54 11.5205
R618 VSS.n116 VSS.n54 11.5205
R619 VSS.n116 VSS.n55 11.5205
R620 VSS.n55 VSS.n45 11.5205
R621 VSS.n45 VSS.n43 11.5205
R622 VSS.n83 VSS.n75 11.5205
R623 VSS.n78 VSS.n75 11.5205
R624 VSS.n87 VSS.n73 11.5205
R625 VSS.n87 VSS.n63 11.5205
R626 VSS.n100 VSS.n63 11.5205
R627 VSS.n100 VSS.n61 11.5205
R628 VSS.n104 VSS.n61 11.5205
R629 VSS.n104 VSS.n50 11.5205
R630 VSS.n120 VSS.n50 11.5205
R631 VSS.n120 VSS.n48 11.5205
R632 VSS.n125 VSS.n48 11.5205
R633 VSS.n125 VSS.n39 11.5205
R634 VSS.n144 VSS.n31 11.5205
R635 VSS.n144 VSS.n27 11.5205
R636 VSS.n151 VSS.n27 11.5205
R637 VSS.n151 VSS.n25 11.5205
R638 VSS.n155 VSS.n25 11.5205
R639 VSS.n155 VSS.n21 11.5205
R640 VSS.n162 VSS.n21 11.5205
R641 VSS.n162 VSS.n19 11.5205
R642 VSS.n167 VSS.n15 11.5205
R643 VSS.n172 VSS.n15 11.5205
R644 VSS.n187 VSS.n186 11.5205
R645 VSS.n186 VSS.n185 11.5205
R646 VSS.n185 VSS.n7 11.5205
R647 VSS.n180 VSS.n7 11.5205
R648 VSS.n180 VSS.n179 11.5205
R649 VSS.n179 VSS.n178 11.5205
R650 VSS.n178 VSS.n12 11.5205
R651 VSS.n173 VSS.n12 11.5205
R652 VSS.n140 VSS.n139 11.5205
R653 VSS.n139 VSS.n3 11.5205
R654 VSS.n167 VSS.n166 9.35465
R655 VSS.n172 VSS.n13 9.35285
R656 VSS.n131 VSS.n42 9.3005
R657 VSS.n132 VSS.n41 9.3005
R658 VSS.n133 VSS.n40 9.3005
R659 VSS.n84 VSS.n83 9.3005
R660 VSS.n75 VSS.n74 9.3005
R661 VSS.n78 VSS.n77 9.3005
R662 VSS.n85 VSS.n73 9.3005
R663 VSS.n87 VSS.n86 9.3005
R664 VSS.n63 VSS.n62 9.3005
R665 VSS.n101 VSS.n100 9.3005
R666 VSS.n102 VSS.n61 9.3005
R667 VSS.n104 VSS.n103 9.3005
R668 VSS.n50 VSS.n49 9.3005
R669 VSS.n121 VSS.n120 9.3005
R670 VSS.n122 VSS.n48 9.3005
R671 VSS.n125 VSS.n124 9.3005
R672 VSS.n123 VSS.n39 9.3005
R673 VSS.n165 VSS.n15 9.3005
R674 VSS.n141 VSS.n140 9.3005
R675 VSS.n139 VSS.n32 9.3005
R676 VSS.n3 VSS.n1 9.3005
R677 VSS.n142 VSS.n31 9.3005
R678 VSS.n144 VSS.n143 9.3005
R679 VSS.n27 VSS.n26 9.3005
R680 VSS.n152 VSS.n151 9.3005
R681 VSS.n153 VSS.n25 9.3005
R682 VSS.n155 VSS.n154 9.3005
R683 VSS.n21 VSS.n20 9.3005
R684 VSS.n163 VSS.n162 9.3005
R685 VSS.n164 VSS.n19 9.3005
R686 VSS.n92 VSS.n91 9.3005
R687 VSS.n93 VSS.n66 9.3005
R688 VSS.n96 VSS.n95 9.3005
R689 VSS.n57 VSS.n56 9.3005
R690 VSS.n109 VSS.n108 9.3005
R691 VSS.n110 VSS.n54 9.3005
R692 VSS.n116 VSS.n115 9.3005
R693 VSS.n114 VSS.n55 9.3005
R694 VSS.n112 VSS.n45 9.3005
R695 VSS.n111 VSS.n43 9.3005
R696 VSS.n68 VSS.n67 9.3005
R697 VSS.n174 VSS.n173 9.3005
R698 VSS.n175 VSS.n12 9.3005
R699 VSS.n178 VSS.n177 9.3005
R700 VSS.n179 VSS.n8 9.3005
R701 VSS.n181 VSS.n180 9.3005
R702 VSS.n182 VSS.n7 9.3005
R703 VSS.n185 VSS.n184 9.3005
R704 VSS.n186 VSS.n2 9.3005
R705 VSS.n188 VSS.n187 9.3005
R706 VSS.n166 VSS.n164 0.316091
R707 VSS.n142 VSS.n141 0.3005
R708 VSS.n85 VSS.n84 0.297375
R709 VSS.n123 VSS.n40 0.297375
R710 VSS.n174 VSS.n13 0.237269
R711 VSS.n77 VSS.n67 0.197375
R712 VSS VSS.n190 0.1847
R713 VSS.n42 VSS.n0 0.172375
R714 VSS.n189 VSS.n1 0.172375
R715 VSS.n190 VSS.n189 0.145813
R716 VSS.n84 VSS.n74 0.113
R717 VSS.n77 VSS.n74 0.113
R718 VSS.n86 VSS.n85 0.113
R719 VSS.n86 VSS.n62 0.113
R720 VSS.n101 VSS.n62 0.113
R721 VSS.n102 VSS.n101 0.113
R722 VSS.n103 VSS.n102 0.113
R723 VSS.n103 VSS.n49 0.113
R724 VSS.n121 VSS.n49 0.113
R725 VSS.n122 VSS.n121 0.113
R726 VSS.n124 VSS.n122 0.113
R727 VSS.n124 VSS.n123 0.113
R728 VSS.n41 VSS.n40 0.113
R729 VSS.n42 VSS.n41 0.113
R730 VSS.n141 VSS.n32 0.113
R731 VSS.n32 VSS.n1 0.113
R732 VSS.n143 VSS.n142 0.113
R733 VSS.n143 VSS.n26 0.113
R734 VSS.n152 VSS.n26 0.113
R735 VSS.n153 VSS.n152 0.113
R736 VSS.n154 VSS.n153 0.113
R737 VSS.n154 VSS.n20 0.113
R738 VSS.n163 VSS.n20 0.113
R739 VSS.n164 VSS.n163 0.113
R740 VSS.n165 VSS.n13 0.104564
R741 VSS.n166 VSS.n165 0.103112
R742 VSS.n190 VSS.n0 0.0676875
R743 VSS.n189 VSS.n188 0.026125
R744 VSS.n111 VSS.n0 0.0255
R745 VSS.n92 VSS.n67 0.023
R746 VSS.n93 VSS.n92 0.023
R747 VSS.n95 VSS.n93 0.023
R748 VSS.n109 VSS.n56 0.023
R749 VSS.n110 VSS.n109 0.023
R750 VSS.n115 VSS.n110 0.023
R751 VSS.n115 VSS.n114 0.023
R752 VSS.n112 VSS.n111 0.023
R753 VSS.n188 VSS.n2 0.023
R754 VSS.n184 VSS.n2 0.023
R755 VSS.n182 VSS.n181 0.023
R756 VSS.n181 VSS.n8 0.023
R757 VSS.n177 VSS.n8 0.023
R758 VSS.n175 VSS.n174 0.023
R759 VSS.n177 VSS.n176 0.021125
R760 VSS.n114 VSS.n113 0.0205
R761 VSS.n94 VSS.n56 0.0155
R762 VSS.n183 VSS.n182 0.0155
R763 VSS.n95 VSS.n94 0.008
R764 VSS.n184 VSS.n183 0.008
R765 VSS.n113 VSS.n112 0.003
R766 VSS.n176 VSS.n175 0.002375
C0 VAPWR VDD 0.45261f
C1 in VDD 0.4173f
C2 VAPWR ctrl_n 0.01813f
C3 B A 1.09092f
C4 in ctrl_n 0.00208f
C5 B ctrl 0.08333f
C6 A ctrl 0.45155f
C7 in VAPWR 0
C8 B VDD 0.00646f
C9 A VDD 0.00147f
C10 B ctrl_n 0.27142f
C11 ctrl_n A 0.38231f
C12 VDD ctrl 0.86013f
C13 ctrl_n ctrl 1.23711f
C14 B VAPWR 0.90191f
C15 VAPWR A 0.69488f
C16 B in 0.00516f
C17 in A 0
C18 ctrl_n VDD 0.45013f
C19 VAPWR ctrl 0.0853f
C20 in ctrl 0.77276f
C21 A VSS 0.79918f
C22 B VSS 0.85149f
C23 in VSS 0.86415f
C24 VAPWR VSS 5.14483f
C25 VDD VSS 4.56616f
C26 ctrl_n VSS 1.39877f
C27 ctrl VSS 1.53474f
C28 VDD.n0 VSS 0.02324f
C29 VDD.t3 VSS 0.00849f
C30 VDD.n1 VSS 0.02814f
C31 VDD.n2 VSS 0.00468f
C32 VDD.n3 VSS 0.00468f
C33 VDD.n4 VSS 0.00468f
C34 VDD.n5 VSS 0.00468f
C35 VDD.n6 VSS 0.02243f
C36 VDD.n7 VSS 0.00468f
C37 VDD.n8 VSS 0.00468f
C38 VDD.n9 VSS 0.00468f
C39 VDD.n10 VSS 0.00953f
C40 VDD.t1 VSS 0.00849f
C41 VDD.n11 VSS 0.02814f
C42 VDD.n12 VSS 0.00878f
C43 VDD.n13 VSS 0.00293f
C44 VDD.n14 VSS 0.00932f
C45 VDD.n15 VSS 0.00468f
C46 VDD.n16 VSS 0.00468f
C47 VDD.n17 VSS 0.00468f
C48 VDD.n18 VSS 0.00932f
C49 VDD.n19 VSS 0.00468f
C50 VDD.n20 VSS 0.00468f
C51 VDD.n21 VSS 0.00468f
C52 VDD.n22 VSS 0.00932f
C53 VDD.n23 VSS 0.04915f
C54 VDD.n24 VSS 0.00468f
C55 VDD.n25 VSS 0.00468f
C56 VDD.n26 VSS 0.00468f
C57 VDD.n27 VSS 0.00468f
C58 VDD.n28 VSS 0.00468f
C59 VDD.t2 VSS 0.02457f
C60 VDD.n29 VSS 0.00468f
C61 VDD.n30 VSS 0.00468f
C62 VDD.n31 VSS 0.00932f
C63 VDD.n32 VSS 0.00932f
C64 VDD.n33 VSS 0.00932f
C65 VDD.n34 VSS 0.12356f
C66 VDD.n35 VSS 0.04198f
C67 VDD.n36 VSS 0.00932f
C68 VDD.n37 VSS 0.00468f
C69 VDD.n38 VSS 0.00932f
C70 VDD.n39 VSS 0.00468f
C71 VDD.n41 VSS 0.00468f
C72 VDD.n42 VSS 0.00468f
C73 VDD.n44 VSS 0.00468f
C74 VDD.n45 VSS 0.00468f
C75 VDD.n46 VSS 0.00468f
C76 VDD.n47 VSS 0.00468f
C77 VDD.n48 VSS 0.00468f
C78 VDD.n49 VSS 0.00468f
C79 VDD.n50 VSS 0.02114f
C80 VDD.n51 VSS 0.11681f
C81 VDD.n52 VSS 0.00953f
C82 VDD.n53 VSS 0.00953f
C83 VDD.n54 VSS 0.05256f
C84 VDD.n55 VSS 0.00953f
C85 VDD.n56 VSS 0.00953f
C86 VDD.n57 VSS 0.00953f
C87 VDD.n58 VSS 0.00468f
C88 VDD.n59 VSS 0.00468f
C89 VDD.n60 VSS 0.00468f
C90 VDD.n61 VSS 0.00468f
C91 VDD.n62 VSS 0.03174f
C92 VDD.n63 VSS 0.04915f
C93 VDD.n64 VSS 0.00468f
C94 VDD.n65 VSS 0.04915f
C95 VDD.n66 VSS 0.00468f
C96 VDD.n67 VSS 0.00468f
C97 VDD.n68 VSS 0.00468f
C98 VDD.n69 VSS 0.00468f
C99 VDD.n70 VSS 0.00468f
C100 VDD.n71 VSS 0.00468f
C101 VDD.n72 VSS 0.00468f
C102 VDD.n73 VSS 0.03174f
C103 VDD.t0 VSS 0.02457f
C104 VDD.n74 VSS 0.04198f
C105 VDD.n77 VSS 0.12356f
C106 VDD.n78 VSS 0.00953f
C107 VDD.n79 VSS 0.05256f
C108 VDD.n80 VSS 0.00953f
C109 VDD.n81 VSS 0.00953f
C110 VDD.n82 VSS 0.00419f
C111 VDD.n83 VSS 0.00983f
C112 VDD.n84 VSS 0.00454f
C113 VDD.n85 VSS 0.00293f
C114 VDD.n86 VSS 0.00468f
C115 VDD.n87 VSS 0.00468f
C116 VDD.n88 VSS 0.00468f
C117 VDD.n89 VSS 0.00932f
C118 VDD.n90 VSS 0.00432f
C119 VDD.n91 VSS 0.02136f
C120 VDD.n92 VSS 0.02097f
C121 VDD.n93 VSS 0.01268f
C122 VDD.n94 VSS 0.00468f
C123 VDD.n95 VSS 0.00468f
C124 VDD.n96 VSS 0.00468f
C125 VDD.n97 VSS 0.0234f
C126 VDD.n98 VSS 0.0234f
C127 VDD.n99 VSS 0.0195f
C128 VDD.n100 VSS 0.00468f
C129 VDD.n101 VSS 0.00468f
C130 VDD.n102 VSS 0.00406f
C131 VDD.n103 VSS 0.32915f
C132 VAPWR.n0 VSS 0.01224f
C133 VAPWR.n1 VSS 0.0185f
C134 VAPWR.n2 VSS 0.00392f
C135 VAPWR.n3 VSS 0.00392f
C136 VAPWR.n4 VSS 0.00392f
C137 VAPWR.n5 VSS 0.00392f
C138 VAPWR.n6 VSS 0.00793f
C139 VAPWR.t3 VSS 0.00319f
C140 VAPWR.n7 VSS 0.02876f
C141 VAPWR.n8 VSS 0.00392f
C142 VAPWR.n9 VSS 0.00774f
C143 VAPWR.n10 VSS 0.00392f
C144 VAPWR.n11 VSS 0.00392f
C145 VAPWR.n12 VSS 0.00392f
C146 VAPWR.n13 VSS 0.00793f
C147 VAPWR.n14 VSS 0.00774f
C148 VAPWR.n15 VSS 0.00392f
C149 VAPWR.n16 VSS 0.00392f
C150 VAPWR.t2 VSS 0.02057f
C151 VAPWR.n17 VSS 0.00392f
C152 VAPWR.n18 VSS 0.00392f
C153 VAPWR.n19 VSS 0.00392f
C154 VAPWR.n20 VSS 0.00392f
C155 VAPWR.n21 VSS 0.00392f
C156 VAPWR.n22 VSS 0.04114f
C157 VAPWR.n23 VSS 0.03657f
C158 VAPWR.n24 VSS 0.00392f
C159 VAPWR.n25 VSS 0.00392f
C160 VAPWR.t1 VSS 0.00319f
C161 VAPWR.n26 VSS 0.01959f
C162 VAPWR.n27 VSS 0.00392f
C163 VAPWR.n28 VSS 0.00392f
C164 VAPWR.t0 VSS 0.02057f
C165 VAPWR.n29 VSS 0.00392f
C166 VAPWR.n30 VSS 0.00392f
C167 VAPWR.n31 VSS 0.00392f
C168 VAPWR.n32 VSS 0.00392f
C169 VAPWR.n33 VSS 0.00392f
C170 VAPWR.n34 VSS 0.04342f
C171 VAPWR.n35 VSS 0.00793f
C172 VAPWR.n36 VSS 0.00793f
C173 VAPWR.n37 VSS 0.00392f
C174 VAPWR.n38 VSS 0.00774f
C175 VAPWR.n39 VSS 0.00392f
C176 VAPWR.n40 VSS 0.00392f
C177 VAPWR.n41 VSS 0.00392f
C178 VAPWR.n42 VSS 0.00793f
C179 VAPWR.n43 VSS 0.00392f
C180 VAPWR.n45 VSS 0.10285f
C181 VAPWR.n47 VSS 0.00774f
C182 VAPWR.n48 VSS 0.00793f
C183 VAPWR.n49 VSS 0.00793f
C184 VAPWR.n50 VSS 0.00774f
C185 VAPWR.n51 VSS 0.00774f
C186 VAPWR.n52 VSS 0.00392f
C187 VAPWR.n53 VSS 0.00392f
C188 VAPWR.n54 VSS 0.00392f
C189 VAPWR.n55 VSS 0.00392f
C190 VAPWR.n56 VSS 0.00774f
C191 VAPWR.n57 VSS 0.01039f
C192 VAPWR.n58 VSS 0.05557f
C193 VAPWR.n59 VSS 0.01959f
C194 VAPWR.n60 VSS 0.00392f
C195 VAPWR.n61 VSS 0.00392f
C196 VAPWR.n62 VSS 0.04114f
C197 VAPWR.n63 VSS 0.02514f
C198 VAPWR.n64 VSS 0.00392f
C199 VAPWR.n65 VSS 0.00392f
C200 VAPWR.n66 VSS 0.00392f
C201 VAPWR.n67 VSS 0.00392f
C202 VAPWR.n68 VSS 0.00392f
C203 VAPWR.n69 VSS 0.00392f
C204 VAPWR.n70 VSS 0.00392f
C205 VAPWR.n71 VSS 0.04114f
C206 VAPWR.n72 VSS 0.03657f
C207 VAPWR.n73 VSS 0.00392f
C208 VAPWR.n74 VSS 0.00392f
C209 VAPWR.n75 VSS 0.01306f
C210 VAPWR.n76 VSS 0.02876f
C211 VAPWR.n77 VSS 0.01632f
C212 VAPWR.n78 VSS 0.01959f
C213 VAPWR.n79 VSS 0.00392f
C214 VAPWR.n80 VSS 0.00392f
C215 VAPWR.n81 VSS 0.00392f
C216 VAPWR.n82 VSS 0.04114f
C217 VAPWR.n83 VSS 0.00392f
C218 VAPWR.n84 VSS 0.00392f
C219 VAPWR.n85 VSS 0.00392f
C220 VAPWR.n86 VSS 0.00392f
C221 VAPWR.n87 VSS 0.00392f
C222 VAPWR.n88 VSS 0.00392f
C223 VAPWR.n89 VSS 0.00392f
C224 VAPWR.n90 VSS 0.00392f
C225 VAPWR.n91 VSS 0.02514f
C226 VAPWR.n92 VSS 0.04114f
C227 VAPWR.n93 VSS 0.00392f
C228 VAPWR.n96 VSS 0.10285f
C229 VAPWR.n97 VSS 0.00793f
C230 VAPWR.n98 VSS 0.04342f
C231 VAPWR.n99 VSS 0.00793f
C232 VAPWR.n100 VSS 0.00793f
C233 VAPWR.n101 VSS 0.00774f
C234 VAPWR.n102 VSS 0.00774f
C235 VAPWR.n103 VSS 0.00392f
C236 VAPWR.n104 VSS 0.00392f
C237 VAPWR.n105 VSS 0.00392f
C238 VAPWR.n106 VSS 0.00392f
C239 VAPWR.n107 VSS 0.00774f
C240 VAPWR.n108 VSS 0.01738f
C241 VAPWR.n109 VSS 0.09754f
C242 VAPWR.n110 VSS 0.01088f
C243 VAPWR.n111 VSS 0.00392f
C244 VAPWR.n112 VSS 0.00392f
C245 VAPWR.n113 VSS 0.00392f
C246 VAPWR.n114 VSS 0.01714f
C247 VAPWR.n115 VSS 0.38722f
C248 in.t1 VSS 0.06418f
C249 in.t0 VSS 0.04186f
C250 in.n0 VSS 0.86057f
C251 B.t2 VSS 0.1332f
C252 B.t0 VSS 0.04687f
C253 B.t1 VSS 0.04861f
C254 B.n0 VSS 1.04349f
C255 B.n1 VSS 0.91121f
C256 A.t0 VSS 0.05044f
C257 A.t1 VSS 0.05012f
C258 A.n0 VSS 1.12171f
C259 A.t2 VSS 0.14546f
C260 A.n1 VSS 1.0196f
.ends
