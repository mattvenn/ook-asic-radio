* tx_ls_en: magic R+C extraction of layout/tx_ls_en.gds (layout/pex.sh)
.subckt tx_ls_en in A B VDD VAPWR VSS
X0 A.t0 B.t2 VAPWR.t3 VAPWR.t2 sky130_fd_pr__pfet_g5v0d10v5 ad=0.126 pd=1.44 as=0.126 ps=1.44 w=0.42 l=0.5
X1 ctrl_n ctrl VSS.t7 VSS.t6 sky130_fd_pr__nfet_01v8 ad=0.504 pd=3.96 as=0.504 ps=3.96 w=1.68 l=0.15
X2 VDD.t5 ctrl ctrl_n VDD.t4 sky130_fd_pr__pfet_01v8_hvt ad=0.6 pd=4.6 as=0.3 ps=2.3 w=2 l=0.15
X3 ctrl_n ctrl VDD.t3 VDD.t2 sky130_fd_pr__pfet_01v8_hvt ad=0.3 pd=2.3 as=0.6 ps=4.6 w=2 l=0.15
X4 A.t1 ctrl VSS.t5 VSS.t4 sky130_fd_pr__nfet_g5v0d10v5 ad=0.126 pd=1.44 as=0.126 ps=1.44 w=0.42 l=0.5
X5 ctrl in.t0 VSS.t1 VSS.t0 sky130_fd_pr__nfet_01v8 ad=0.126 pd=1.44 as=0.126 ps=1.44 w=0.42 l=0.15
X6 ctrl in.t1 VDD.t1 VDD.t0 sky130_fd_pr__pfet_01v8 ad=0.3 pd=2.6 as=0.3 ps=2.6 w=1 l=0.15
X7 B.t0 A.t2 VAPWR.t1 VAPWR.t0 sky130_fd_pr__pfet_g5v0d10v5 ad=0.126 pd=1.44 as=0.126 ps=1.44 w=0.42 l=0.5
X8 B.t1 ctrl_n VSS.t3 VSS.t2 sky130_fd_pr__nfet_g5v0d10v5 ad=0.126 pd=1.44 as=0.126 ps=1.44 w=0.42 l=0.5
R0 A.n0 A.t0 665.415
R1 A.n0 A.t1 237.291
R2 A.n1 A.t2 220.01
R3 A.n1 A.n0 1.82585
R4 A A.n1 0.122129
R5 B.n0 B.t0 664.818
R6 B.n0 B.t1 237.861
R7 B.n1 B.t2 219.583
R8 B.n1 B.n0 0.853
R9 B B.n1 0.037756
R10 in.n0 in.t1 417.45
R11 in.n0 in.t0 326.365
R12 in.n1 in.n0 0.874049
R13 in.n1 in 0.03575
R14 in in.n1 0.0221258
R15 VAPWR.n7 VAPWR.t3 663.143
R16 VAPWR.n103 VAPWR.t1 663.143
R17 VAPWR.n119 VAPWR.n9 236.55
R18 VAPWR.n22 VAPWR.n20 236.55
R19 VAPWR.n64 VAPWR.n63 236.55
R20 VAPWR.n45 VAPWR.n42 236.55
R21 VAPWR.n43 VAPWR.n42 185
R22 VAPWR.n42 VAPWR.n41 185
R23 VAPWR.n85 VAPWR.n84 185
R24 VAPWR.n86 VAPWR.n85 185
R25 VAPWR.n33 VAPWR.n32 185
R26 VAPWR.n87 VAPWR.n33 185
R27 VAPWR.n101 VAPWR.n100 185
R28 VAPWR.n100 VAPWR.n99 185
R29 VAPWR.n30 VAPWR.n29 185
R30 VAPWR.n98 VAPWR.n29 185
R31 VAPWR.n107 VAPWR.n106 185
R32 VAPWR.n107 VAPWR.n27 185
R33 VAPWR.n108 VAPWR.n2 185
R34 VAPWR.n109 VAPWR.n108 185
R35 VAPWR.n148 VAPWR.n3 185
R36 VAPWR.n110 VAPWR.n3 185
R37 VAPWR.n147 VAPWR.n4 185
R38 VAPWR.n122 VAPWR.n4 185
R39 VAPWR.n146 VAPWR.n5 185
R40 VAPWR.n121 VAPWR.n5 185
R41 VAPWR.n119 VAPWR.n6 185
R42 VAPWR.n120 VAPWR.n119 185
R43 VAPWR.n80 VAPWR.n45 185
R44 VAPWR.n79 VAPWR.n46 185
R45 VAPWR.n78 VAPWR.n47 185
R46 VAPWR.n62 VAPWR.n47 185
R47 VAPWR.n56 VAPWR.n48 185
R48 VAPWR.n74 VAPWR.n50 185
R49 VAPWR.n73 VAPWR.n51 185
R50 VAPWR.n72 VAPWR.n52 185
R51 VAPWR.n59 VAPWR.n53 185
R52 VAPWR.n68 VAPWR.n55 185
R53 VAPWR.n67 VAPWR.n63 185
R54 VAPWR.n63 VAPWR.n62 185
R55 VAPWR.n128 VAPWR.n22 185
R56 VAPWR.n120 VAPWR.n22 185
R57 VAPWR.n26 VAPWR.n21 185
R58 VAPWR.n121 VAPWR.n26 185
R59 VAPWR.n124 VAPWR.n123 185
R60 VAPWR.n123 VAPWR.n122 185
R61 VAPWR.n25 VAPWR.n24 185
R62 VAPWR.n110 VAPWR.n25 185
R63 VAPWR.n92 VAPWR.n28 185
R64 VAPWR.n109 VAPWR.n28 185
R65 VAPWR.n37 VAPWR.n35 185
R66 VAPWR.n35 VAPWR.n27 185
R67 VAPWR.n97 VAPWR.n96 185
R68 VAPWR.n98 VAPWR.n97 185
R69 VAPWR.n36 VAPWR.n34 185
R70 VAPWR.n99 VAPWR.n34 185
R71 VAPWR.n89 VAPWR.n88 185
R72 VAPWR.n88 VAPWR.n87 185
R73 VAPWR.n40 VAPWR.n39 185
R74 VAPWR.n86 VAPWR.n40 185
R75 VAPWR.n66 VAPWR.n64 185
R76 VAPWR.n64 VAPWR.n41 185
R77 VAPWR.n129 VAPWR.n20 185
R78 VAPWR.n130 VAPWR.n19 185
R79 VAPWR.n115 VAPWR.n17 185
R80 VAPWR.n134 VAPWR.n16 185
R81 VAPWR.n135 VAPWR.n15 185
R82 VAPWR.n136 VAPWR.n14 185
R83 VAPWR.n112 VAPWR.n12 185
R84 VAPWR.n140 VAPWR.n11 185
R85 VAPWR.n141 VAPWR.n10 185
R86 VAPWR.n142 VAPWR.n9 185
R87 VAPWR.n11 VAPWR.n10 102.6
R88 VAPWR.n112 VAPWR.n14 102.6
R89 VAPWR.n16 VAPWR.n15 102.6
R90 VAPWR.n115 VAPWR.n19 102.6
R91 VAPWR.n64 VAPWR.n40 102.6
R92 VAPWR.n88 VAPWR.n40 102.6
R93 VAPWR.n88 VAPWR.n34 102.6
R94 VAPWR.n97 VAPWR.n34 102.6
R95 VAPWR.n97 VAPWR.n35 102.6
R96 VAPWR.n35 VAPWR.n28 102.6
R97 VAPWR.n28 VAPWR.n25 102.6
R98 VAPWR.n123 VAPWR.n25 102.6
R99 VAPWR.n123 VAPWR.n26 102.6
R100 VAPWR.n26 VAPWR.n22 102.6
R101 VAPWR.n47 VAPWR.n46 102.6
R102 VAPWR.n56 VAPWR.n47 102.6
R103 VAPWR.n51 VAPWR.n50 102.6
R104 VAPWR.n59 VAPWR.n52 102.6
R105 VAPWR.n63 VAPWR.n55 102.6
R106 VAPWR.n85 VAPWR.n42 102.6
R107 VAPWR.n85 VAPWR.n33 102.6
R108 VAPWR.n100 VAPWR.n33 102.6
R109 VAPWR.n100 VAPWR.n29 102.6
R110 VAPWR.n107 VAPWR.n29 102.6
R111 VAPWR.n108 VAPWR.n107 102.6
R112 VAPWR.n108 VAPWR.n3 102.6
R113 VAPWR.n4 VAPWR.n3 102.6
R114 VAPWR.n5 VAPWR.n4 102.6
R115 VAPWR.n119 VAPWR.n5 102.6
R116 VAPWR.n62 VAPWR.n61 72.4195
R117 VAPWR.n62 VAPWR.n57 72.4195
R118 VAPWR.n62 VAPWR.n58 72.4195
R119 VAPWR.n62 VAPWR.n60 72.4195
R120 VAPWR.n118 VAPWR.n117 72.4195
R121 VAPWR.n118 VAPWR.n116 72.4195
R122 VAPWR.n118 VAPWR.n114 72.4195
R123 VAPWR.n118 VAPWR.n113 72.4195
R124 VAPWR.n118 VAPWR.n111 72.4195
R125 VAPWR.n62 VAPWR.n41 64.4073
R126 VAPWR.n120 VAPWR.n118 64.4073
R127 VAPWR.n86 VAPWR.n41 57.9666
R128 VAPWR.n87 VAPWR.n86 57.9666
R129 VAPWR.n99 VAPWR.n98 57.9666
R130 VAPWR.n98 VAPWR.n27 57.9666
R131 VAPWR.n109 VAPWR.n27 57.9666
R132 VAPWR.n110 VAPWR.n109 57.9666
R133 VAPWR.n122 VAPWR.n121 57.9666
R134 VAPWR.n121 VAPWR.n120 57.9666
R135 VAPWR.n99 VAPWR.t0 45.0852
R136 VAPWR.t2 VAPWR.n110 45.0852
R137 VAPWR.n111 VAPWR.n10 40.1639
R138 VAPWR.n113 VAPWR.n112 40.1639
R139 VAPWR.n114 VAPWR.n15 40.1639
R140 VAPWR.n116 VAPWR.n115 40.1639
R141 VAPWR.n117 VAPWR.n20 40.1639
R142 VAPWR.n61 VAPWR.n45 40.1639
R143 VAPWR.n57 VAPWR.n56 40.1639
R144 VAPWR.n58 VAPWR.n51 40.1639
R145 VAPWR.n60 VAPWR.n59 40.1639
R146 VAPWR.n61 VAPWR.n46 40.1639
R147 VAPWR.n57 VAPWR.n50 40.1639
R148 VAPWR.n58 VAPWR.n52 40.1639
R149 VAPWR.n60 VAPWR.n55 40.1639
R150 VAPWR.n117 VAPWR.n19 40.1639
R151 VAPWR.n116 VAPWR.n16 40.1639
R152 VAPWR.n114 VAPWR.n14 40.1639
R153 VAPWR.n113 VAPWR.n11 40.1639
R154 VAPWR.n111 VAPWR.n9 40.1639
R155 VAPWR.n80 VAPWR.n43 26.5605
R156 VAPWR.n142 VAPWR.n6 26.5605
R157 VAPWR.n67 VAPWR.n66 26.5605
R158 VAPWR.n129 VAPWR.n128 26.5605
R159 VAPWR.n87 VAPWR.t0 12.8819
R160 VAPWR.n122 VAPWR.t2 12.8819
R161 VAPWR.n84 VAPWR.n43 11.5205
R162 VAPWR.n84 VAPWR.n32 11.5205
R163 VAPWR.n101 VAPWR.n32 11.5205
R164 VAPWR.n101 VAPWR.n30 11.5205
R165 VAPWR.n106 VAPWR.n30 11.5205
R166 VAPWR.n106 VAPWR.n2 11.5205
R167 VAPWR.n148 VAPWR.n2 11.5205
R168 VAPWR.n148 VAPWR.n147 11.5205
R169 VAPWR.n147 VAPWR.n146 11.5205
R170 VAPWR.n146 VAPWR.n6 11.5205
R171 VAPWR.n80 VAPWR.n79 11.5205
R172 VAPWR.n79 VAPWR.n78 11.5205
R173 VAPWR.n78 VAPWR.n48 11.5205
R174 VAPWR.n74 VAPWR.n48 11.5205
R175 VAPWR.n74 VAPWR.n73 11.5205
R176 VAPWR.n73 VAPWR.n72 11.5205
R177 VAPWR.n72 VAPWR.n53 11.5205
R178 VAPWR.n68 VAPWR.n53 11.5205
R179 VAPWR.n68 VAPWR.n67 11.5205
R180 VAPWR.n66 VAPWR.n39 11.5205
R181 VAPWR.n89 VAPWR.n39 11.5205
R182 VAPWR.n89 VAPWR.n36 11.5205
R183 VAPWR.n96 VAPWR.n36 11.5205
R184 VAPWR.n96 VAPWR.n37 11.5205
R185 VAPWR.n92 VAPWR.n37 11.5205
R186 VAPWR.n92 VAPWR.n24 11.5205
R187 VAPWR.n124 VAPWR.n24 11.5205
R188 VAPWR.n124 VAPWR.n21 11.5205
R189 VAPWR.n128 VAPWR.n21 11.5205
R190 VAPWR.n142 VAPWR.n141 11.5205
R191 VAPWR.n141 VAPWR.n140 11.5205
R192 VAPWR.n140 VAPWR.n12 11.5205
R193 VAPWR.n136 VAPWR.n12 11.5205
R194 VAPWR.n136 VAPWR.n135 11.5205
R195 VAPWR.n135 VAPWR.n134 11.5205
R196 VAPWR.n134 VAPWR.n17 11.5205
R197 VAPWR.n130 VAPWR.n17 11.5205
R198 VAPWR.n130 VAPWR.n129 11.5205
R199 VAPWR.n129 VAPWR.n18 9.3005
R200 VAPWR.n131 VAPWR.n130 9.3005
R201 VAPWR.n132 VAPWR.n17 9.3005
R202 VAPWR.n134 VAPWR.n133 9.3005
R203 VAPWR.n135 VAPWR.n13 9.3005
R204 VAPWR.n137 VAPWR.n136 9.3005
R205 VAPWR.n138 VAPWR.n12 9.3005
R206 VAPWR.n140 VAPWR.n139 9.3005
R207 VAPWR.n141 VAPWR.n8 9.3005
R208 VAPWR.n143 VAPWR.n142 9.3005
R209 VAPWR.n128 VAPWR.n127 9.3005
R210 VAPWR.n126 VAPWR.n21 9.3005
R211 VAPWR.n125 VAPWR.n124 9.3005
R212 VAPWR.n24 VAPWR.n23 9.3005
R213 VAPWR.n93 VAPWR.n92 9.3005
R214 VAPWR.n94 VAPWR.n37 9.3005
R215 VAPWR.n96 VAPWR.n95 9.3005
R216 VAPWR.n91 VAPWR.n36 9.3005
R217 VAPWR.n90 VAPWR.n89 9.3005
R218 VAPWR.n39 VAPWR.n38 9.3005
R219 VAPWR.n66 VAPWR.n65 9.3005
R220 VAPWR.n81 VAPWR.n80 9.3005
R221 VAPWR.n79 VAPWR.n44 9.3005
R222 VAPWR.n78 VAPWR.n77 9.3005
R223 VAPWR.n76 VAPWR.n48 9.3005
R224 VAPWR.n75 VAPWR.n74 9.3005
R225 VAPWR.n73 VAPWR.n49 9.3005
R226 VAPWR.n72 VAPWR.n71 9.3005
R227 VAPWR.n70 VAPWR.n53 9.3005
R228 VAPWR.n69 VAPWR.n68 9.3005
R229 VAPWR.n67 VAPWR.n54 9.3005
R230 VAPWR.n82 VAPWR.n43 9.3005
R231 VAPWR.n84 VAPWR.n83 9.3005
R232 VAPWR.n32 VAPWR.n31 9.3005
R233 VAPWR.n102 VAPWR.n101 9.3005
R234 VAPWR.n104 VAPWR.n30 9.3005
R235 VAPWR.n106 VAPWR.n105 9.3005
R236 VAPWR.n2 VAPWR.n0 9.3005
R237 VAPWR.n149 VAPWR.n148 9.3005
R238 VAPWR.n147 VAPWR.n1 9.3005
R239 VAPWR.n146 VAPWR.n145 9.3005
R240 VAPWR.n144 VAPWR.n6 9.3005
R241 VAPWR.n127 VAPWR.n18 0.259875
R242 VAPWR.n65 VAPWR.n54 0.259875
R243 VAPWR.n144 VAPWR.n143 0.159875
R244 VAPWR.n82 VAPWR.n81 0.159875
R245 VAPWR VAPWR.n150 0.159465
R246 VAPWR.n143 VAPWR.n8 0.113
R247 VAPWR.n139 VAPWR.n8 0.113
R248 VAPWR.n139 VAPWR.n138 0.113
R249 VAPWR.n138 VAPWR.n137 0.113
R250 VAPWR.n137 VAPWR.n13 0.113
R251 VAPWR.n133 VAPWR.n13 0.113
R252 VAPWR.n133 VAPWR.n132 0.113
R253 VAPWR.n132 VAPWR.n131 0.113
R254 VAPWR.n131 VAPWR.n18 0.113
R255 VAPWR.n65 VAPWR.n38 0.113
R256 VAPWR.n90 VAPWR.n38 0.113
R257 VAPWR.n91 VAPWR.n90 0.113
R258 VAPWR.n95 VAPWR.n91 0.113
R259 VAPWR.n95 VAPWR.n94 0.113
R260 VAPWR.n94 VAPWR.n93 0.113
R261 VAPWR.n93 VAPWR.n23 0.113
R262 VAPWR.n125 VAPWR.n23 0.113
R263 VAPWR.n126 VAPWR.n125 0.113
R264 VAPWR.n127 VAPWR.n126 0.113
R265 VAPWR.n81 VAPWR.n44 0.113
R266 VAPWR.n77 VAPWR.n44 0.113
R267 VAPWR.n77 VAPWR.n76 0.113
R268 VAPWR.n76 VAPWR.n75 0.113
R269 VAPWR.n75 VAPWR.n49 0.113
R270 VAPWR.n71 VAPWR.n49 0.113
R271 VAPWR.n71 VAPWR.n70 0.113
R272 VAPWR.n70 VAPWR.n69 0.113
R273 VAPWR.n69 VAPWR.n54 0.113
R274 VAPWR.n83 VAPWR.n82 0.023
R275 VAPWR.n83 VAPWR.n31 0.023
R276 VAPWR.n102 VAPWR.n31 0.023
R277 VAPWR.n105 VAPWR.n104 0.023
R278 VAPWR.n105 VAPWR.n0 0.023
R279 VAPWR.n149 VAPWR.n1 0.023
R280 VAPWR.n145 VAPWR.n144 0.023
R281 VAPWR.n7 VAPWR.n1 0.0205
R282 VAPWR.n150 VAPWR.n149 0.017375
R283 VAPWR.n104 VAPWR.n103 0.0155
R284 VAPWR.n103 VAPWR.n102 0.008
R285 VAPWR.n150 VAPWR.n0 0.006125
R286 VAPWR.n145 VAPWR.n7 0.003
R287 VDD.n136 VDD.t1 357.123
R288 VDD.n110 VDD.n13 265.5
R289 VDD.n28 VDD.n23 265.5
R290 VDD.n79 VDD.n40 265.5
R291 VDD.n76 VDD.n37 265.5
R292 VDD.n51 VDD.n37 185
R293 VDD.n39 VDD.n37 185
R294 VDD.n88 VDD.n38 185
R295 VDD.n88 VDD.n87 185
R296 VDD.n89 VDD.n2 185
R297 VDD.n90 VDD.n89 185
R298 VDD.n145 VDD.n3 185
R299 VDD.n91 VDD.n3 185
R300 VDD.n144 VDD.n4 185
R301 VDD.n92 VDD.n4 185
R302 VDD.n29 VDD.n5 185
R303 VDD.n30 VDD.n29 185
R304 VDD.n140 VDD.n7 185
R305 VDD.n100 VDD.n7 185
R306 VDD.n139 VDD.n8 185
R307 VDD.n101 VDD.n8 185
R308 VDD.n138 VDD.n9 185
R309 VDD.n112 VDD.n9 185
R310 VDD.n110 VDD.n10 185
R311 VDD.n111 VDD.n110 185
R312 VDD.n76 VDD.n75 185
R313 VDD.n52 VDD.n50 185
R314 VDD.n71 VDD.n49 185
R315 VDD.n78 VDD.n49 185
R316 VDD.n70 VDD.n57 185
R317 VDD.n69 VDD.n58 185
R318 VDD.n60 VDD.n59 185
R319 VDD.n65 VDD.n62 185
R320 VDD.n64 VDD.n63 185
R321 VDD.n45 VDD.n44 185
R322 VDD.n80 VDD.n79 185
R323 VDD.n79 VDD.n78 185
R324 VDD.n28 VDD.n24 185
R325 VDD.n111 VDD.n28 185
R326 VDD.n114 VDD.n113 185
R327 VDD.n113 VDD.n112 185
R328 VDD.n27 VDD.n26 185
R329 VDD.n101 VDD.n27 185
R330 VDD.n99 VDD.n98 185
R331 VDD.n100 VDD.n99 185
R332 VDD.n32 VDD.n31 185
R333 VDD.n31 VDD.n30 185
R334 VDD.n94 VDD.n93 185
R335 VDD.n93 VDD.n92 185
R336 VDD.n35 VDD.n34 185
R337 VDD.n91 VDD.n35 185
R338 VDD.n42 VDD.n36 185
R339 VDD.n90 VDD.n36 185
R340 VDD.n86 VDD.n85 185
R341 VDD.n87 VDD.n86 185
R342 VDD.n41 VDD.n40 185
R343 VDD.n40 VDD.n39 185
R344 VDD.n119 VDD.n23 185
R345 VDD.n120 VDD.n22 185
R346 VDD.n121 VDD.n21 185
R347 VDD.n106 VDD.n19 185
R348 VDD.n125 VDD.n18 185
R349 VDD.n126 VDD.n17 185
R350 VDD.n103 VDD.n16 185
R351 VDD.n130 VDD.n15 185
R352 VDD.n131 VDD.n14 185
R353 VDD.n132 VDD.n13 185
R354 VDD.n1 VDD.t3 134.185
R355 VDD.n54 VDD.t5 134.185
R356 VDD.n15 VDD.n14 108.001
R357 VDD.n103 VDD.n17 108.001
R358 VDD.n106 VDD.n18 108.001
R359 VDD.n22 VDD.n21 108.001
R360 VDD.n86 VDD.n40 108.001
R361 VDD.n86 VDD.n36 108.001
R362 VDD.n36 VDD.n35 108.001
R363 VDD.n93 VDD.n35 108.001
R364 VDD.n93 VDD.n31 108.001
R365 VDD.n99 VDD.n31 108.001
R366 VDD.n99 VDD.n27 108.001
R367 VDD.n113 VDD.n27 108.001
R368 VDD.n113 VDD.n28 108.001
R369 VDD.n50 VDD.n49 108.001
R370 VDD.n57 VDD.n49 108.001
R371 VDD.n59 VDD.n58 108.001
R372 VDD.n63 VDD.n62 108.001
R373 VDD.n79 VDD.n45 108.001
R374 VDD.n88 VDD.n37 108.001
R375 VDD.n89 VDD.n88 108.001
R376 VDD.n89 VDD.n3 108.001
R377 VDD.n4 VDD.n3 108.001
R378 VDD.n29 VDD.n4 108.001
R379 VDD.n29 VDD.n7 108.001
R380 VDD.n8 VDD.n7 108.001
R381 VDD.n9 VDD.n8 108.001
R382 VDD.n110 VDD.n9 108.001
R383 VDD.n78 VDD.n39 73.2632
R384 VDD.n111 VDD.n109 73.2632
R385 VDD.n78 VDD.n77 71.6014
R386 VDD.n78 VDD.n46 71.6014
R387 VDD.n78 VDD.n47 71.6014
R388 VDD.n78 VDD.n48 71.6014
R389 VDD.n109 VDD.n108 71.6014
R390 VDD.n109 VDD.n107 71.6014
R391 VDD.n109 VDD.n105 71.6014
R392 VDD.n109 VDD.n104 71.6014
R393 VDD.n109 VDD.n102 71.6014
R394 VDD.n87 VDD.n39 57.9666
R395 VDD.n92 VDD.n91 57.9666
R396 VDD.n92 VDD.n30 57.9666
R397 VDD.n100 VDD.n30 57.9666
R398 VDD.n101 VDD.n100 57.9666
R399 VDD.n112 VDD.n111 57.9666
R400 VDD.t2 VDD.n90 48.3056
R401 VDD.n102 VDD.n14 41.8002
R402 VDD.n104 VDD.n103 41.8002
R403 VDD.n105 VDD.n18 41.8002
R404 VDD.n107 VDD.n21 41.8002
R405 VDD.n108 VDD.n23 41.8002
R406 VDD.n77 VDD.n76 41.8002
R407 VDD.n57 VDD.n46 41.8002
R408 VDD.n59 VDD.n47 41.8002
R409 VDD.n63 VDD.n48 41.8002
R410 VDD.n77 VDD.n50 41.8002
R411 VDD.n58 VDD.n46 41.8002
R412 VDD.n62 VDD.n47 41.8002
R413 VDD.n48 VDD.n45 41.8002
R414 VDD.n108 VDD.n22 41.8002
R415 VDD.n107 VDD.n106 41.8002
R416 VDD.n105 VDD.n17 41.8002
R417 VDD.n104 VDD.n15 41.8002
R418 VDD.n102 VDD.n13 41.8002
R419 VDD.n87 VDD.t4 33.8141
R420 VDD.n112 VDD.t0 33.8141
R421 VDD.n75 VDD.n51 28.3205
R422 VDD.n132 VDD.n10 28.3205
R423 VDD.n80 VDD.n41 28.3205
R424 VDD.n119 VDD.n24 28.3205
R425 VDD.n90 VDD.t4 24.153
R426 VDD.t0 VDD.n101 24.153
R427 VDD.n51 VDD.n38 11.5205
R428 VDD.n38 VDD.n2 11.5205
R429 VDD.n145 VDD.n2 11.5205
R430 VDD.n145 VDD.n144 11.5205
R431 VDD.n144 VDD.n5 11.5205
R432 VDD.n140 VDD.n5 11.5205
R433 VDD.n140 VDD.n139 11.5205
R434 VDD.n139 VDD.n138 11.5205
R435 VDD.n138 VDD.n10 11.5205
R436 VDD.n75 VDD.n52 11.5205
R437 VDD.n71 VDD.n52 11.5205
R438 VDD.n71 VDD.n70 11.5205
R439 VDD.n70 VDD.n69 11.5205
R440 VDD.n69 VDD.n60 11.5205
R441 VDD.n65 VDD.n60 11.5205
R442 VDD.n65 VDD.n64 11.5205
R443 VDD.n64 VDD.n44 11.5205
R444 VDD.n80 VDD.n44 11.5205
R445 VDD.n85 VDD.n41 11.5205
R446 VDD.n85 VDD.n42 11.5205
R447 VDD.n42 VDD.n34 11.5205
R448 VDD.n94 VDD.n34 11.5205
R449 VDD.n94 VDD.n32 11.5205
R450 VDD.n98 VDD.n32 11.5205
R451 VDD.n98 VDD.n26 11.5205
R452 VDD.n114 VDD.n26 11.5205
R453 VDD.n114 VDD.n24 11.5205
R454 VDD.n132 VDD.n131 11.5205
R455 VDD.n131 VDD.n130 11.5205
R456 VDD.n130 VDD.n16 11.5205
R457 VDD.n126 VDD.n16 11.5205
R458 VDD.n126 VDD.n125 11.5205
R459 VDD.n125 VDD.n19 11.5205
R460 VDD.n121 VDD.n19 11.5205
R461 VDD.n121 VDD.n120 11.5205
R462 VDD.n120 VDD.n119 11.5205
R463 VDD.n91 VDD.t2 9.66152
R464 VDD.n119 VDD.n118 9.3005
R465 VDD.n120 VDD.n20 9.3005
R466 VDD.n122 VDD.n121 9.3005
R467 VDD.n123 VDD.n19 9.3005
R468 VDD.n125 VDD.n124 9.3005
R469 VDD.n127 VDD.n126 9.3005
R470 VDD.n128 VDD.n16 9.3005
R471 VDD.n130 VDD.n129 9.3005
R472 VDD.n131 VDD.n12 9.3005
R473 VDD.n133 VDD.n132 9.3005
R474 VDD.n116 VDD.n24 9.3005
R475 VDD.n115 VDD.n114 9.3005
R476 VDD.n26 VDD.n25 9.3005
R477 VDD.n98 VDD.n97 9.3005
R478 VDD.n96 VDD.n32 9.3005
R479 VDD.n95 VDD.n94 9.3005
R480 VDD.n34 VDD.n33 9.3005
R481 VDD.n83 VDD.n42 9.3005
R482 VDD.n85 VDD.n84 9.3005
R483 VDD.n82 VDD.n41 9.3005
R484 VDD.n75 VDD.n74 9.3005
R485 VDD.n73 VDD.n52 9.3005
R486 VDD.n72 VDD.n71 9.3005
R487 VDD.n70 VDD.n56 9.3005
R488 VDD.n69 VDD.n68 9.3005
R489 VDD.n67 VDD.n60 9.3005
R490 VDD.n66 VDD.n65 9.3005
R491 VDD.n64 VDD.n61 9.3005
R492 VDD.n44 VDD.n43 9.3005
R493 VDD.n81 VDD.n80 9.3005
R494 VDD.n55 VDD.n51 9.3005
R495 VDD.n53 VDD.n38 9.3005
R496 VDD.n2 VDD.n0 9.3005
R497 VDD.n146 VDD.n145 9.3005
R498 VDD.n144 VDD.n143 9.3005
R499 VDD.n142 VDD.n5 9.3005
R500 VDD.n141 VDD.n140 9.3005
R501 VDD.n139 VDD.n6 9.3005
R502 VDD.n138 VDD.n137 9.3005
R503 VDD.n135 VDD.n10 9.3005
R504 VDD.n134 VDD.n11 1.70883
R505 VDD.n117 VDD.n11 1.70883
R506 VDD.n118 VDD.n117 0.338937
R507 VDD.n134 VDD.n133 0.320187
R508 VDD.n82 VDD.n81 0.277063
R509 VDD.n133 VDD.n12 0.1805
R510 VDD.n129 VDD.n12 0.1805
R511 VDD.n129 VDD.n128 0.1805
R512 VDD.n128 VDD.n127 0.1805
R513 VDD.n124 VDD.n123 0.1805
R514 VDD.n123 VDD.n122 0.1805
R515 VDD.n122 VDD.n20 0.1805
R516 VDD.n118 VDD.n20 0.1805
R517 VDD.n74 VDD.n55 0.163313
R518 VDD VDD.n147 0.161704
R519 VDD.n84 VDD.n82 0.113
R520 VDD.n84 VDD.n83 0.113
R521 VDD.n83 VDD.n33 0.113
R522 VDD.n95 VDD.n33 0.113
R523 VDD.n96 VDD.n95 0.113
R524 VDD.n97 VDD.n96 0.113
R525 VDD.n97 VDD.n25 0.113
R526 VDD.n115 VDD.n25 0.113
R527 VDD.n116 VDD.n115 0.113
R528 VDD.n74 VDD.n73 0.113
R529 VDD.n73 VDD.n72 0.113
R530 VDD.n72 VDD.n56 0.113
R531 VDD.n68 VDD.n56 0.113
R532 VDD.n68 VDD.n67 0.113
R533 VDD.n67 VDD.n66 0.113
R534 VDD.n66 VDD.n61 0.113
R535 VDD.n61 VDD.n43 0.113
R536 VDD.n81 VDD.n43 0.113
R537 VDD.n117 VDD.n116 0.103625
R538 VDD.n127 VDD.n11 0.0905
R539 VDD.n124 VDD.n11 0.0905
R540 VDD.n53 VDD.n0 0.023
R541 VDD.n143 VDD.n142 0.023
R542 VDD.n142 VDD.n141 0.023
R543 VDD.n141 VDD.n6 0.023
R544 VDD.n137 VDD.n6 0.023
R545 VDD.n55 VDD.n54 0.0220625
R546 VDD.n136 VDD.n135 0.0220625
R547 VDD.n135 VDD.n134 0.021125
R548 VDD.n143 VDD.n1 0.0126875
R549 VDD.n147 VDD.n146 0.0120625
R550 VDD.n147 VDD.n0 0.0114375
R551 VDD.n146 VDD.n1 0.0108125
R552 VDD.n54 VDD.n53 0.0014375
R553 VDD.n137 VDD.n136 0.0014375
R554 VSS.n191 VSS.n171 1764.15
R555 VSS.n49 VSS.n47 585
R556 VSS.n47 VSS.n43 585
R557 VSS.n154 VSS.n153 585
R558 VSS.n155 VSS.n154 585
R559 VSS.n62 VSS.n61 585
R560 VSS.n61 VSS.n60 585
R561 VSS.n148 VSS.n147 585
R562 VSS.n147 VSS.n146 585
R563 VSS.n65 VSS.n64 585
R564 VSS.n66 VSS.n65 585
R565 VSS.n133 VSS.n132 585
R566 VSS.n134 VSS.n133 585
R567 VSS.n75 VSS.n74 585
R568 VSS.n74 VSS.n73 585
R569 VSS.n128 VSS.n127 585
R570 VSS.n127 VSS.n126 585
R571 VSS.n78 VSS.n77 585
R572 VSS.n85 VSS.n78 585
R573 VSS.n116 VSS.n115 585
R574 VSS.n117 VSS.n116 585
R575 VSS.n87 VSS.n86 585
R576 VSS.n86 VSS.n84 585
R577 VSS.n111 VSS.n110 585
R578 VSS.n90 VSS.n89 585
R579 VSS.n107 VSS.n106 585
R580 VSS.n108 VSS.n107 585
R581 VSS.n105 VSS.n93 585
R582 VSS.n104 VSS.n103 585
R583 VSS.n102 VSS.n101 585
R584 VSS.n100 VSS.n99 585
R585 VSS.n159 VSS.n158 585
R586 VSS.n161 VSS.n160 585
R587 VSS.n163 VSS.n162 585
R588 VSS.n165 VSS.n164 585
R589 VSS.n167 VSS.n166 585
R590 VSS.n168 VSS.n48 585
R591 VSS.n170 VSS.n169 585
R592 VSS.n171 VSS.n170 585
R593 VSS.n157 VSS.n57 585
R594 VSS.n157 VSS.n43 585
R595 VSS.n156 VSS.n59 585
R596 VSS.n156 VSS.n155 585
R597 VSS.n69 VSS.n58 585
R598 VSS.n60 VSS.n58 585
R599 VSS.n145 VSS.n144 585
R600 VSS.n146 VSS.n145 585
R601 VSS.n68 VSS.n67 585
R602 VSS.n67 VSS.n66 585
R603 VSS.n136 VSS.n135 585
R604 VSS.n135 VSS.n134 585
R605 VSS.n72 VSS.n71 585
R606 VSS.n73 VSS.n72 585
R607 VSS.n125 VSS.n124 585
R608 VSS.n126 VSS.n125 585
R609 VSS.n80 VSS.n79 585
R610 VSS.n85 VSS.n79 585
R611 VSS.n119 VSS.n118 585
R612 VSS.n118 VSS.n117 585
R613 VSS.n83 VSS.n82 585
R614 VSS.n84 VSS.n83 585
R615 VSS.n194 VSS.n193 585
R616 VSS.n193 VSS.n192 585
R617 VSS.n39 VSS.n38 585
R618 VSS.n38 VSS.n37 585
R619 VSS.n199 VSS.n198 585
R620 VSS.n200 VSS.n199 585
R621 VSS.n36 VSS.n35 585
R622 VSS.n202 VSS.n36 585
R623 VSS.n205 VSS.n204 585
R624 VSS.n204 VSS.n203 585
R625 VSS.n33 VSS.n32 585
R626 VSS.n32 VSS.n31 585
R627 VSS.n210 VSS.n209 585
R628 VSS.n211 VSS.n210 585
R629 VSS.n30 VSS.n29 585
R630 VSS.n213 VSS.n30 585
R631 VSS.n216 VSS.n215 585
R632 VSS.n215 VSS.n214 585
R633 VSS.n26 VSS.n24 585
R634 VSS.n24 VSS.n21 585
R635 VSS.n230 VSS.n16 585
R636 VSS.n233 VSS.n232 585
R637 VSS.n20 VSS.n19 585
R638 VSS.n222 VSS.n221 585
R639 VSS.n223 VSS.n220 585
R640 VSS.n27 VSS.n25 585
R641 VSS.n228 VSS.n227 585
R642 VSS.n229 VSS.n228 585
R643 VSS.n238 VSS.n15 585
R644 VSS.n21 VSS.n15 585
R645 VSS.n239 VSS.n14 585
R646 VSS.n214 VSS.n14 585
R647 VSS.n212 VSS.n12 585
R648 VSS.n213 VSS.n212 585
R649 VSS.n243 VSS.n11 585
R650 VSS.n211 VSS.n11 585
R651 VSS.n244 VSS.n10 585
R652 VSS.n31 VSS.n10 585
R653 VSS.n245 VSS.n9 585
R654 VSS.n203 VSS.n9 585
R655 VSS.n201 VSS.n7 585
R656 VSS.n202 VSS.n201 585
R657 VSS.n250 VSS.n6 585
R658 VSS.n200 VSS.n6 585
R659 VSS.n251 VSS.n5 585
R660 VSS.n37 VSS.n5 585
R661 VSS.n252 VSS.n4 585
R662 VSS.n192 VSS.n4 585
R663 VSS.n42 VSS.n41 585
R664 VSS.n189 VSS.n188 585
R665 VSS.n176 VSS.n175 585
R666 VSS.n191 VSS.n175 585
R667 VSS.n184 VSS.n178 585
R668 VSS.n183 VSS.n179 585
R669 VSS.n182 VSS.n180 585
R670 VSS.n173 VSS.n3 585
R671 VSS.n228 VSS.n24 450.639
R672 VSS.n230 VSS.n15 450.639
R673 VSS.n173 VSS.n4 450.639
R674 VSS.n193 VSS.n42 450.639
R675 VSS.n170 VSS.n47 410.651
R676 VSS.n158 VSS.n157 410.651
R677 VSS.n99 VSS.n83 410.651
R678 VSS.n110 VSS.n86 410.651
R679 VSS.n109 VSS.n108 255.031
R680 VSS.n108 VSS.n91 255.031
R681 VSS.n108 VSS.n92 255.031
R682 VSS.n171 VSS.n44 255.031
R683 VSS.n171 VSS.n45 255.031
R684 VSS.n171 VSS.n46 255.031
R685 VSS.n231 VSS.n229 254.01
R686 VSS.n229 VSS.n22 254.01
R687 VSS.n229 VSS.n23 254.01
R688 VSS.n191 VSS.n190 254.01
R689 VSS.n191 VSS.n172 254.01
R690 VSS.n191 VSS.n174 254.01
R691 VSS.n13 VSS.t1 238.052
R692 VSS.n192 VSS.n191 236.085
R693 VSS.n229 VSS.n21 236.085
R694 VSS.n122 VSS.t3 235.554
R695 VSS.n141 VSS.t5 235.554
R696 VSS.n108 VSS.n84 207.548
R697 VSS.n171 VSS.n43 207.548
R698 VSS.n117 VSS.n84 186.792
R699 VSS.n117 VSS.n85 186.792
R700 VSS.n126 VSS.n73 186.792
R701 VSS.n134 VSS.n73 186.792
R702 VSS.n134 VSS.n66 186.792
R703 VSS.n146 VSS.n66 186.792
R704 VSS.n155 VSS.n60 186.792
R705 VSS.n155 VSS.n43 186.792
R706 VSS.n192 VSS.n37 186.792
R707 VSS.n200 VSS.n37 186.792
R708 VSS.n203 VSS.n202 186.792
R709 VSS.n203 VSS.n31 186.792
R710 VSS.n211 VSS.n31 186.792
R711 VSS.n213 VSS.n211 186.792
R712 VSS.n214 VSS.n21 186.792
R713 VSS.n228 VSS.n25 177.3
R714 VSS.n221 VSS.n220 177.3
R715 VSS.n232 VSS.n20 177.3
R716 VSS.n5 VSS.n4 177.3
R717 VSS.n6 VSS.n5 177.3
R718 VSS.n201 VSS.n6 177.3
R719 VSS.n201 VSS.n9 177.3
R720 VSS.n10 VSS.n9 177.3
R721 VSS.n11 VSS.n10 177.3
R722 VSS.n212 VSS.n11 177.3
R723 VSS.n212 VSS.n14 177.3
R724 VSS.n15 VSS.n14 177.3
R725 VSS.n189 VSS.n175 177.3
R726 VSS.n178 VSS.n175 177.3
R727 VSS.n180 VSS.n179 177.3
R728 VSS.n193 VSS.n38 177.3
R729 VSS.n199 VSS.n38 177.3
R730 VSS.n199 VSS.n36 177.3
R731 VSS.n204 VSS.n36 177.3
R732 VSS.n204 VSS.n32 177.3
R733 VSS.n210 VSS.n32 177.3
R734 VSS.n210 VSS.n30 177.3
R735 VSS.n215 VSS.n30 177.3
R736 VSS.n215 VSS.n24 177.3
R737 VSS.n170 VSS.n48 171.9
R738 VSS.n166 VSS.n165 171.9
R739 VSS.n162 VSS.n161 171.9
R740 VSS.n118 VSS.n83 171.9
R741 VSS.n118 VSS.n79 171.9
R742 VSS.n125 VSS.n79 171.9
R743 VSS.n125 VSS.n72 171.9
R744 VSS.n135 VSS.n72 171.9
R745 VSS.n135 VSS.n67 171.9
R746 VSS.n145 VSS.n67 171.9
R747 VSS.n145 VSS.n58 171.9
R748 VSS.n156 VSS.n58 171.9
R749 VSS.n157 VSS.n156 171.9
R750 VSS.n107 VSS.n90 171.9
R751 VSS.n107 VSS.n93 171.9
R752 VSS.n103 VSS.n102 171.9
R753 VSS.n116 VSS.n86 171.9
R754 VSS.n116 VSS.n78 171.9
R755 VSS.n127 VSS.n78 171.9
R756 VSS.n127 VSS.n74 171.9
R757 VSS.n133 VSS.n74 171.9
R758 VSS.n133 VSS.n65 171.9
R759 VSS.n147 VSS.n65 171.9
R760 VSS.n147 VSS.n61 171.9
R761 VSS.n154 VSS.n61 171.9
R762 VSS.n154 VSS.n47 171.9
R763 VSS.t6 VSS.n200 155.661
R764 VSS.n126 VSS.t2 145.284
R765 VSS.n146 VSS.t4 145.284
R766 VSS.n214 VSS.t0 108.963
R767 VSS.n247 VSS.t7 98.1504
R768 VSS.t0 VSS.n213 77.8307
R769 VSS.n220 VSS.n23 76.985
R770 VSS.n22 VSS.n20 76.985
R771 VSS.n231 VSS.n230 76.985
R772 VSS.n190 VSS.n42 76.985
R773 VSS.n178 VSS.n172 76.985
R774 VSS.n180 VSS.n174 76.985
R775 VSS.n232 VSS.n231 76.985
R776 VSS.n221 VSS.n22 76.985
R777 VSS.n25 VSS.n23 76.985
R778 VSS.n190 VSS.n189 76.985
R779 VSS.n179 VSS.n172 76.985
R780 VSS.n174 VSS.n173 76.985
R781 VSS.n166 VSS.n46 74.9406
R782 VSS.n162 VSS.n45 74.9406
R783 VSS.n158 VSS.n44 74.9406
R784 VSS.n110 VSS.n109 74.9406
R785 VSS.n93 VSS.n91 74.9406
R786 VSS.n102 VSS.n92 74.9406
R787 VSS.n109 VSS.n90 74.9406
R788 VSS.n103 VSS.n91 74.9406
R789 VSS.n99 VSS.n92 74.9406
R790 VSS.n161 VSS.n44 74.9406
R791 VSS.n165 VSS.n45 74.9406
R792 VSS.n48 VSS.n46 74.9406
R793 VSS.n85 VSS.t2 41.5099
R794 VSS.t4 VSS.n60 41.5099
R795 VSS.n202 VSS.t6 31.1326
R796 VSS.n194 VSS.n41 29.2805
R797 VSS.n227 VSS.n26 29.2805
R798 VSS.n238 VSS.n16 29.2805
R799 VSS.n252 VSS.n3 29.2805
R800 VSS.n169 VSS.n49 27.5205
R801 VSS.n159 VSS.n57 27.5205
R802 VSS.n100 VSS.n82 27.5205
R803 VSS.n111 VSS.n87 27.5205
R804 VSS.n169 VSS.n168 11.5205
R805 VSS.n168 VSS.n167 11.5205
R806 VSS.n167 VSS.n164 11.5205
R807 VSS.n164 VSS.n163 11.5205
R808 VSS.n163 VSS.n160 11.5205
R809 VSS.n160 VSS.n159 11.5205
R810 VSS.n119 VSS.n82 11.5205
R811 VSS.n119 VSS.n80 11.5205
R812 VSS.n124 VSS.n80 11.5205
R813 VSS.n124 VSS.n71 11.5205
R814 VSS.n136 VSS.n71 11.5205
R815 VSS.n136 VSS.n68 11.5205
R816 VSS.n144 VSS.n68 11.5205
R817 VSS.n144 VSS.n69 11.5205
R818 VSS.n69 VSS.n59 11.5205
R819 VSS.n59 VSS.n57 11.5205
R820 VSS.n111 VSS.n89 11.5205
R821 VSS.n106 VSS.n89 11.5205
R822 VSS.n106 VSS.n105 11.5205
R823 VSS.n105 VSS.n104 11.5205
R824 VSS.n104 VSS.n101 11.5205
R825 VSS.n101 VSS.n100 11.5205
R826 VSS.n115 VSS.n87 11.5205
R827 VSS.n115 VSS.n77 11.5205
R828 VSS.n128 VSS.n77 11.5205
R829 VSS.n128 VSS.n75 11.5205
R830 VSS.n132 VSS.n75 11.5205
R831 VSS.n132 VSS.n64 11.5205
R832 VSS.n148 VSS.n64 11.5205
R833 VSS.n148 VSS.n62 11.5205
R834 VSS.n153 VSS.n62 11.5205
R835 VSS.n153 VSS.n49 11.5205
R836 VSS.n194 VSS.n39 11.5205
R837 VSS.n198 VSS.n39 11.5205
R838 VSS.n198 VSS.n35 11.5205
R839 VSS.n205 VSS.n35 11.5205
R840 VSS.n205 VSS.n33 11.5205
R841 VSS.n209 VSS.n33 11.5205
R842 VSS.n209 VSS.n29 11.5205
R843 VSS.n216 VSS.n29 11.5205
R844 VSS.n216 VSS.n26 11.5205
R845 VSS.n227 VSS.n27 11.5205
R846 VSS.n223 VSS.n27 11.5205
R847 VSS.n223 VSS.n222 11.5205
R848 VSS.n222 VSS.n19 11.5205
R849 VSS.n233 VSS.n19 11.5205
R850 VSS.n233 VSS.n16 11.5205
R851 VSS.n252 VSS.n251 11.5205
R852 VSS.n251 VSS.n250 11.5205
R853 VSS.n250 VSS.n7 11.5205
R854 VSS.n245 VSS.n7 11.5205
R855 VSS.n245 VSS.n244 11.5205
R856 VSS.n244 VSS.n243 11.5205
R857 VSS.n243 VSS.n12 11.5205
R858 VSS.n239 VSS.n12 11.5205
R859 VSS.n239 VSS.n238 11.5205
R860 VSS.n188 VSS.n41 11.5205
R861 VSS.n188 VSS.n176 11.5205
R862 VSS.n184 VSS.n176 11.5205
R863 VSS.n184 VSS.n183 11.5205
R864 VSS.n183 VSS.n182 11.5205
R865 VSS.n182 VSS.n3 11.5205
R866 VSS.n159 VSS.n56 9.3005
R867 VSS.n160 VSS.n55 9.3005
R868 VSS.n163 VSS.n54 9.3005
R869 VSS.n164 VSS.n53 9.3005
R870 VSS.n167 VSS.n52 9.3005
R871 VSS.n168 VSS.n51 9.3005
R872 VSS.n169 VSS.n50 9.3005
R873 VSS.n112 VSS.n111 9.3005
R874 VSS.n89 VSS.n88 9.3005
R875 VSS.n106 VSS.n94 9.3005
R876 VSS.n105 VSS.n95 9.3005
R877 VSS.n104 VSS.n96 9.3005
R878 VSS.n101 VSS.n97 9.3005
R879 VSS.n100 VSS.n98 9.3005
R880 VSS.n113 VSS.n87 9.3005
R881 VSS.n115 VSS.n114 9.3005
R882 VSS.n77 VSS.n76 9.3005
R883 VSS.n129 VSS.n128 9.3005
R884 VSS.n130 VSS.n75 9.3005
R885 VSS.n132 VSS.n131 9.3005
R886 VSS.n64 VSS.n63 9.3005
R887 VSS.n149 VSS.n148 9.3005
R888 VSS.n150 VSS.n62 9.3005
R889 VSS.n153 VSS.n152 9.3005
R890 VSS.n151 VSS.n49 9.3005
R891 VSS.n235 VSS.n16 9.3005
R892 VSS.n234 VSS.n233 9.3005
R893 VSS.n19 VSS.n18 9.3005
R894 VSS.n222 VSS.n17 9.3005
R895 VSS.n224 VSS.n223 9.3005
R896 VSS.n225 VSS.n27 9.3005
R897 VSS.n227 VSS.n226 9.3005
R898 VSS.n41 VSS.n40 9.3005
R899 VSS.n188 VSS.n187 9.3005
R900 VSS.n186 VSS.n176 9.3005
R901 VSS.n185 VSS.n184 9.3005
R902 VSS.n183 VSS.n177 9.3005
R903 VSS.n182 VSS.n181 9.3005
R904 VSS.n3 VSS.n1 9.3005
R905 VSS.n195 VSS.n194 9.3005
R906 VSS.n196 VSS.n39 9.3005
R907 VSS.n198 VSS.n197 9.3005
R908 VSS.n35 VSS.n34 9.3005
R909 VSS.n206 VSS.n205 9.3005
R910 VSS.n207 VSS.n33 9.3005
R911 VSS.n209 VSS.n208 9.3005
R912 VSS.n29 VSS.n28 9.3005
R913 VSS.n217 VSS.n216 9.3005
R914 VSS.n218 VSS.n26 9.3005
R915 VSS.n120 VSS.n119 9.3005
R916 VSS.n121 VSS.n80 9.3005
R917 VSS.n124 VSS.n123 9.3005
R918 VSS.n71 VSS.n70 9.3005
R919 VSS.n137 VSS.n136 9.3005
R920 VSS.n138 VSS.n68 9.3005
R921 VSS.n144 VSS.n143 9.3005
R922 VSS.n142 VSS.n69 9.3005
R923 VSS.n140 VSS.n59 9.3005
R924 VSS.n139 VSS.n57 9.3005
R925 VSS.n82 VSS.n81 9.3005
R926 VSS.n238 VSS.n237 9.3005
R927 VSS.n240 VSS.n239 9.3005
R928 VSS.n241 VSS.n12 9.3005
R929 VSS.n243 VSS.n242 9.3005
R930 VSS.n244 VSS.n8 9.3005
R931 VSS.n246 VSS.n245 9.3005
R932 VSS.n248 VSS.n7 9.3005
R933 VSS.n250 VSS.n249 9.3005
R934 VSS.n251 VSS.n2 9.3005
R935 VSS.n253 VSS.n252 9.3005
R936 VSS.n219 VSS.n17 1.28383
R937 VSS.n236 VSS.n17 1.28383
R938 VSS.n226 VSS.n219 0.353938
R939 VSS.n236 VSS.n235 0.335188
R940 VSS.n195 VSS.n40 0.286437
R941 VSS.n113 VSS.n112 0.26925
R942 VSS.n151 VSS.n50 0.26925
R943 VSS VSS.n255 0.187937
R944 VSS.n226 VSS.n225 0.1805
R945 VSS.n225 VSS.n224 0.1805
R946 VSS.n224 VSS.n17 0.1805
R947 VSS.n18 VSS.n17 0.1805
R948 VSS.n234 VSS.n18 0.1805
R949 VSS.n235 VSS.n234 0.1805
R950 VSS.n98 VSS.n81 0.16925
R951 VSS.n56 VSS.n0 0.14425
R952 VSS.n254 VSS.n1 0.14425
R953 VSS.n255 VSS.n254 0.13175
R954 VSS.n112 VSS.n88 0.113
R955 VSS.n94 VSS.n88 0.113
R956 VSS.n95 VSS.n94 0.113
R957 VSS.n96 VSS.n95 0.113
R958 VSS.n97 VSS.n96 0.113
R959 VSS.n98 VSS.n97 0.113
R960 VSS.n114 VSS.n113 0.113
R961 VSS.n114 VSS.n76 0.113
R962 VSS.n129 VSS.n76 0.113
R963 VSS.n130 VSS.n129 0.113
R964 VSS.n131 VSS.n130 0.113
R965 VSS.n131 VSS.n63 0.113
R966 VSS.n149 VSS.n63 0.113
R967 VSS.n150 VSS.n149 0.113
R968 VSS.n152 VSS.n150 0.113
R969 VSS.n152 VSS.n151 0.113
R970 VSS.n51 VSS.n50 0.113
R971 VSS.n52 VSS.n51 0.113
R972 VSS.n53 VSS.n52 0.113
R973 VSS.n54 VSS.n53 0.113
R974 VSS.n55 VSS.n54 0.113
R975 VSS.n56 VSS.n55 0.113
R976 VSS.n187 VSS.n40 0.113
R977 VSS.n187 VSS.n186 0.113
R978 VSS.n186 VSS.n185 0.113
R979 VSS.n185 VSS.n177 0.113
R980 VSS.n181 VSS.n177 0.113
R981 VSS.n181 VSS.n1 0.113
R982 VSS.n196 VSS.n195 0.113
R983 VSS.n197 VSS.n196 0.113
R984 VSS.n197 VSS.n34 0.113
R985 VSS.n206 VSS.n34 0.113
R986 VSS.n207 VSS.n206 0.113
R987 VSS.n208 VSS.n207 0.113
R988 VSS.n208 VSS.n28 0.113
R989 VSS.n217 VSS.n28 0.113
R990 VSS.n218 VSS.n217 0.113
R991 VSS.n219 VSS.n218 0.103625
R992 VSS.n255 VSS.n0 0.08175
R993 VSS.n254 VSS.n253 0.0289375
R994 VSS.n139 VSS.n0 0.0255
R995 VSS.n120 VSS.n81 0.023
R996 VSS.n121 VSS.n120 0.023
R997 VSS.n123 VSS.n121 0.023
R998 VSS.n137 VSS.n70 0.023
R999 VSS.n138 VSS.n137 0.023
R1000 VSS.n143 VSS.n138 0.023
R1001 VSS.n143 VSS.n142 0.023
R1002 VSS.n140 VSS.n139 0.023
R1003 VSS.n253 VSS.n2 0.023
R1004 VSS.n249 VSS.n2 0.023
R1005 VSS.n249 VSS.n248 0.023
R1006 VSS.n246 VSS.n8 0.023
R1007 VSS.n242 VSS.n8 0.023
R1008 VSS.n242 VSS.n241 0.023
R1009 VSS.n241 VSS.n240 0.023
R1010 VSS.n237 VSS.n13 0.0220625
R1011 VSS.n237 VSS.n236 0.021125
R1012 VSS.n142 VSS.n141 0.0205
R1013 VSS.n122 VSS.n70 0.0155
R1014 VSS.n247 VSS.n246 0.0126875
R1015 VSS.n248 VSS.n247 0.0108125
R1016 VSS.n123 VSS.n122 0.008
R1017 VSS.n141 VSS.n140 0.003
R1018 VSS.n240 VSS.n13 0.0014375
C0 B VAPWR 1.21997f
C1 A VAPWR 0.88921f
C2 ctrl_n in 0.00405f
C3 ctrl in 0.89184f
C4 VDD in 0.56959f
C5 A B 1.34041f
C6 ctrl_n VAPWR 0.01957f
C7 ctrl VAPWR 0.07073f
C8 VDD VAPWR 0.50335f
C9 ctrl_n B 0.2876f
C10 ctrl B 0.14176f
C11 A ctrl_n 0.43193f
C12 ctrl A 0.45871f
C13 VDD B 0.01476f
C14 VDD A 0.00319f
C15 ctrl ctrl_n 1.53278f
C16 VDD ctrl_n 0.87084f
C17 VDD ctrl 1.36122f
C18 in VAPWR 0.00145f
C19 B in 0.00804f
C20 A in 0
C21 A VSS 0.88454f
C22 B VSS 0.98231f
C23 in VSS 0.72542f
C24 VAPWR VSS 6.46833f
C25 VDD VSS 6.14461f
C26 ctrl_n VSS 1.84664f
C27 ctrl VSS 1.81718f
C28 VDD.n0 VSS 0.02f
C29 VDD.t3 VSS 0.02086f
C30 VDD.n1 VSS 0.04985f
C31 VDD.n2 VSS 0.00538f
C32 VDD.n3 VSS 0.00538f
C33 VDD.n4 VSS 0.00538f
C34 VDD.n5 VSS 0.00538f
C35 VDD.n6 VSS 0.02692f
C36 VDD.n7 VSS 0.00538f
C37 VDD.n8 VSS 0.00538f
C38 VDD.n9 VSS 0.00538f
C39 VDD.n10 VSS 0.01076f
C40 VDD.t1 VSS 0.00979f
C41 VDD.n11 VSS 0.01318f
C42 VDD.n12 VSS 0.00336f
C43 VDD.n13 VSS 0.01085f
C44 VDD.n14 VSS 0.00538f
C45 VDD.n15 VSS 0.00538f
C46 VDD.n16 VSS 0.00538f
C47 VDD.n17 VSS 0.00538f
C48 VDD.n18 VSS 0.00538f
C49 VDD.n19 VSS 0.00538f
C50 VDD.n20 VSS 0.00336f
C51 VDD.n21 VSS 0.00538f
C52 VDD.n22 VSS 0.00538f
C53 VDD.n23 VSS 0.01085f
C54 VDD.n24 VSS 0.01076f
C55 VDD.n25 VSS 0.00538f
C56 VDD.n26 VSS 0.00538f
C57 VDD.n27 VSS 0.00538f
C58 VDD.n28 VSS 0.01076f
C59 VDD.n29 VSS 0.00538f
C60 VDD.n30 VSS 0.07941f
C61 VDD.n31 VSS 0.00538f
C62 VDD.n32 VSS 0.00538f
C63 VDD.n33 VSS 0.00538f
C64 VDD.n34 VSS 0.00538f
C65 VDD.n35 VSS 0.00538f
C66 VDD.t4 VSS 0.0397f
C67 VDD.n36 VSS 0.00538f
C68 VDD.n37 VSS 0.01076f
C69 VDD.n38 VSS 0.00538f
C70 VDD.n39 VSS 0.08988f
C71 VDD.n40 VSS 0.01076f
C72 VDD.n41 VSS 0.01076f
C73 VDD.n42 VSS 0.00538f
C74 VDD.n43 VSS 0.00538f
C75 VDD.n44 VSS 0.00538f
C76 VDD.n45 VSS 0.00538f
C77 VDD.n49 VSS 0.00538f
C78 VDD.n50 VSS 0.00538f
C79 VDD.n51 VSS 0.01076f
C80 VDD.n52 VSS 0.00538f
C81 VDD.t5 VSS 0.02086f
C82 VDD.n53 VSS 0.01402f
C83 VDD.n54 VSS 0.04985f
C84 VDD.n55 VSS 0.13299f
C85 VDD.n56 VSS 0.00538f
C86 VDD.n57 VSS 0.00538f
C87 VDD.n58 VSS 0.00538f
C88 VDD.n59 VSS 0.00538f
C89 VDD.n60 VSS 0.00538f
C90 VDD.n61 VSS 0.00538f
C91 VDD.n62 VSS 0.00538f
C92 VDD.n63 VSS 0.00538f
C93 VDD.n64 VSS 0.00538f
C94 VDD.n65 VSS 0.00538f
C95 VDD.n66 VSS 0.00538f
C96 VDD.n67 VSS 0.00538f
C97 VDD.n68 VSS 0.00538f
C98 VDD.n69 VSS 0.00538f
C99 VDD.n70 VSS 0.00538f
C100 VDD.n71 VSS 0.00538f
C101 VDD.n72 VSS 0.00538f
C102 VDD.n73 VSS 0.00538f
C103 VDD.n74 VSS 0.02772f
C104 VDD.n75 VSS 0.01085f
C105 VDD.n76 VSS 0.01085f
C106 VDD.n78 VSS 0.20458f
C107 VDD.n79 VSS 0.01085f
C108 VDD.n80 VSS 0.01085f
C109 VDD.n81 VSS 0.01085f
C110 VDD.n82 VSS 0.01076f
C111 VDD.n83 VSS 0.00538f
C112 VDD.n84 VSS 0.00538f
C113 VDD.n85 VSS 0.00538f
C114 VDD.n86 VSS 0.00538f
C115 VDD.n87 VSS 0.06286f
C116 VDD.n88 VSS 0.00538f
C117 VDD.n89 VSS 0.00538f
C118 VDD.n90 VSS 0.04963f
C119 VDD.t2 VSS 0.0397f
C120 VDD.n91 VSS 0.04632f
C121 VDD.n92 VSS 0.07941f
C122 VDD.n93 VSS 0.00538f
C123 VDD.n94 VSS 0.00538f
C124 VDD.n95 VSS 0.00538f
C125 VDD.n96 VSS 0.00538f
C126 VDD.n97 VSS 0.00538f
C127 VDD.n98 VSS 0.00538f
C128 VDD.n99 VSS 0.00538f
C129 VDD.n100 VSS 0.07941f
C130 VDD.n101 VSS 0.05625f
C131 VDD.t0 VSS 0.0397f
C132 VDD.n103 VSS 0.00538f
C133 VDD.n106 VSS 0.00538f
C134 VDD.n109 VSS 0.20458f
C135 VDD.n110 VSS 0.01076f
C136 VDD.n111 VSS 0.08988f
C137 VDD.n112 VSS 0.06286f
C138 VDD.n113 VSS 0.00538f
C139 VDD.n114 VSS 0.00538f
C140 VDD.n115 VSS 0.00538f
C141 VDD.n116 VSS 0.00516f
C142 VDD.n117 VSS 0.01378f
C143 VDD.n118 VSS 0.005f
C144 VDD.n119 VSS 0.01085f
C145 VDD.n120 VSS 0.00538f
C146 VDD.n121 VSS 0.00538f
C147 VDD.n122 VSS 0.00336f
C148 VDD.n123 VSS 0.00336f
C149 VDD.n124 VSS 0.00252f
C150 VDD.n125 VSS 0.00538f
C151 VDD.n126 VSS 0.00538f
C152 VDD.n127 VSS 0.00252f
C153 VDD.n128 VSS 0.00336f
C154 VDD.n129 VSS 0.00336f
C155 VDD.n130 VSS 0.00538f
C156 VDD.n131 VSS 0.00538f
C157 VDD.n132 VSS 0.01085f
C158 VDD.n133 VSS 0.00474f
C159 VDD.n134 VSS 0.02839f
C160 VDD.n135 VSS 0.02523f
C161 VDD.n136 VSS 0.04243f
C162 VDD.n137 VSS 0.01402f
C163 VDD.n138 VSS 0.00538f
C164 VDD.n139 VSS 0.00538f
C165 VDD.n140 VSS 0.00538f
C166 VDD.n141 VSS 0.02692f
C167 VDD.n142 VSS 0.02692f
C168 VDD.n143 VSS 0.02075f
C169 VDD.n144 VSS 0.00538f
C170 VDD.n145 VSS 0.00538f
C171 VDD.n146 VSS 0.01308f
C172 VDD.n147 VSS 0.43579f
C173 VAPWR.n0 VSS 0.01295f
C174 VAPWR.n1 VSS 0.01957f
C175 VAPWR.n2 VSS 0.00414f
C176 VAPWR.n3 VSS 0.00414f
C177 VAPWR.n4 VSS 0.00414f
C178 VAPWR.n5 VSS 0.00414f
C179 VAPWR.n6 VSS 0.00804f
C180 VAPWR.t3 VSS 0.00339f
C181 VAPWR.n7 VSS 0.04335f
C182 VAPWR.n8 VSS 0.00414f
C183 VAPWR.n9 VSS 0.00796f
C184 VAPWR.n10 VSS 0.00414f
C185 VAPWR.n11 VSS 0.00414f
C186 VAPWR.n12 VSS 0.00414f
C187 VAPWR.n13 VSS 0.00414f
C188 VAPWR.n14 VSS 0.00414f
C189 VAPWR.n15 VSS 0.00414f
C190 VAPWR.n16 VSS 0.00414f
C191 VAPWR.n17 VSS 0.00414f
C192 VAPWR.n18 VSS 0.00796f
C193 VAPWR.n19 VSS 0.00414f
C194 VAPWR.n20 VSS 0.00796f
C195 VAPWR.n21 VSS 0.00414f
C196 VAPWR.n22 VSS 0.00804f
C197 VAPWR.n23 VSS 0.00414f
C198 VAPWR.n24 VSS 0.00414f
C199 VAPWR.n25 VSS 0.00414f
C200 VAPWR.n26 VSS 0.00414f
C201 VAPWR.n27 VSS 0.06111f
C202 VAPWR.n28 VSS 0.00414f
C203 VAPWR.n29 VSS 0.00414f
C204 VAPWR.n30 VSS 0.00414f
C205 VAPWR.t1 VSS 0.00339f
C206 VAPWR.n31 VSS 0.02072f
C207 VAPWR.n32 VSS 0.00414f
C208 VAPWR.n33 VSS 0.00414f
C209 VAPWR.t0 VSS 0.03056f
C210 VAPWR.n34 VSS 0.00414f
C211 VAPWR.n35 VSS 0.00414f
C212 VAPWR.n36 VSS 0.00414f
C213 VAPWR.n37 VSS 0.00414f
C214 VAPWR.n38 VSS 0.00414f
C215 VAPWR.n39 VSS 0.00414f
C216 VAPWR.n40 VSS 0.00414f
C217 VAPWR.n41 VSS 0.06451f
C218 VAPWR.n42 VSS 0.00804f
C219 VAPWR.n43 VSS 0.00804f
C220 VAPWR.n44 VSS 0.00414f
C221 VAPWR.n45 VSS 0.00796f
C222 VAPWR.n46 VSS 0.00414f
C223 VAPWR.n47 VSS 0.00414f
C224 VAPWR.n48 VSS 0.00414f
C225 VAPWR.n49 VSS 0.00414f
C226 VAPWR.n50 VSS 0.00414f
C227 VAPWR.n51 VSS 0.00414f
C228 VAPWR.n52 VSS 0.00414f
C229 VAPWR.n53 VSS 0.00414f
C230 VAPWR.n54 VSS 0.00796f
C231 VAPWR.n55 VSS 0.00414f
C232 VAPWR.n56 VSS 0.00414f
C233 VAPWR.n59 VSS 0.00414f
C234 VAPWR.n62 VSS 0.15278f
C235 VAPWR.n63 VSS 0.00796f
C236 VAPWR.n64 VSS 0.00804f
C237 VAPWR.n65 VSS 0.00804f
C238 VAPWR.n66 VSS 0.00804f
C239 VAPWR.n67 VSS 0.00796f
C240 VAPWR.n68 VSS 0.00414f
C241 VAPWR.n69 VSS 0.00414f
C242 VAPWR.n70 VSS 0.00414f
C243 VAPWR.n71 VSS 0.00414f
C244 VAPWR.n72 VSS 0.00414f
C245 VAPWR.n73 VSS 0.00414f
C246 VAPWR.n74 VSS 0.00414f
C247 VAPWR.n75 VSS 0.00414f
C248 VAPWR.n76 VSS 0.00414f
C249 VAPWR.n77 VSS 0.00414f
C250 VAPWR.n78 VSS 0.00414f
C251 VAPWR.n79 VSS 0.00414f
C252 VAPWR.n80 VSS 0.00796f
C253 VAPWR.n81 VSS 0.01125f
C254 VAPWR.n82 VSS 0.05792f
C255 VAPWR.n83 VSS 0.02072f
C256 VAPWR.n84 VSS 0.00414f
C257 VAPWR.n85 VSS 0.00414f
C258 VAPWR.n86 VSS 0.06111f
C259 VAPWR.n87 VSS 0.03735f
C260 VAPWR.n88 VSS 0.00414f
C261 VAPWR.n89 VSS 0.00414f
C262 VAPWR.n90 VSS 0.00414f
C263 VAPWR.n91 VSS 0.00414f
C264 VAPWR.n92 VSS 0.00414f
C265 VAPWR.n93 VSS 0.00414f
C266 VAPWR.n94 VSS 0.00414f
C267 VAPWR.n95 VSS 0.00414f
C268 VAPWR.n96 VSS 0.00414f
C269 VAPWR.n97 VSS 0.00414f
C270 VAPWR.n98 VSS 0.06111f
C271 VAPWR.n99 VSS 0.05432f
C272 VAPWR.n100 VSS 0.00414f
C273 VAPWR.n101 VSS 0.00414f
C274 VAPWR.n102 VSS 0.01381f
C275 VAPWR.n103 VSS 0.04335f
C276 VAPWR.n104 VSS 0.01726f
C277 VAPWR.n105 VSS 0.02072f
C278 VAPWR.n106 VSS 0.00414f
C279 VAPWR.n107 VSS 0.00414f
C280 VAPWR.n108 VSS 0.00414f
C281 VAPWR.n109 VSS 0.06111f
C282 VAPWR.n110 VSS 0.05432f
C283 VAPWR.t2 VSS 0.03056f
C284 VAPWR.n112 VSS 0.00414f
C285 VAPWR.n115 VSS 0.00414f
C286 VAPWR.n118 VSS 0.15278f
C287 VAPWR.n119 VSS 0.00804f
C288 VAPWR.n120 VSS 0.06451f
C289 VAPWR.n121 VSS 0.06111f
C290 VAPWR.n122 VSS 0.03735f
C291 VAPWR.n123 VSS 0.00414f
C292 VAPWR.n124 VSS 0.00414f
C293 VAPWR.n125 VSS 0.00414f
C294 VAPWR.n126 VSS 0.00414f
C295 VAPWR.n127 VSS 0.00804f
C296 VAPWR.n128 VSS 0.00804f
C297 VAPWR.n129 VSS 0.00796f
C298 VAPWR.n130 VSS 0.00414f
C299 VAPWR.n131 VSS 0.00414f
C300 VAPWR.n132 VSS 0.00414f
C301 VAPWR.n133 VSS 0.00414f
C302 VAPWR.n134 VSS 0.00414f
C303 VAPWR.n135 VSS 0.00414f
C304 VAPWR.n136 VSS 0.00414f
C305 VAPWR.n137 VSS 0.00414f
C306 VAPWR.n138 VSS 0.00414f
C307 VAPWR.n139 VSS 0.00414f
C308 VAPWR.n140 VSS 0.00414f
C309 VAPWR.n141 VSS 0.00414f
C310 VAPWR.n142 VSS 0.00796f
C311 VAPWR.n143 VSS 0.01938f
C312 VAPWR.n144 VSS 0.10158f
C313 VAPWR.n145 VSS 0.01151f
C314 VAPWR.n146 VSS 0.00414f
C315 VAPWR.n147 VSS 0.00414f
C316 VAPWR.n148 VSS 0.00414f
C317 VAPWR.n149 VSS 0.01813f
C318 VAPWR.n150 VSS 0.40948f
C319 in.t1 VSS 0.05554f
C320 in.t0 VSS 0.0364f
C321 in.n0 VSS 1.1324f
C322 in.n1 VSS 0.27095f
C323 B.t2 VSS 0.12815f
C324 B.t0 VSS 0.04583f
C325 B.t1 VSS 0.04677f
C326 B.n0 VSS 1.33626f
C327 B.n1 VSS 1.32947f
C328 A.t1 VSS 0.04586f
C329 A.t0 VSS 0.04687f
C330 A.n0 VSS 1.29936f
C331 A.t2 VSS 0.131f
C332 A.n1 VSS 1.37153f
.ends
