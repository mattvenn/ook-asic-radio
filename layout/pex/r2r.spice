* r2r: magic R+C extraction of layout/r2r.gds (layout/pex.sh)
.subckt r2r b0 b1 b2 b3 b4 b5 b6 b7 out VGND
X0 a_0_10000# r2r_startmod_0.a VGND.t3 sky130_fd_pr__res_high_po_1p41 l=45
X1 a_7000_10000# b4.t0 VGND.t0 sky130_fd_pr__res_high_po_1p41 l=45
X2 a_8500_10000# b5.t0 VGND.t22 sky130_fd_pr__res_high_po_1p41 l=45
X3 d e VGND.t15 sky130_fd_pr__res_high_po_1p41 l=45
X4 e f VGND.t13 sky130_fd_pr__res_high_po_1p41 l=45
X5 VGND.t6 VGND.t7 VGND.t5 sky130_fd_pr__res_high_po_1p41 l=45
X6 a_5500_10000# d VGND.t12 sky130_fd_pr__res_high_po_1p41 l=45
X7 a_7000_10000# e VGND.t14 sky130_fd_pr__res_high_po_1p41 l=45
X8 a_0_10000# b0.t0 VGND.t4 sky130_fd_pr__res_high_po_1p41 l=45
X9 a_4000_10000# b2.t0 VGND.t10 sky130_fd_pr__res_high_po_1p41 l=45
X10 a_5500_10000# b3.t0 VGND.t16 sky130_fd_pr__res_high_po_1p41 l=45
X11 VGND.t28 VGND.t29 VGND.t27 sky130_fd_pr__res_high_po_1p41 l=45
X12 b c VGND.t21 sky130_fd_pr__res_high_po_1p41 l=45
X13 c d VGND.t2 sky130_fd_pr__res_high_po_1p41 l=45
X14 a_11500_10000# out.t0 VGND.t24 sky130_fd_pr__res_high_po_1p41 l=45
X15 a_2500_10000# b VGND.t8 sky130_fd_pr__res_high_po_1p41 l=45
X16 a_4000_10000# c VGND.t11 sky130_fd_pr__res_high_po_1p41 l=45
X17 a_1000_10000# VGND.t18 VGND.t17 sky130_fd_pr__res_high_po_1p41 l=45
X18 a_10000_10000# b6.t0 VGND.t31 sky130_fd_pr__res_high_po_1p41 l=45
X19 a_11500_10000# b7.t0 VGND.t26 sky130_fd_pr__res_high_po_1p41 l=45
X20 a_2500_10000# b1.t0 VGND.t1 sky130_fd_pr__res_high_po_1p41 l=45
X21 r2r_startmod_0.a b VGND.t9 sky130_fd_pr__res_high_po_1p41 l=45
X22 g out.t1 VGND.t25 sky130_fd_pr__res_high_po_1p41 l=45
X23 a_1000_10000# r2r_startmod_0.a VGND.t19 sky130_fd_pr__res_high_po_1p41 l=45
X24 a_10000_10000# g VGND.t20 sky130_fd_pr__res_high_po_1p41 l=45
X25 f g VGND.t23 sky130_fd_pr__res_high_po_1p41 l=45
X26 a_8500_10000# f VGND.t30 sky130_fd_pr__res_high_po_1p41 l=45
R0 b7 b7.t0 10.7889
R1 out.n0 out.t1 10.6705
R2 out.n0 out.t0 10.6336
R3 out out.n0 0.1255
R4 b6 b6.t0 10.7889
R5 b5 b5.t0 10.7889
R6 b4 b4.t0 10.7889
R7 b3 b3.t0 10.7889
R8 b2 b2.t0 10.7889
R9 b1 b1.t0 10.7889
R10 b0 b0.t0 10.7889
R11 VGND.t27 VGND.n178 208.918
R12 VGND.t26 VGND.t27 203.214
R13 VGND.t24 VGND.t26 203.214
R14 VGND.t25 VGND.t24 203.214
R15 VGND.t31 VGND.t25 203.214
R16 VGND.t20 VGND.t31 203.214
R17 VGND.t23 VGND.t20 203.214
R18 VGND.t22 VGND.t23 203.214
R19 VGND.t30 VGND.t22 203.214
R20 VGND.t13 VGND.t30 203.214
R21 VGND.t0 VGND.t13 203.214
R22 VGND.t14 VGND.t0 203.214
R23 VGND.t15 VGND.t14 203.214
R24 VGND.t16 VGND.t12 203.214
R25 VGND.t12 VGND.t2 203.214
R26 VGND.t2 VGND.t10 203.214
R27 VGND.t10 VGND.t11 203.214
R28 VGND.t11 VGND.t21 203.214
R29 VGND.t21 VGND.t1 203.214
R30 VGND.t1 VGND.t8 203.214
R31 VGND.t8 VGND.t9 203.214
R32 VGND.t9 VGND.t17 203.214
R33 VGND.t17 VGND.t19 203.214
R34 VGND.t19 VGND.t3 203.214
R35 VGND.t3 VGND.t4 203.214
R36 VGND.t4 VGND.t5 203.214
R37 VGND.t5 VGND.n29 201.602
R38 VGND.n179 VGND.t15 199.558
R39 VGND.n89 VGND.n59 16.0409
R40 VGND.n183 VGND.n182 16.0409
R41 VGND.n177 VGND.t29 12.7592
R42 VGND.n358 VGND.t7 10.9444
R43 VGND.n90 VGND.t28 10.672
R44 VGND.n181 VGND.t6 10.6664
R45 VGND.n360 VGND.t18 10.5739
R46 VGND.n176 VGND.n60 9.3005
R47 VGND.n175 VGND.n174 9.3005
R48 VGND.n173 VGND.n61 9.3005
R49 VGND.n172 VGND.n171 9.3005
R50 VGND.n170 VGND.n62 9.3005
R51 VGND.n169 VGND.n168 9.3005
R52 VGND.n167 VGND.n63 9.3005
R53 VGND.n166 VGND.n165 9.3005
R54 VGND.n164 VGND.n64 9.3005
R55 VGND.n163 VGND.n162 9.3005
R56 VGND.n161 VGND.n65 9.3005
R57 VGND.n160 VGND.n159 9.3005
R58 VGND.n158 VGND.n66 9.3005
R59 VGND.n157 VGND.n156 9.3005
R60 VGND.n155 VGND.n67 9.3005
R61 VGND.n154 VGND.n153 9.3005
R62 VGND.n152 VGND.n68 9.3005
R63 VGND.n151 VGND.n150 9.3005
R64 VGND.n149 VGND.n69 9.3005
R65 VGND.n148 VGND.n147 9.3005
R66 VGND.n146 VGND.n70 9.3005
R67 VGND.n145 VGND.n144 9.3005
R68 VGND.n143 VGND.n71 9.3005
R69 VGND.n142 VGND.n141 9.3005
R70 VGND.n140 VGND.n72 9.3005
R71 VGND.n139 VGND.n138 9.3005
R72 VGND.n137 VGND.n73 9.3005
R73 VGND.n136 VGND.n135 9.3005
R74 VGND.n134 VGND.n74 9.3005
R75 VGND.n133 VGND.n132 9.3005
R76 VGND.n131 VGND.n75 9.3005
R77 VGND.n130 VGND.n129 9.3005
R78 VGND.n128 VGND.n76 9.3005
R79 VGND.n127 VGND.n126 9.3005
R80 VGND.n125 VGND.n77 9.3005
R81 VGND.n124 VGND.n123 9.3005
R82 VGND.n122 VGND.n78 9.3005
R83 VGND.n121 VGND.n120 9.3005
R84 VGND.n119 VGND.n79 9.3005
R85 VGND.n118 VGND.n117 9.3005
R86 VGND.n116 VGND.n80 9.3005
R87 VGND.n115 VGND.n114 9.3005
R88 VGND.n113 VGND.n81 9.3005
R89 VGND.n112 VGND.n111 9.3005
R90 VGND.n110 VGND.n82 9.3005
R91 VGND.n109 VGND.n108 9.3005
R92 VGND.n107 VGND.n83 9.3005
R93 VGND.n106 VGND.n105 9.3005
R94 VGND.n104 VGND.n84 9.3005
R95 VGND.n103 VGND.n102 9.3005
R96 VGND.n101 VGND.n85 9.3005
R97 VGND.n100 VGND.n99 9.3005
R98 VGND.n98 VGND.n86 9.3005
R99 VGND.n97 VGND.n96 9.3005
R100 VGND.n95 VGND.n87 9.3005
R101 VGND.n94 VGND.n93 9.3005
R102 VGND.n92 VGND.n88 9.3005
R103 VGND.n354 VGND.n1 9.3005
R104 VGND.n353 VGND.n352 9.3005
R105 VGND.n351 VGND.n2 9.3005
R106 VGND.n350 VGND.n349 9.3005
R107 VGND.n348 VGND.n3 9.3005
R108 VGND.n347 VGND.n346 9.3005
R109 VGND.n345 VGND.n4 9.3005
R110 VGND.n344 VGND.n343 9.3005
R111 VGND.n342 VGND.n5 9.3005
R112 VGND.n341 VGND.n340 9.3005
R113 VGND.n339 VGND.n6 9.3005
R114 VGND.n338 VGND.n337 9.3005
R115 VGND.n336 VGND.n7 9.3005
R116 VGND.n335 VGND.n334 9.3005
R117 VGND.n333 VGND.n8 9.3005
R118 VGND.n332 VGND.n331 9.3005
R119 VGND.n330 VGND.n9 9.3005
R120 VGND.n329 VGND.n328 9.3005
R121 VGND.n327 VGND.n10 9.3005
R122 VGND.n326 VGND.n325 9.3005
R123 VGND.n324 VGND.n11 9.3005
R124 VGND.n323 VGND.n322 9.3005
R125 VGND.n321 VGND.n12 9.3005
R126 VGND.n320 VGND.n319 9.3005
R127 VGND.n318 VGND.n13 9.3005
R128 VGND.n317 VGND.n316 9.3005
R129 VGND.n315 VGND.n14 9.3005
R130 VGND.n314 VGND.n313 9.3005
R131 VGND.n312 VGND.n15 9.3005
R132 VGND.n311 VGND.n310 9.3005
R133 VGND.n309 VGND.n16 9.3005
R134 VGND.n308 VGND.n307 9.3005
R135 VGND.n306 VGND.n17 9.3005
R136 VGND.n305 VGND.n304 9.3005
R137 VGND.n303 VGND.n18 9.3005
R138 VGND.n302 VGND.n301 9.3005
R139 VGND.n300 VGND.n19 9.3005
R140 VGND.n299 VGND.n298 9.3005
R141 VGND.n297 VGND.n20 9.3005
R142 VGND.n296 VGND.n295 9.3005
R143 VGND.n294 VGND.n21 9.3005
R144 VGND.n293 VGND.n292 9.3005
R145 VGND.n291 VGND.n22 9.3005
R146 VGND.n290 VGND.n289 9.3005
R147 VGND.n288 VGND.n23 9.3005
R148 VGND.n287 VGND.n286 9.3005
R149 VGND.n285 VGND.n24 9.3005
R150 VGND.n284 VGND.n283 9.3005
R151 VGND.n282 VGND.n25 9.3005
R152 VGND.n281 VGND.n280 9.3005
R153 VGND.n279 VGND.n26 9.3005
R154 VGND.n278 VGND.n277 9.3005
R155 VGND.n276 VGND.n27 9.3005
R156 VGND.n275 VGND.n274 9.3005
R157 VGND.n273 VGND.n28 9.3005
R158 VGND.n272 VGND.n271 9.3005
R159 VGND.n270 VGND.n29 9.3005
R160 VGND.n269 VGND.n268 9.3005
R161 VGND.n267 VGND.n30 9.3005
R162 VGND.n266 VGND.n265 9.3005
R163 VGND.n264 VGND.n31 9.3005
R164 VGND.n263 VGND.n262 9.3005
R165 VGND.n261 VGND.n32 9.3005
R166 VGND.n260 VGND.n259 9.3005
R167 VGND.n258 VGND.n33 9.3005
R168 VGND.n257 VGND.n256 9.3005
R169 VGND.n255 VGND.n34 9.3005
R170 VGND.n254 VGND.n253 9.3005
R171 VGND.n252 VGND.n35 9.3005
R172 VGND.n251 VGND.n250 9.3005
R173 VGND.n249 VGND.n36 9.3005
R174 VGND.n248 VGND.n247 9.3005
R175 VGND.n246 VGND.n37 9.3005
R176 VGND.n245 VGND.n244 9.3005
R177 VGND.n243 VGND.n38 9.3005
R178 VGND.n242 VGND.n241 9.3005
R179 VGND.n240 VGND.n39 9.3005
R180 VGND.n239 VGND.n238 9.3005
R181 VGND.n237 VGND.n40 9.3005
R182 VGND.n236 VGND.n235 9.3005
R183 VGND.n234 VGND.n41 9.3005
R184 VGND.n233 VGND.n232 9.3005
R185 VGND.n231 VGND.n42 9.3005
R186 VGND.n230 VGND.n229 9.3005
R187 VGND.n228 VGND.n43 9.3005
R188 VGND.n227 VGND.n226 9.3005
R189 VGND.n225 VGND.n44 9.3005
R190 VGND.n224 VGND.n223 9.3005
R191 VGND.n222 VGND.n45 9.3005
R192 VGND.n221 VGND.n220 9.3005
R193 VGND.n219 VGND.n46 9.3005
R194 VGND.n218 VGND.n217 9.3005
R195 VGND.n216 VGND.n47 9.3005
R196 VGND.n215 VGND.n214 9.3005
R197 VGND.n213 VGND.n48 9.3005
R198 VGND.n212 VGND.n211 9.3005
R199 VGND.n210 VGND.n49 9.3005
R200 VGND.n209 VGND.n208 9.3005
R201 VGND.n207 VGND.n50 9.3005
R202 VGND.n206 VGND.n205 9.3005
R203 VGND.n204 VGND.n51 9.3005
R204 VGND.n203 VGND.n202 9.3005
R205 VGND.n201 VGND.n52 9.3005
R206 VGND.n200 VGND.n199 9.3005
R207 VGND.n198 VGND.n53 9.3005
R208 VGND.n197 VGND.n196 9.3005
R209 VGND.n195 VGND.n54 9.3005
R210 VGND.n194 VGND.n193 9.3005
R211 VGND.n192 VGND.n55 9.3005
R212 VGND.n191 VGND.n190 9.3005
R213 VGND.n189 VGND.n56 9.3005
R214 VGND.n188 VGND.n187 9.3005
R215 VGND.n186 VGND.n57 9.3005
R216 VGND.n185 VGND.n184 9.3005
R217 VGND.n357 VGND.n0 9.3005
R218 VGND.n356 VGND.n355 9.3005
R219 VGND.n358 VGND.n357 7.08943
R220 VGND.n89 VGND.n88 6.74171
R221 VGND.n184 VGND.n183 6.74171
R222 VGND.n178 VGND.n177 4.00131
R223 VGND.n179 VGND.t16 3.65836
R224 VGND.n94 VGND.n88 3.0725
R225 VGND.n95 VGND.n94 3.0725
R226 VGND.n96 VGND.n95 3.0725
R227 VGND.n96 VGND.n86 3.0725
R228 VGND.n100 VGND.n86 3.0725
R229 VGND.n101 VGND.n100 3.0725
R230 VGND.n102 VGND.n101 3.0725
R231 VGND.n102 VGND.n84 3.0725
R232 VGND.n106 VGND.n84 3.0725
R233 VGND.n107 VGND.n106 3.0725
R234 VGND.n108 VGND.n107 3.0725
R235 VGND.n108 VGND.n82 3.0725
R236 VGND.n112 VGND.n82 3.0725
R237 VGND.n113 VGND.n112 3.0725
R238 VGND.n114 VGND.n113 3.0725
R239 VGND.n114 VGND.n80 3.0725
R240 VGND.n118 VGND.n80 3.0725
R241 VGND.n119 VGND.n118 3.0725
R242 VGND.n120 VGND.n119 3.0725
R243 VGND.n120 VGND.n78 3.0725
R244 VGND.n124 VGND.n78 3.0725
R245 VGND.n125 VGND.n124 3.0725
R246 VGND.n126 VGND.n125 3.0725
R247 VGND.n126 VGND.n76 3.0725
R248 VGND.n130 VGND.n76 3.0725
R249 VGND.n131 VGND.n130 3.0725
R250 VGND.n132 VGND.n131 3.0725
R251 VGND.n132 VGND.n74 3.0725
R252 VGND.n136 VGND.n74 3.0725
R253 VGND.n137 VGND.n136 3.0725
R254 VGND.n138 VGND.n137 3.0725
R255 VGND.n138 VGND.n72 3.0725
R256 VGND.n142 VGND.n72 3.0725
R257 VGND.n143 VGND.n142 3.0725
R258 VGND.n144 VGND.n143 3.0725
R259 VGND.n144 VGND.n70 3.0725
R260 VGND.n148 VGND.n70 3.0725
R261 VGND.n149 VGND.n148 3.0725
R262 VGND.n150 VGND.n149 3.0725
R263 VGND.n150 VGND.n68 3.0725
R264 VGND.n154 VGND.n68 3.0725
R265 VGND.n155 VGND.n154 3.0725
R266 VGND.n156 VGND.n155 3.0725
R267 VGND.n156 VGND.n66 3.0725
R268 VGND.n160 VGND.n66 3.0725
R269 VGND.n161 VGND.n160 3.0725
R270 VGND.n162 VGND.n161 3.0725
R271 VGND.n162 VGND.n64 3.0725
R272 VGND.n166 VGND.n64 3.0725
R273 VGND.n167 VGND.n166 3.0725
R274 VGND.n168 VGND.n167 3.0725
R275 VGND.n168 VGND.n62 3.0725
R276 VGND.n172 VGND.n62 3.0725
R277 VGND.n173 VGND.n172 3.0725
R278 VGND.n174 VGND.n173 3.0725
R279 VGND.n174 VGND.n60 3.0725
R280 VGND.n178 VGND.n60 3.0725
R281 VGND.n184 VGND.n57 3.0725
R282 VGND.n188 VGND.n57 3.0725
R283 VGND.n189 VGND.n188 3.0725
R284 VGND.n190 VGND.n189 3.0725
R285 VGND.n190 VGND.n55 3.0725
R286 VGND.n194 VGND.n55 3.0725
R287 VGND.n195 VGND.n194 3.0725
R288 VGND.n196 VGND.n195 3.0725
R289 VGND.n196 VGND.n53 3.0725
R290 VGND.n200 VGND.n53 3.0725
R291 VGND.n201 VGND.n200 3.0725
R292 VGND.n202 VGND.n201 3.0725
R293 VGND.n202 VGND.n51 3.0725
R294 VGND.n206 VGND.n51 3.0725
R295 VGND.n207 VGND.n206 3.0725
R296 VGND.n208 VGND.n207 3.0725
R297 VGND.n208 VGND.n49 3.0725
R298 VGND.n212 VGND.n49 3.0725
R299 VGND.n213 VGND.n212 3.0725
R300 VGND.n214 VGND.n213 3.0725
R301 VGND.n214 VGND.n47 3.0725
R302 VGND.n218 VGND.n47 3.0725
R303 VGND.n219 VGND.n218 3.0725
R304 VGND.n220 VGND.n219 3.0725
R305 VGND.n220 VGND.n45 3.0725
R306 VGND.n224 VGND.n45 3.0725
R307 VGND.n225 VGND.n224 3.0725
R308 VGND.n226 VGND.n225 3.0725
R309 VGND.n226 VGND.n43 3.0725
R310 VGND.n230 VGND.n43 3.0725
R311 VGND.n231 VGND.n230 3.0725
R312 VGND.n232 VGND.n231 3.0725
R313 VGND.n232 VGND.n41 3.0725
R314 VGND.n236 VGND.n41 3.0725
R315 VGND.n237 VGND.n236 3.0725
R316 VGND.n238 VGND.n237 3.0725
R317 VGND.n238 VGND.n39 3.0725
R318 VGND.n242 VGND.n39 3.0725
R319 VGND.n243 VGND.n242 3.0725
R320 VGND.n244 VGND.n243 3.0725
R321 VGND.n244 VGND.n37 3.0725
R322 VGND.n248 VGND.n37 3.0725
R323 VGND.n249 VGND.n248 3.0725
R324 VGND.n250 VGND.n249 3.0725
R325 VGND.n250 VGND.n35 3.0725
R326 VGND.n254 VGND.n35 3.0725
R327 VGND.n255 VGND.n254 3.0725
R328 VGND.n256 VGND.n255 3.0725
R329 VGND.n256 VGND.n33 3.0725
R330 VGND.n260 VGND.n33 3.0725
R331 VGND.n261 VGND.n260 3.0725
R332 VGND.n262 VGND.n261 3.0725
R333 VGND.n262 VGND.n31 3.0725
R334 VGND.n266 VGND.n31 3.0725
R335 VGND.n267 VGND.n266 3.0725
R336 VGND.n268 VGND.n267 3.0725
R337 VGND.n268 VGND.n29 3.0725
R338 VGND.n272 VGND.n29 3.0725
R339 VGND.n273 VGND.n272 3.0725
R340 VGND.n274 VGND.n273 3.0725
R341 VGND.n274 VGND.n27 3.0725
R342 VGND.n278 VGND.n27 3.0725
R343 VGND.n279 VGND.n278 3.0725
R344 VGND.n280 VGND.n279 3.0725
R345 VGND.n280 VGND.n25 3.0725
R346 VGND.n284 VGND.n25 3.0725
R347 VGND.n285 VGND.n284 3.0725
R348 VGND.n286 VGND.n285 3.0725
R349 VGND.n286 VGND.n23 3.0725
R350 VGND.n290 VGND.n23 3.0725
R351 VGND.n291 VGND.n290 3.0725
R352 VGND.n292 VGND.n291 3.0725
R353 VGND.n292 VGND.n21 3.0725
R354 VGND.n296 VGND.n21 3.0725
R355 VGND.n297 VGND.n296 3.0725
R356 VGND.n298 VGND.n297 3.0725
R357 VGND.n298 VGND.n19 3.0725
R358 VGND.n302 VGND.n19 3.0725
R359 VGND.n303 VGND.n302 3.0725
R360 VGND.n304 VGND.n303 3.0725
R361 VGND.n304 VGND.n17 3.0725
R362 VGND.n308 VGND.n17 3.0725
R363 VGND.n309 VGND.n308 3.0725
R364 VGND.n310 VGND.n309 3.0725
R365 VGND.n310 VGND.n15 3.0725
R366 VGND.n314 VGND.n15 3.0725
R367 VGND.n315 VGND.n314 3.0725
R368 VGND.n316 VGND.n315 3.0725
R369 VGND.n316 VGND.n13 3.0725
R370 VGND.n320 VGND.n13 3.0725
R371 VGND.n321 VGND.n320 3.0725
R372 VGND.n322 VGND.n321 3.0725
R373 VGND.n322 VGND.n11 3.0725
R374 VGND.n326 VGND.n11 3.0725
R375 VGND.n327 VGND.n326 3.0725
R376 VGND.n328 VGND.n327 3.0725
R377 VGND.n328 VGND.n9 3.0725
R378 VGND.n332 VGND.n9 3.0725
R379 VGND.n333 VGND.n332 3.0725
R380 VGND.n334 VGND.n333 3.0725
R381 VGND.n334 VGND.n7 3.0725
R382 VGND.n338 VGND.n7 3.0725
R383 VGND.n339 VGND.n338 3.0725
R384 VGND.n340 VGND.n339 3.0725
R385 VGND.n340 VGND.n5 3.0725
R386 VGND.n344 VGND.n5 3.0725
R387 VGND.n345 VGND.n344 3.0725
R388 VGND.n346 VGND.n345 3.0725
R389 VGND.n346 VGND.n3 3.0725
R390 VGND.n350 VGND.n3 3.0725
R391 VGND.n351 VGND.n350 3.0725
R392 VGND.n352 VGND.n351 3.0725
R393 VGND.n352 VGND.n1 3.0725
R394 VGND.n356 VGND.n1 3.0725
R395 VGND.n357 VGND.n356 3.0725
R396 VGND.n180 VGND.n59 2.248
R397 VGND.n182 VGND.n180 2.248
R398 VGND.n360 VGND.n359 1.94826
R399 VGND.n180 VGND.n179 0.997156
R400 VGND.n91 VGND.n89 0.371793
R401 VGND.n183 VGND.n58 0.371793
R402 VGND VGND.n360 0.2155
R403 VGND.n177 VGND.n176 0.0707101
R404 VGND.n359 VGND.n358 0.0546562
R405 VGND.n93 VGND.n92 0.0305
R406 VGND.n93 VGND.n87 0.0305
R407 VGND.n97 VGND.n87 0.0305
R408 VGND.n98 VGND.n97 0.0305
R409 VGND.n99 VGND.n98 0.0305
R410 VGND.n99 VGND.n85 0.0305
R411 VGND.n103 VGND.n85 0.0305
R412 VGND.n104 VGND.n103 0.0305
R413 VGND.n105 VGND.n104 0.0305
R414 VGND.n105 VGND.n83 0.0305
R415 VGND.n109 VGND.n83 0.0305
R416 VGND.n110 VGND.n109 0.0305
R417 VGND.n111 VGND.n110 0.0305
R418 VGND.n111 VGND.n81 0.0305
R419 VGND.n115 VGND.n81 0.0305
R420 VGND.n116 VGND.n115 0.0305
R421 VGND.n117 VGND.n116 0.0305
R422 VGND.n117 VGND.n79 0.0305
R423 VGND.n121 VGND.n79 0.0305
R424 VGND.n122 VGND.n121 0.0305
R425 VGND.n123 VGND.n122 0.0305
R426 VGND.n123 VGND.n77 0.0305
R427 VGND.n127 VGND.n77 0.0305
R428 VGND.n128 VGND.n127 0.0305
R429 VGND.n129 VGND.n128 0.0305
R430 VGND.n129 VGND.n75 0.0305
R431 VGND.n133 VGND.n75 0.0305
R432 VGND.n134 VGND.n133 0.0305
R433 VGND.n135 VGND.n134 0.0305
R434 VGND.n135 VGND.n73 0.0305
R435 VGND.n139 VGND.n73 0.0305
R436 VGND.n140 VGND.n139 0.0305
R437 VGND.n141 VGND.n140 0.0305
R438 VGND.n141 VGND.n71 0.0305
R439 VGND.n145 VGND.n71 0.0305
R440 VGND.n146 VGND.n145 0.0305
R441 VGND.n147 VGND.n146 0.0305
R442 VGND.n147 VGND.n69 0.0305
R443 VGND.n151 VGND.n69 0.0305
R444 VGND.n152 VGND.n151 0.0305
R445 VGND.n153 VGND.n152 0.0305
R446 VGND.n153 VGND.n67 0.0305
R447 VGND.n157 VGND.n67 0.0305
R448 VGND.n158 VGND.n157 0.0305
R449 VGND.n159 VGND.n158 0.0305
R450 VGND.n159 VGND.n65 0.0305
R451 VGND.n163 VGND.n65 0.0305
R452 VGND.n164 VGND.n163 0.0305
R453 VGND.n165 VGND.n164 0.0305
R454 VGND.n165 VGND.n63 0.0305
R455 VGND.n169 VGND.n63 0.0305
R456 VGND.n170 VGND.n169 0.0305
R457 VGND.n171 VGND.n170 0.0305
R458 VGND.n171 VGND.n61 0.0305
R459 VGND.n175 VGND.n61 0.0305
R460 VGND.n176 VGND.n175 0.0305
R461 VGND.n186 VGND.n185 0.0305
R462 VGND.n187 VGND.n186 0.0305
R463 VGND.n187 VGND.n56 0.0305
R464 VGND.n191 VGND.n56 0.0305
R465 VGND.n192 VGND.n191 0.0305
R466 VGND.n193 VGND.n192 0.0305
R467 VGND.n193 VGND.n54 0.0305
R468 VGND.n197 VGND.n54 0.0305
R469 VGND.n198 VGND.n197 0.0305
R470 VGND.n199 VGND.n198 0.0305
R471 VGND.n199 VGND.n52 0.0305
R472 VGND.n203 VGND.n52 0.0305
R473 VGND.n204 VGND.n203 0.0305
R474 VGND.n205 VGND.n204 0.0305
R475 VGND.n205 VGND.n50 0.0305
R476 VGND.n209 VGND.n50 0.0305
R477 VGND.n210 VGND.n209 0.0305
R478 VGND.n211 VGND.n210 0.0305
R479 VGND.n211 VGND.n48 0.0305
R480 VGND.n215 VGND.n48 0.0305
R481 VGND.n216 VGND.n215 0.0305
R482 VGND.n217 VGND.n216 0.0305
R483 VGND.n217 VGND.n46 0.0305
R484 VGND.n221 VGND.n46 0.0305
R485 VGND.n222 VGND.n221 0.0305
R486 VGND.n223 VGND.n222 0.0305
R487 VGND.n223 VGND.n44 0.0305
R488 VGND.n227 VGND.n44 0.0305
R489 VGND.n228 VGND.n227 0.0305
R490 VGND.n229 VGND.n228 0.0305
R491 VGND.n229 VGND.n42 0.0305
R492 VGND.n233 VGND.n42 0.0305
R493 VGND.n234 VGND.n233 0.0305
R494 VGND.n235 VGND.n234 0.0305
R495 VGND.n235 VGND.n40 0.0305
R496 VGND.n239 VGND.n40 0.0305
R497 VGND.n240 VGND.n239 0.0305
R498 VGND.n241 VGND.n240 0.0305
R499 VGND.n241 VGND.n38 0.0305
R500 VGND.n245 VGND.n38 0.0305
R501 VGND.n246 VGND.n245 0.0305
R502 VGND.n247 VGND.n246 0.0305
R503 VGND.n247 VGND.n36 0.0305
R504 VGND.n251 VGND.n36 0.0305
R505 VGND.n252 VGND.n251 0.0305
R506 VGND.n253 VGND.n252 0.0305
R507 VGND.n253 VGND.n34 0.0305
R508 VGND.n257 VGND.n34 0.0305
R509 VGND.n258 VGND.n257 0.0305
R510 VGND.n259 VGND.n258 0.0305
R511 VGND.n259 VGND.n32 0.0305
R512 VGND.n263 VGND.n32 0.0305
R513 VGND.n264 VGND.n263 0.0305
R514 VGND.n265 VGND.n264 0.0305
R515 VGND.n265 VGND.n30 0.0305
R516 VGND.n269 VGND.n30 0.0305
R517 VGND.n270 VGND.n269 0.0305
R518 VGND.n271 VGND.n270 0.0305
R519 VGND.n271 VGND.n28 0.0305
R520 VGND.n275 VGND.n28 0.0305
R521 VGND.n276 VGND.n275 0.0305
R522 VGND.n277 VGND.n276 0.0305
R523 VGND.n277 VGND.n26 0.0305
R524 VGND.n281 VGND.n26 0.0305
R525 VGND.n282 VGND.n281 0.0305
R526 VGND.n283 VGND.n282 0.0305
R527 VGND.n283 VGND.n24 0.0305
R528 VGND.n287 VGND.n24 0.0305
R529 VGND.n288 VGND.n287 0.0305
R530 VGND.n289 VGND.n288 0.0305
R531 VGND.n289 VGND.n22 0.0305
R532 VGND.n293 VGND.n22 0.0305
R533 VGND.n294 VGND.n293 0.0305
R534 VGND.n295 VGND.n294 0.0305
R535 VGND.n295 VGND.n20 0.0305
R536 VGND.n299 VGND.n20 0.0305
R537 VGND.n300 VGND.n299 0.0305
R538 VGND.n301 VGND.n300 0.0305
R539 VGND.n301 VGND.n18 0.0305
R540 VGND.n305 VGND.n18 0.0305
R541 VGND.n306 VGND.n305 0.0305
R542 VGND.n307 VGND.n306 0.0305
R543 VGND.n307 VGND.n16 0.0305
R544 VGND.n311 VGND.n16 0.0305
R545 VGND.n312 VGND.n311 0.0305
R546 VGND.n313 VGND.n312 0.0305
R547 VGND.n313 VGND.n14 0.0305
R548 VGND.n317 VGND.n14 0.0305
R549 VGND.n318 VGND.n317 0.0305
R550 VGND.n319 VGND.n318 0.0305
R551 VGND.n319 VGND.n12 0.0305
R552 VGND.n323 VGND.n12 0.0305
R553 VGND.n324 VGND.n323 0.0305
R554 VGND.n325 VGND.n324 0.0305
R555 VGND.n325 VGND.n10 0.0305
R556 VGND.n329 VGND.n10 0.0305
R557 VGND.n330 VGND.n329 0.0305
R558 VGND.n331 VGND.n330 0.0305
R559 VGND.n331 VGND.n8 0.0305
R560 VGND.n335 VGND.n8 0.0305
R561 VGND.n336 VGND.n335 0.0305
R562 VGND.n337 VGND.n336 0.0305
R563 VGND.n337 VGND.n6 0.0305
R564 VGND.n341 VGND.n6 0.0305
R565 VGND.n342 VGND.n341 0.0305
R566 VGND.n343 VGND.n342 0.0305
R567 VGND.n343 VGND.n4 0.0305
R568 VGND.n347 VGND.n4 0.0305
R569 VGND.n348 VGND.n347 0.0305
R570 VGND.n349 VGND.n348 0.0305
R571 VGND.n349 VGND.n2 0.0305
R572 VGND.n353 VGND.n2 0.0305
R573 VGND.n354 VGND.n353 0.0305
R574 VGND.n355 VGND.n354 0.0290938
R575 VGND.n355 VGND.n0 0.028625
R576 VGND.n92 VGND.n91 0.0196667
R577 VGND.n185 VGND.n58 0.0196667
R578 VGND.n90 VGND.n59 0.018625
R579 VGND.n182 VGND.n181 0.018625
R580 VGND.n91 VGND.n90 0.016125
R581 VGND.n181 VGND.n58 0.016125
R582 VGND.n359 VGND.n0 0.009875
C0 b2 d 0.16562f
C1 e a_8500_10000# 0.16543f
C2 e d 0.35812f
C3 b4 e 0.16631f
C4 b6 b5 0.01056f
C5 c a_5500_10000# 0.16543f
C6 a_2500_10000# r2r_startmod_0.a 0.16543f
C7 b a_4000_10000# 0.16543f
C8 g a_10000_10000# 0.16543f
C9 b5 g 0.16562f
C10 c b1 0.16562f
C11 d a_5500_10000# 0.16543f
C12 b6 g 0.16631f
C13 b c 0.35812f
C14 f a_10000_10000# 0.16543f
C15 b5 f 0.16631f
C16 b2 b1 0.01056f
C17 b3 b2 0.01056f
C18 r2r_startmod_0.a a_1000_10000# 0.16543f
C19 a_7000_10000# d 0.16543f
C20 b3 d 0.16631f
C21 b3 b4 0.01056f
C22 a_7000_10000# e 0.16543f
C23 b r2r_startmod_0.a 0.33088f
C24 b3 e 0.16562f
C25 f g 0.35812f
C26 a_1000_10000# a_0_10000# 0.16543f
C27 a_2500_10000# b 0.16543f
C28 b5 b4 0.01056f
C29 out b6 0.18959f
C30 c a_4000_10000# 0.16543f
C31 out b7 0.19492f
C32 out g 0
C33 a_11500_10000# g 0.16543f
C34 c b2 0.16631f
C35 f a_8500_10000# 0.16543f
C36 b4 f 0.16562f
C37 b0 r2r_startmod_0.a 0.16562f
C38 b b1 0.16631f
C39 f e 0.35812f
C40 c d 0.35812f
C41 b7 VGND 1.02648f
C42 out VGND 1.30142f
C43 b6 VGND 1.00596f
C44 b5 VGND 1.00744f
C45 b4 VGND 1.00744f
C46 b3 VGND 1.00744f
C47 b2 VGND 1.00744f
C48 b1 VGND 1.00858f
C49 b0 VGND 1.04119f
C50 a_11500_10000# VGND 1.27134f
C51 a_10000_10000# VGND 1.10584f
C52 g VGND 5.38595f
C53 a_8500_10000# VGND 1.10584f
C54 f VGND 4.99336f
C55 a_7000_10000# VGND 1.10584f
C56 e VGND 4.99336f
C57 a_5500_10000# VGND 1.10584f
C58 d VGND 4.99336f
C59 a_4000_10000# VGND 1.10584f
C60 c VGND 4.99336f
C61 a_2500_10000# VGND 1.10584f
C62 b VGND 5.18789f
C63 a_1000_10000# VGND 1.10584f
C64 r2r_startmod_0.a VGND 6.25163f
C65 a_0_10000# VGND 1.27134f
C66 b0.t0 VGND 0.01784f
C67 b1.t0 VGND 0.03689f
C68 b2.t0 VGND 0.03802f
C69 b3.t0 VGND 0.03802f
C70 b4.t0 VGND 0.03802f
C71 b5.t0 VGND 0.03802f
C72 b6.t0 VGND 0.03947f
C73 out.t0 VGND 0.01883f
C74 out.t1 VGND 0.01933f
C75 out.n0 VGND 0.3268f
C76 b7.t0 VGND 0.02099f
.ends
