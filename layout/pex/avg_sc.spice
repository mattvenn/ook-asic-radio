* avg_sc: magic R+C extraction of layout/avg_sc.gds (layout/pex.sh)
.subckt avg_sc in phi1 phi2 out VDD VSS
X0 cs phi1b in.t1 VDD.t0 sky130_fd_pr__pfet_01v8 ad=0.3 pd=2.6 as=0.3 ps=2.6 w=1 l=0.15
X1 out.t0 phi2.t0 cs VSS.t4 sky130_fd_pr__nfet_01v8 ad=0.15 pd=1.6 as=0.15 ps=1.6 w=0.5 l=0.15
X2 phi1b phi1.t2 VDD.t5 VDD.t4 sky130_fd_pr__pfet_01v8 ad=0.3 pd=2.6 as=0.3 ps=2.6 w=1 l=0.15
X3 phi1b phi1.t1 VSS.t7 VSS.t6 sky130_fd_pr__nfet_01v8 ad=0.15 pd=1.6 as=0.15 ps=1.6 w=0.5 l=0.15
X4 out.t3 VSS.t0 sky130_fd_pr__cap_mim_m3_1 l=30 w=30
X5 phi2b phi2.t1 VSS.t3 VSS.t2 sky130_fd_pr__nfet_01v8 ad=0.15 pd=1.6 as=0.15 ps=1.6 w=0.5 l=0.15
X6 out.t1 phi2b cs VDD.t3 sky130_fd_pr__pfet_01v8 ad=0.3 pd=2.6 as=0.3 ps=2.6 w=1 l=0.15
X7 out.t2 VSS.t1 sky130_fd_pr__cap_mim_m3_1 l=30 w=30
X8 phi2b phi2.t2 VDD.t2 VDD.t1 sky130_fd_pr__pfet_01v8 ad=0.3 pd=2.6 as=0.3 ps=2.6 w=1 l=0.15
X9 cs phi1.t0 in.t0 VSS.t8 sky130_fd_pr__nfet_01v8 ad=0.15 pd=1.6 as=0.15 ps=1.6 w=0.5 l=0.15
X10 cs VSS.t5 sky130_fd_pr__cap_mim_m3_1 l=7 w=7
R0 out.n2 out.t1 361.731
R1 out.n2 out.t0 237.417
R2 out.n3 out.n2 3.43118
R3 out out.n1 3.4293
R4 out.n3 out.n1 3.4105
R5 out.n1 out.n0 1.05666
R6 out out.t2 0.643688
R7 out.n0 out 0.465296
R8 out.n0 out.t3 0.0207703
R9 out out.n3 0.0193
R10 in.n0 in.t1 361.731
R11 in.n0 in.t0 237.345
R12 in in.n0 3.78556
R13 phi2.n0 phi2.t2 422.151
R14 phi2.n1 phi2.t0 344.603
R15 phi2.n0 phi2.t1 340.817
R16 phi2.n1 phi2.n0 3.4105
R17 phi2 phi2.n1 0.24396
R18 phi1.n0 phi1.t2 421.483
R19 phi1.n1 phi1.t0 345.269
R20 phi1.n0 phi1.t1 341.483
R21 phi1.n1 phi1.n0 3.4105
R22 phi1 phi1.n1 0.08886
R23 VDD.n151 VDD.t5 356.659
R24 VDD.n158 VDD.t2 356.659
R25 VDD.n15 VDD.n14 276
R26 VDD.n140 VDD.n22 276
R27 VDD.n78 VDD.n57 276
R28 VDD.n76 VDD.n60 276
R29 VDD.n76 VDD.n75 185
R30 VDD.n77 VDD.n76 185
R31 VDD.n52 VDD.n51 185
R32 VDD.n59 VDD.n52 185
R33 VDD.n87 VDD.n86 185
R34 VDD.n86 VDD.n85 185
R35 VDD.n48 VDD.n47 185
R36 VDD.n47 VDD.n46 185
R37 VDD.n94 VDD.n93 185
R38 VDD.n95 VDD.n94 185
R39 VDD.n49 VDD.n37 185
R40 VDD.n39 VDD.n37 185
R41 VDD.n105 VDD.n38 185
R42 VDD.n105 VDD.n104 185
R43 VDD.n106 VDD.n2 185
R44 VDD.n107 VDD.n106 185
R45 VDD.n163 VDD.n3 185
R46 VDD.n108 VDD.n3 185
R47 VDD.n162 VDD.n4 185
R48 VDD.n110 VDD.n4 185
R49 VDD.n161 VDD.n5 185
R50 VDD.n109 VDD.n5 185
R51 VDD.n118 VDD.n6 185
R52 VDD.n119 VDD.n118 185
R53 VDD.n156 VDD.n8 185
R54 VDD.n120 VDD.n8 185
R55 VDD.n155 VDD.n9 185
R56 VDD.n121 VDD.n9 185
R57 VDD.n154 VDD.n10 185
R58 VDD.n25 VDD.n10 185
R59 VDD.n130 VDD.n11 185
R60 VDD.n131 VDD.n130 185
R61 VDD.n150 VDD.n13 185
R62 VDD.n132 VDD.n13 185
R63 VDD.n149 VDD.n14 185
R64 VDD.n139 VDD.n14 185
R65 VDD.n61 VDD.n60 185
R66 VDD.n71 VDD.n64 185
R67 VDD.n70 VDD.n65 185
R68 VDD.n65 VDD.n58 185
R69 VDD.n69 VDD.n67 185
R70 VDD.n57 VDD.n56 185
R71 VDD.n141 VDD.n140 185
R72 VDD.n140 VDD.n139 185
R73 VDD.n24 VDD.n23 185
R74 VDD.n132 VDD.n24 185
R75 VDD.n129 VDD.n128 185
R76 VDD.n131 VDD.n129 185
R77 VDD.n27 VDD.n26 185
R78 VDD.n26 VDD.n25 185
R79 VDD.n123 VDD.n122 185
R80 VDD.n122 VDD.n121 185
R81 VDD.n30 VDD.n29 185
R82 VDD.n120 VDD.n30 185
R83 VDD.n117 VDD.n116 185
R84 VDD.n119 VDD.n117 185
R85 VDD.n32 VDD.n31 185
R86 VDD.n109 VDD.n31 185
R87 VDD.n112 VDD.n111 185
R88 VDD.n111 VDD.n110 185
R89 VDD.n35 VDD.n34 185
R90 VDD.n108 VDD.n35 185
R91 VDD.n42 VDD.n36 185
R92 VDD.n107 VDD.n36 185
R93 VDD.n103 VDD.n102 185
R94 VDD.n104 VDD.n103 185
R95 VDD.n41 VDD.n40 185
R96 VDD.n40 VDD.n39 185
R97 VDD.n97 VDD.n96 185
R98 VDD.n96 VDD.n95 185
R99 VDD.n45 VDD.n44 185
R100 VDD.n46 VDD.n45 185
R101 VDD.n84 VDD.n83 185
R102 VDD.n85 VDD.n84 185
R103 VDD.n54 VDD.n53 185
R104 VDD.n59 VDD.n53 185
R105 VDD.n79 VDD.n78 185
R106 VDD.n78 VDD.n77 185
R107 VDD.n142 VDD.n22 185
R108 VDD.n135 VDD.n21 185
R109 VDD.n136 VDD.n18 185
R110 VDD.n134 VDD.n16 185
R111 VDD.n148 VDD.n15 185
R112 VDD.n138 VDD.n15 185
R113 VDD.n134 VDD.n15 108.001
R114 VDD.n136 VDD.n135 108.001
R115 VDD.n78 VDD.n53 108.001
R116 VDD.n84 VDD.n53 108.001
R117 VDD.n84 VDD.n45 108.001
R118 VDD.n96 VDD.n45 108.001
R119 VDD.n96 VDD.n40 108.001
R120 VDD.n103 VDD.n40 108.001
R121 VDD.n103 VDD.n36 108.001
R122 VDD.n36 VDD.n35 108.001
R123 VDD.n111 VDD.n35 108.001
R124 VDD.n111 VDD.n31 108.001
R125 VDD.n117 VDD.n31 108.001
R126 VDD.n117 VDD.n30 108.001
R127 VDD.n122 VDD.n30 108.001
R128 VDD.n122 VDD.n26 108.001
R129 VDD.n129 VDD.n26 108.001
R130 VDD.n129 VDD.n24 108.001
R131 VDD.n140 VDD.n24 108.001
R132 VDD.n65 VDD.n64 108.001
R133 VDD.n67 VDD.n65 108.001
R134 VDD.n76 VDD.n52 108.001
R135 VDD.n86 VDD.n52 108.001
R136 VDD.n86 VDD.n47 108.001
R137 VDD.n94 VDD.n47 108.001
R138 VDD.n94 VDD.n37 108.001
R139 VDD.n105 VDD.n37 108.001
R140 VDD.n106 VDD.n105 108.001
R141 VDD.n106 VDD.n3 108.001
R142 VDD.n4 VDD.n3 108.001
R143 VDD.n5 VDD.n4 108.001
R144 VDD.n118 VDD.n5 108.001
R145 VDD.n118 VDD.n8 108.001
R146 VDD.n9 VDD.n8 108.001
R147 VDD.n10 VDD.n9 108.001
R148 VDD.n130 VDD.n10 108.001
R149 VDD.n130 VDD.n13 108.001
R150 VDD.n14 VDD.n13 108.001
R151 VDD.n77 VDD.n58 99.5243
R152 VDD.n139 VDD.n138 99.5243
R153 VDD.n77 VDD.n59 81.4291
R154 VDD.n85 VDD.n46 81.4291
R155 VDD.n95 VDD.n46 81.4291
R156 VDD.n95 VDD.n39 81.4291
R157 VDD.n104 VDD.n39 81.4291
R158 VDD.n108 VDD.n107 81.4291
R159 VDD.n110 VDD.n108 81.4291
R160 VDD.n110 VDD.n109 81.4291
R161 VDD.n120 VDD.n119 81.4291
R162 VDD.n121 VDD.n120 81.4291
R163 VDD.n121 VDD.n25 81.4291
R164 VDD.n131 VDD.n25 81.4291
R165 VDD.n139 VDD.n132 81.4291
R166 VDD.n63 VDD.n58 71.6014
R167 VDD.n66 VDD.n58 71.6014
R168 VDD.n138 VDD.n133 71.6014
R169 VDD.n138 VDD.n137 71.6014
R170 VDD.n107 VDD.t0 64.4648
R171 VDD.n109 VDD.t1 64.4648
R172 VDD.n59 VDD.t3 50.8934
R173 VDD.n132 VDD.t4 50.8934
R174 VDD.n137 VDD.n136 41.8002
R175 VDD.n133 VDD.n22 41.8002
R176 VDD.n63 VDD.n60 41.8002
R177 VDD.n67 VDD.n66 41.8002
R178 VDD.n64 VDD.n63 41.8002
R179 VDD.n66 VDD.n57 41.8002
R180 VDD.n135 VDD.n133 41.8002
R181 VDD.n137 VDD.n134 41.8002
R182 VDD.n85 VDD.t3 30.5362
R183 VDD.t4 VDD.n131 30.5362
R184 VDD.n75 VDD.n61 29.4405
R185 VDD.n149 VDD.n148 29.4405
R186 VDD.n79 VDD.n56 29.4405
R187 VDD.n142 VDD.n141 29.4405
R188 VDD.n104 VDD.t0 16.9648
R189 VDD.n119 VDD.t1 16.9648
R190 VDD.n75 VDD.n51 11.5205
R191 VDD.n87 VDD.n51 11.5205
R192 VDD.n87 VDD.n48 11.5205
R193 VDD.n93 VDD.n48 11.5205
R194 VDD.n93 VDD.n49 11.5205
R195 VDD.n49 VDD.n38 11.5205
R196 VDD.n38 VDD.n2 11.5205
R197 VDD.n163 VDD.n2 11.5205
R198 VDD.n163 VDD.n162 11.5205
R199 VDD.n162 VDD.n161 11.5205
R200 VDD.n161 VDD.n6 11.5205
R201 VDD.n156 VDD.n6 11.5205
R202 VDD.n156 VDD.n155 11.5205
R203 VDD.n155 VDD.n154 11.5205
R204 VDD.n154 VDD.n11 11.5205
R205 VDD.n150 VDD.n11 11.5205
R206 VDD.n150 VDD.n149 11.5205
R207 VDD.n71 VDD.n61 11.5205
R208 VDD.n71 VDD.n70 11.5205
R209 VDD.n70 VDD.n69 11.5205
R210 VDD.n69 VDD.n56 11.5205
R211 VDD.n79 VDD.n54 11.5205
R212 VDD.n83 VDD.n54 11.5205
R213 VDD.n83 VDD.n44 11.5205
R214 VDD.n97 VDD.n44 11.5205
R215 VDD.n97 VDD.n41 11.5205
R216 VDD.n102 VDD.n41 11.5205
R217 VDD.n102 VDD.n42 11.5205
R218 VDD.n42 VDD.n34 11.5205
R219 VDD.n112 VDD.n34 11.5205
R220 VDD.n112 VDD.n32 11.5205
R221 VDD.n116 VDD.n32 11.5205
R222 VDD.n116 VDD.n29 11.5205
R223 VDD.n123 VDD.n29 11.5205
R224 VDD.n123 VDD.n27 11.5205
R225 VDD.n128 VDD.n27 11.5205
R226 VDD.n128 VDD.n23 11.5205
R227 VDD.n141 VDD.n23 11.5205
R228 VDD.n148 VDD.n16 11.5205
R229 VDD.n18 VDD.n16 11.5205
R230 VDD.n21 VDD.n18 11.5205
R231 VDD.n142 VDD.n21 11.5205
R232 VDD.n143 VDD.n142 9.3005
R233 VDD.n21 VDD.n19 9.3005
R234 VDD.n145 VDD.n18 9.3005
R235 VDD.n146 VDD.n16 9.3005
R236 VDD.n148 VDD.n147 9.3005
R237 VDD.n141 VDD.n20 9.3005
R238 VDD.n126 VDD.n23 9.3005
R239 VDD.n128 VDD.n127 9.3005
R240 VDD.n125 VDD.n27 9.3005
R241 VDD.n124 VDD.n123 9.3005
R242 VDD.n29 VDD.n28 9.3005
R243 VDD.n116 VDD.n115 9.3005
R244 VDD.n114 VDD.n32 9.3005
R245 VDD.n113 VDD.n112 9.3005
R246 VDD.n34 VDD.n33 9.3005
R247 VDD.n100 VDD.n42 9.3005
R248 VDD.n102 VDD.n101 9.3005
R249 VDD.n99 VDD.n41 9.3005
R250 VDD.n98 VDD.n97 9.3005
R251 VDD.n44 VDD.n43 9.3005
R252 VDD.n83 VDD.n82 9.3005
R253 VDD.n81 VDD.n54 9.3005
R254 VDD.n80 VDD.n79 9.3005
R255 VDD.n73 VDD.n61 9.3005
R256 VDD.n72 VDD.n71 9.3005
R257 VDD.n70 VDD.n62 9.3005
R258 VDD.n69 VDD.n68 9.3005
R259 VDD.n56 VDD.n55 9.3005
R260 VDD.n75 VDD.n74 9.3005
R261 VDD.n51 VDD.n50 9.3005
R262 VDD.n88 VDD.n87 9.3005
R263 VDD.n89 VDD.n48 9.3005
R264 VDD.n93 VDD.n92 9.3005
R265 VDD.n91 VDD.n49 9.3005
R266 VDD.n90 VDD.n38 9.3005
R267 VDD.n2 VDD.n0 9.3005
R268 VDD.n164 VDD.n163 9.3005
R269 VDD.n162 VDD.n1 9.3005
R270 VDD.n161 VDD.n160 9.3005
R271 VDD.n159 VDD.n6 9.3005
R272 VDD.n157 VDD.n156 9.3005
R273 VDD.n155 VDD.n7 9.3005
R274 VDD.n154 VDD.n153 9.3005
R275 VDD.n152 VDD.n11 9.3005
R276 VDD.n151 VDD.n150 9.3005
R277 VDD.n149 VDD.n12 9.3005
R278 VDD.n145 VDD.n17 1.0005
R279 VDD.n145 VDD.n144 1.0005
R280 VDD.n144 VDD.n143 0.363938
R281 VDD.n147 VDD.n17 0.34675
R282 VDD.n80 VDD.n55 0.288
R283 VDD VDD.n165 0.229278
R284 VDD.n74 VDD.n73 0.187167
R285 VDD.n147 VDD.n146 0.1805
R286 VDD.n146 VDD.n145 0.1805
R287 VDD.n145 VDD.n19 0.1805
R288 VDD.n143 VDD.n19 0.1805
R289 VDD.n81 VDD.n80 0.113
R290 VDD.n82 VDD.n81 0.113
R291 VDD.n82 VDD.n43 0.113
R292 VDD.n98 VDD.n43 0.113
R293 VDD.n99 VDD.n98 0.113
R294 VDD.n101 VDD.n99 0.113
R295 VDD.n101 VDD.n100 0.113
R296 VDD.n100 VDD.n33 0.113
R297 VDD.n113 VDD.n33 0.113
R298 VDD.n114 VDD.n113 0.113
R299 VDD.n115 VDD.n114 0.113
R300 VDD.n115 VDD.n28 0.113
R301 VDD.n124 VDD.n28 0.113
R302 VDD.n125 VDD.n124 0.113
R303 VDD.n127 VDD.n125 0.113
R304 VDD.n127 VDD.n126 0.113
R305 VDD.n126 VDD.n20 0.113
R306 VDD.n73 VDD.n72 0.113
R307 VDD.n72 VDD.n62 0.113
R308 VDD.n68 VDD.n62 0.113
R309 VDD.n68 VDD.n55 0.113
R310 VDD.n144 VDD.n20 0.0989375
R311 VDD.n74 VDD.n50 0.0305
R312 VDD.n88 VDD.n50 0.0305
R313 VDD.n89 VDD.n88 0.0305
R314 VDD.n92 VDD.n89 0.0305
R315 VDD.n92 VDD.n91 0.0305
R316 VDD.n91 VDD.n90 0.0305
R317 VDD.n90 VDD.n0 0.0305
R318 VDD.n164 VDD.n1 0.0305
R319 VDD.n160 VDD.n1 0.0305
R320 VDD.n160 VDD.n159 0.0305
R321 VDD.n157 VDD.n7 0.0305
R322 VDD.n153 VDD.n7 0.0305
R323 VDD.n153 VDD.n152 0.0305
R324 VDD.n152 VDD.n151 0.0305
R325 VDD.n151 VDD.n12 0.0305
R326 VDD.n17 VDD.n12 0.02675
R327 VDD.n165 VDD.n0 0.0225833
R328 VDD.n158 VDD.n157 0.018
R329 VDD.n159 VDD.n158 0.013
R330 VDD.n165 VDD.n164 0.00841667
R331 VSS.n78 VSS.n77 585
R332 VSS.n79 VSS.n78 585
R333 VSS.n56 VSS.n55 585
R334 VSS.n63 VSS.n56 585
R335 VSS.n89 VSS.n88 585
R336 VSS.n88 VSS.n87 585
R337 VSS.n53 VSS.n52 585
R338 VSS.n52 VSS.n51 585
R339 VSS.n94 VSS.n93 585
R340 VSS.n95 VSS.n94 585
R341 VSS.n43 VSS.n42 585
R342 VSS.n44 VSS.n43 585
R343 VSS.n105 VSS.n104 585
R344 VSS.n104 VSS.n103 585
R345 VSS.n40 VSS.n39 585
R346 VSS.n39 VSS.n38 585
R347 VSS.n110 VSS.n109 585
R348 VSS.n111 VSS.n110 585
R349 VSS.n37 VSS.n36 585
R350 VSS.n112 VSS.n37 585
R351 VSS.n115 VSS.n114 585
R352 VSS.n114 VSS.n113 585
R353 VSS.n34 VSS.n33 585
R354 VSS.n33 VSS.n32 585
R355 VSS.n120 VSS.n119 585
R356 VSS.n121 VSS.n120 585
R357 VSS.n30 VSS.n29 585
R358 VSS.n122 VSS.n30 585
R359 VSS.n127 VSS.n126 585
R360 VSS.n126 VSS.n125 585
R361 VSS.n27 VSS.n26 585
R362 VSS.n124 VSS.n26 585
R363 VSS.n132 VSS.n131 585
R364 VSS.n132 VSS.n25 585
R365 VSS.n133 VSS.n22 585
R366 VSS.n134 VSS.n133 585
R367 VSS.n146 VSS.n18 585
R368 VSS.n137 VSS.n17 585
R369 VSS.n139 VSS.n138 585
R370 VSS.n140 VSS.n23 585
R371 VSS.n147 VSS.n16 585
R372 VSS.n134 VSS.n16 585
R373 VSS.n148 VSS.n15 585
R374 VSS.n25 VSS.n15 585
R375 VSS.n123 VSS.n13 585
R376 VSS.n124 VSS.n123 585
R377 VSS.n152 VSS.n12 585
R378 VSS.n125 VSS.n12 585
R379 VSS.n153 VSS.n11 585
R380 VSS.n122 VSS.n11 585
R381 VSS.n154 VSS.n10 585
R382 VSS.n121 VSS.n10 585
R383 VSS.n31 VSS.n8 585
R384 VSS.n32 VSS.n31 585
R385 VSS.n159 VSS.n7 585
R386 VSS.n113 VSS.n7 585
R387 VSS.n160 VSS.n6 585
R388 VSS.n112 VSS.n6 585
R389 VSS.n161 VSS.n5 585
R390 VSS.n111 VSS.n5 585
R391 VSS.n46 VSS.n4 585
R392 VSS.n46 VSS.n38 585
R393 VSS.n102 VSS.n101 585
R394 VSS.n103 VSS.n102 585
R395 VSS.n47 VSS.n45 585
R396 VSS.n45 VSS.n44 585
R397 VSS.n97 VSS.n96 585
R398 VSS.n96 VSS.n95 585
R399 VSS.n50 VSS.n49 585
R400 VSS.n51 VSS.n50 585
R401 VSS.n86 VSS.n85 585
R402 VSS.n87 VSS.n86 585
R403 VSS.n58 VSS.n57 585
R404 VSS.n63 VSS.n57 585
R405 VSS.n81 VSS.n80 585
R406 VSS.n80 VSS.n79 585
R407 VSS.n65 VSS.n64 585
R408 VSS.n73 VSS.n69 585
R409 VSS.n72 VSS.n71 585
R410 VSS.n61 VSS.n60 585
R411 VSS.n133 VSS.n23 418.625
R412 VSS.n18 VSS.n16 418.625
R413 VSS.n80 VSS.n61 418.625
R414 VSS.n78 VSS.n64 418.625
R415 VSS.n136 VSS.n135 254.01
R416 VSS.n135 VSS.n24 254.01
R417 VSS.n68 VSS.n62 254.01
R418 VSS.n70 VSS.n62 254.01
R419 VSS.n149 VSS.t7 230.63
R420 VSS.n156 VSS.t3 230.63
R421 VSS.n138 VSS.n137 177.3
R422 VSS.n80 VSS.n57 177.3
R423 VSS.n86 VSS.n57 177.3
R424 VSS.n86 VSS.n50 177.3
R425 VSS.n96 VSS.n50 177.3
R426 VSS.n96 VSS.n45 177.3
R427 VSS.n102 VSS.n45 177.3
R428 VSS.n102 VSS.n46 177.3
R429 VSS.n46 VSS.n5 177.3
R430 VSS.n6 VSS.n5 177.3
R431 VSS.n7 VSS.n6 177.3
R432 VSS.n31 VSS.n7 177.3
R433 VSS.n31 VSS.n10 177.3
R434 VSS.n11 VSS.n10 177.3
R435 VSS.n12 VSS.n11 177.3
R436 VSS.n123 VSS.n12 177.3
R437 VSS.n123 VSS.n15 177.3
R438 VSS.n16 VSS.n15 177.3
R439 VSS.n71 VSS.n69 177.3
R440 VSS.n78 VSS.n56 177.3
R441 VSS.n88 VSS.n56 177.3
R442 VSS.n88 VSS.n52 177.3
R443 VSS.n94 VSS.n52 177.3
R444 VSS.n94 VSS.n43 177.3
R445 VSS.n104 VSS.n43 177.3
R446 VSS.n104 VSS.n39 177.3
R447 VSS.n110 VSS.n39 177.3
R448 VSS.n110 VSS.n37 177.3
R449 VSS.n114 VSS.n37 177.3
R450 VSS.n114 VSS.n33 177.3
R451 VSS.n120 VSS.n33 177.3
R452 VSS.n120 VSS.n30 177.3
R453 VSS.n126 VSS.n30 177.3
R454 VSS.n126 VSS.n26 177.3
R455 VSS.n132 VSS.n26 177.3
R456 VSS.n133 VSS.n132 177.3
R457 VSS.n138 VSS.n24 76.985
R458 VSS.n136 VSS.n18 76.985
R459 VSS.n68 VSS.n64 76.985
R460 VSS.n70 VSS.n61 76.985
R461 VSS.n137 VSS.n136 76.985
R462 VSS.n24 VSS.n23 76.985
R463 VSS.n69 VSS.n68 76.985
R464 VSS.n71 VSS.n70 76.985
R465 VSS.n79 VSS.n62 49.8974
R466 VSS.n135 VSS.n134 49.8974
R467 VSS.n79 VSS.n63 40.8252
R468 VSS.n87 VSS.n51 40.8252
R469 VSS.n95 VSS.n51 40.8252
R470 VSS.n95 VSS.n44 40.8252
R471 VSS.n103 VSS.n44 40.8252
R472 VSS.n111 VSS.n38 40.8252
R473 VSS.n112 VSS.n111 40.8252
R474 VSS.n113 VSS.n112 40.8252
R475 VSS.n121 VSS.n32 40.8252
R476 VSS.n122 VSS.n121 40.8252
R477 VSS.n125 VSS.n122 40.8252
R478 VSS.n125 VSS.n124 40.8252
R479 VSS.n134 VSS.n25 40.8252
R480 VSS.t8 VSS.n38 32.3201
R481 VSS.n113 VSS.t2 32.3201
R482 VSS.n77 VSS.n65 27.2005
R483 VSS.n140 VSS.n22 27.2005
R484 VSS.n147 VSS.n146 27.2005
R485 VSS.n81 VSS.n60 27.2005
R486 VSS.n63 VSS.t4 25.516
R487 VSS.t6 VSS.n25 25.516
R488 VSS.n87 VSS.t4 15.3098
R489 VSS.n124 VSS.t6 15.3098
R490 VSS.n77 VSS.n55 11.5205
R491 VSS.n89 VSS.n55 11.5205
R492 VSS.n89 VSS.n53 11.5205
R493 VSS.n93 VSS.n53 11.5205
R494 VSS.n93 VSS.n42 11.5205
R495 VSS.n105 VSS.n42 11.5205
R496 VSS.n105 VSS.n40 11.5205
R497 VSS.n109 VSS.n40 11.5205
R498 VSS.n109 VSS.n36 11.5205
R499 VSS.n115 VSS.n36 11.5205
R500 VSS.n115 VSS.n34 11.5205
R501 VSS.n119 VSS.n34 11.5205
R502 VSS.n119 VSS.n29 11.5205
R503 VSS.n127 VSS.n29 11.5205
R504 VSS.n127 VSS.n27 11.5205
R505 VSS.n131 VSS.n27 11.5205
R506 VSS.n131 VSS.n22 11.5205
R507 VSS.n140 VSS.n139 11.5205
R508 VSS.n139 VSS.n17 11.5205
R509 VSS.n146 VSS.n17 11.5205
R510 VSS.n81 VSS.n58 11.5205
R511 VSS.n85 VSS.n58 11.5205
R512 VSS.n85 VSS.n49 11.5205
R513 VSS.n97 VSS.n49 11.5205
R514 VSS.n97 VSS.n47 11.5205
R515 VSS.n101 VSS.n47 11.5205
R516 VSS.n101 VSS.n4 11.5205
R517 VSS.n161 VSS.n4 11.5205
R518 VSS.n161 VSS.n160 11.5205
R519 VSS.n160 VSS.n159 11.5205
R520 VSS.n159 VSS.n8 11.5205
R521 VSS.n154 VSS.n8 11.5205
R522 VSS.n154 VSS.n153 11.5205
R523 VSS.n153 VSS.n152 11.5205
R524 VSS.n152 VSS.n13 11.5205
R525 VSS.n148 VSS.n13 11.5205
R526 VSS.n148 VSS.n147 11.5205
R527 VSS.n73 VSS.n65 11.5205
R528 VSS.n73 VSS.n72 11.5205
R529 VSS.n72 VSS.n60 11.5205
R530 VSS.n146 VSS.n145 9.3005
R531 VSS.n19 VSS.n17 9.3005
R532 VSS.n139 VSS.n20 9.3005
R533 VSS.n141 VSS.n140 9.3005
R534 VSS.n75 VSS.n65 9.3005
R535 VSS.n74 VSS.n73 9.3005
R536 VSS.n72 VSS.n67 9.3005
R537 VSS.n66 VSS.n60 9.3005
R538 VSS.n77 VSS.n76 9.3005
R539 VSS.n55 VSS.n54 9.3005
R540 VSS.n90 VSS.n89 9.3005
R541 VSS.n91 VSS.n53 9.3005
R542 VSS.n93 VSS.n92 9.3005
R543 VSS.n42 VSS.n41 9.3005
R544 VSS.n106 VSS.n105 9.3005
R545 VSS.n107 VSS.n40 9.3005
R546 VSS.n109 VSS.n108 9.3005
R547 VSS.n36 VSS.n35 9.3005
R548 VSS.n116 VSS.n115 9.3005
R549 VSS.n117 VSS.n34 9.3005
R550 VSS.n119 VSS.n118 9.3005
R551 VSS.n29 VSS.n28 9.3005
R552 VSS.n128 VSS.n127 9.3005
R553 VSS.n129 VSS.n27 9.3005
R554 VSS.n131 VSS.n130 9.3005
R555 VSS.n22 VSS.n21 9.3005
R556 VSS.n147 VSS.n14 9.3005
R557 VSS.n149 VSS.n148 9.3005
R558 VSS.n150 VSS.n13 9.3005
R559 VSS.n152 VSS.n151 9.3005
R560 VSS.n153 VSS.n9 9.3005
R561 VSS.n155 VSS.n154 9.3005
R562 VSS.n157 VSS.n8 9.3005
R563 VSS.n159 VSS.n158 9.3005
R564 VSS.n160 VSS.n3 9.3005
R565 VSS.n162 VSS.n161 9.3005
R566 VSS.n4 VSS.n2 9.3005
R567 VSS.n101 VSS.n100 9.3005
R568 VSS.n99 VSS.n47 9.3005
R569 VSS.n98 VSS.n97 9.3005
R570 VSS.n49 VSS.n48 9.3005
R571 VSS.n85 VSS.n84 9.3005
R572 VSS.n83 VSS.n58 9.3005
R573 VSS.n82 VSS.n81 9.3005
R574 VSS.n103 VSS.t8 8.50565
R575 VSS.t2 VSS.n32 8.50565
R576 VSS.n164 VSS.n1 3.07383
R577 VSS.n59 VSS.n1 2.81052
R578 VSS.n143 VSS.n142 0.792167
R579 VSS.n144 VSS.n143 0.792167
R580 VSS.n142 VSS.n141 0.328938
R581 VSS.n145 VSS.n144 0.31175
R582 VSS.n76 VSS.n75 0.266125
R583 VSS.n141 VSS.n20 0.1805
R584 VSS.n145 VSS.n19 0.1805
R585 VSS.n66 VSS.n59 0.128625
R586 VSS.n75 VSS.n74 0.113
R587 VSS.n74 VSS.n67 0.113
R588 VSS.n67 VSS.n66 0.113
R589 VSS.n76 VSS.n54 0.113
R590 VSS.n90 VSS.n54 0.113
R591 VSS.n91 VSS.n90 0.113
R592 VSS.n92 VSS.n91 0.113
R593 VSS.n92 VSS.n41 0.113
R594 VSS.n106 VSS.n41 0.113
R595 VSS.n107 VSS.n106 0.113
R596 VSS.n108 VSS.n107 0.113
R597 VSS.n108 VSS.n35 0.113
R598 VSS.n116 VSS.n35 0.113
R599 VSS.n117 VSS.n116 0.113
R600 VSS.n118 VSS.n117 0.113
R601 VSS.n118 VSS.n28 0.113
R602 VSS.n128 VSS.n28 0.113
R603 VSS.n129 VSS.n128 0.113
R604 VSS.n130 VSS.n129 0.113
R605 VSS.n130 VSS.n21 0.113
R606 VSS.n142 VSS.n21 0.0989375
R607 VSS.n143 VSS.n20 0.0905
R608 VSS.n143 VSS.n19 0.0905
R609 VSS.n0 VSS.t1 0.0878262
R610 VSS.n165 VSS.n164 0.0636481
R611 VSS.n165 VSS.n0 0.0631667
R612 VSS.n164 VSS.n163 0.049413
R613 VSS.n165 VSS 0.04938
R614 VSS.n82 VSS.n59 0.0371667
R615 VSS.n83 VSS.n82 0.0305
R616 VSS.n84 VSS.n83 0.0305
R617 VSS.n84 VSS.n48 0.0305
R618 VSS.n98 VSS.n48 0.0305
R619 VSS.n99 VSS.n98 0.0305
R620 VSS.n100 VSS.n99 0.0305
R621 VSS.n100 VSS.n2 0.0305
R622 VSS.n162 VSS.n3 0.0305
R623 VSS.n158 VSS.n3 0.0305
R624 VSS.n158 VSS.n157 0.0305
R625 VSS.n155 VSS.n9 0.0305
R626 VSS.n151 VSS.n9 0.0305
R627 VSS.n151 VSS.n150 0.0305
R628 VSS.n150 VSS.n149 0.0305
R629 VSS.n149 VSS.n14 0.0305
R630 VSS.n144 VSS.n14 0.02675
R631 VSS.n0 VSS.t0 0.0251595
R632 VSS VSS.t5 0.024
R633 VSS.n163 VSS.n2 0.0225833
R634 VSS.n156 VSS.n155 0.018
R635 VSS.n157 VSS.n156 0.013
R636 VSS.n163 VSS.n162 0.00841667
R637 VSS.n1 VSS.n0 0.00738889
R638 VSS VSS.n165 0.00526351
C0 VDD cs 0.40031f
C1 in out 0.0217f
C2 phi1b VDD 0.68947f
C3 in phi2 0.11082f
C4 cs phi1 0.57294f
C5 in phi2b 0.62635f
C6 phi1b phi1 1.34261f
C7 VDD out 0.44121f
C8 phi2 VDD 0.32424f
C9 VDD phi2b 0.67319f
C10 phi1 out 0.01125f
C11 phi2 phi1 0.37977f
C12 phi1b cs 0.3762f
C13 phi2b phi1 0.27913f
C14 in VDD 0.37452f
C15 cs out 0.8416f
C16 phi2 cs 0.59642f
C17 phi1b out 0.01151f
C18 phi2 phi1b 0.43473f
C19 in phi1 0.6739f
C20 cs phi2b 0.63877f
C21 phi1b phi2b 0.12027f
C22 phi2 out 0.41742f
C23 VDD phi1 0.36777f
C24 in cs 0.34228f
C25 phi2b out 0.61092f
C26 phi2 phi2b 1.34467f
C27 in phi1b 0.77798f
C28 out VSS 20.4671f
C29 in VSS 1.30322f
C30 phi2 VSS 1.28944f
C31 phi1 VSS 1.15013f
C32 VDD VSS 6.79536f
C33 cs VSS 2.83227f
C34 phi2b VSS 0.41819f
C35 phi1b VSS 0.47081f
C36 VDD.n0 VSS 0.01685f
C37 VDD.n1 VSS 0.01941f
C38 VDD.n2 VSS 0.00518f
C39 VDD.n3 VSS 0.00518f
C40 VDD.n4 VSS 0.00518f
C41 VDD.n5 VSS 0.00518f
C42 VDD.n6 VSS 0.00518f
C43 VDD.t2 VSS 0.00939f
C44 VDD.n7 VSS 0.01941f
C45 VDD.n8 VSS 0.00518f
C46 VDD.n9 VSS 0.00518f
C47 VDD.n10 VSS 0.00518f
C48 VDD.n11 VSS 0.00518f
C49 VDD.t5 VSS 0.00939f
C50 VDD.n12 VSS 0.0182f
C51 VDD.n13 VSS 0.00518f
C52 VDD.n14 VSS 0.0107f
C53 VDD.n15 VSS 0.01058f
C54 VDD.n16 VSS 0.00518f
C55 VDD.n17 VSS 0.0205f
C56 VDD.n18 VSS 0.00518f
C57 VDD.n19 VSS 0.00323f
C58 VDD.n20 VSS 0.00485f
C59 VDD.n21 VSS 0.00518f
C60 VDD.n22 VSS 0.01058f
C61 VDD.n23 VSS 0.00518f
C62 VDD.n24 VSS 0.00518f
C63 VDD.n25 VSS 0.05434f
C64 VDD.n26 VSS 0.00518f
C65 VDD.n27 VSS 0.00518f
C66 VDD.n28 VSS 0.00518f
C67 VDD.n29 VSS 0.00518f
C68 VDD.n30 VSS 0.00518f
C69 VDD.t1 VSS 0.02717f
C70 VDD.n31 VSS 0.00518f
C71 VDD.n32 VSS 0.00518f
C72 VDD.n33 VSS 0.00518f
C73 VDD.n34 VSS 0.00518f
C74 VDD.n35 VSS 0.00518f
C75 VDD.t0 VSS 0.02717f
C76 VDD.n36 VSS 0.00518f
C77 VDD.n37 VSS 0.00518f
C78 VDD.n38 VSS 0.00518f
C79 VDD.n39 VSS 0.05434f
C80 VDD.n40 VSS 0.00518f
C81 VDD.n41 VSS 0.00518f
C82 VDD.n42 VSS 0.00518f
C83 VDD.n43 VSS 0.00518f
C84 VDD.n44 VSS 0.00518f
C85 VDD.n45 VSS 0.00518f
C86 VDD.n46 VSS 0.05434f
C87 VDD.n47 VSS 0.00518f
C88 VDD.n48 VSS 0.00518f
C89 VDD.n49 VSS 0.00518f
C90 VDD.n50 VSS 0.01941f
C91 VDD.n51 VSS 0.00518f
C92 VDD.n52 VSS 0.00518f
C93 VDD.t3 VSS 0.02717f
C94 VDD.n53 VSS 0.00518f
C95 VDD.n54 VSS 0.00518f
C96 VDD.n55 VSS 0.01058f
C97 VDD.n56 VSS 0.01058f
C98 VDD.n57 VSS 0.01058f
C99 VDD.n58 VSS 0.13888f
C100 VDD.n59 VSS 0.04416f
C101 VDD.n60 VSS 0.01058f
C102 VDD.n61 VSS 0.01058f
C103 VDD.n62 VSS 0.00518f
C104 VDD.n64 VSS 0.00518f
C105 VDD.n65 VSS 0.00518f
C106 VDD.n67 VSS 0.00518f
C107 VDD.n68 VSS 0.00518f
C108 VDD.n69 VSS 0.00518f
C109 VDD.n70 VSS 0.00518f
C110 VDD.n71 VSS 0.00518f
C111 VDD.n72 VSS 0.00518f
C112 VDD.n73 VSS 0.01434f
C113 VDD.n74 VSS 0.05553f
C114 VDD.n75 VSS 0.0107f
C115 VDD.n76 VSS 0.0107f
C116 VDD.n77 VSS 0.06038f
C117 VDD.n78 VSS 0.0107f
C118 VDD.n79 VSS 0.0107f
C119 VDD.n80 VSS 0.0107f
C120 VDD.n81 VSS 0.00518f
C121 VDD.n82 VSS 0.00518f
C122 VDD.n83 VSS 0.00518f
C123 VDD.n84 VSS 0.00518f
C124 VDD.n85 VSS 0.03736f
C125 VDD.n86 VSS 0.00518f
C126 VDD.n87 VSS 0.00518f
C127 VDD.n88 VSS 0.01941f
C128 VDD.n89 VSS 0.01941f
C129 VDD.n90 VSS 0.01941f
C130 VDD.n91 VSS 0.01941f
C131 VDD.n92 VSS 0.01941f
C132 VDD.n93 VSS 0.00518f
C133 VDD.n94 VSS 0.00518f
C134 VDD.n95 VSS 0.05434f
C135 VDD.n96 VSS 0.00518f
C136 VDD.n97 VSS 0.00518f
C137 VDD.n98 VSS 0.00518f
C138 VDD.n99 VSS 0.00518f
C139 VDD.n100 VSS 0.00518f
C140 VDD.n101 VSS 0.00518f
C141 VDD.n102 VSS 0.00518f
C142 VDD.n103 VSS 0.00518f
C143 VDD.n104 VSS 0.03283f
C144 VDD.n105 VSS 0.00518f
C145 VDD.n106 VSS 0.00518f
C146 VDD.n107 VSS 0.04868f
C147 VDD.n108 VSS 0.05434f
C148 VDD.n109 VSS 0.04868f
C149 VDD.n110 VSS 0.05434f
C150 VDD.n111 VSS 0.00518f
C151 VDD.n112 VSS 0.00518f
C152 VDD.n113 VSS 0.00518f
C153 VDD.n114 VSS 0.00518f
C154 VDD.n115 VSS 0.00518f
C155 VDD.n116 VSS 0.00518f
C156 VDD.n117 VSS 0.00518f
C157 VDD.n118 VSS 0.00518f
C158 VDD.n119 VSS 0.03283f
C159 VDD.n120 VSS 0.05434f
C160 VDD.n121 VSS 0.05434f
C161 VDD.n122 VSS 0.00518f
C162 VDD.n123 VSS 0.00518f
C163 VDD.n124 VSS 0.00518f
C164 VDD.n125 VSS 0.00518f
C165 VDD.n126 VSS 0.00518f
C166 VDD.n127 VSS 0.00518f
C167 VDD.n128 VSS 0.00518f
C168 VDD.n129 VSS 0.00518f
C169 VDD.n130 VSS 0.00518f
C170 VDD.n131 VSS 0.03736f
C171 VDD.t4 VSS 0.02717f
C172 VDD.n132 VSS 0.04416f
C173 VDD.n134 VSS 0.00518f
C174 VDD.n135 VSS 0.00518f
C175 VDD.n136 VSS 0.00518f
C176 VDD.n138 VSS 0.13888f
C177 VDD.n139 VSS 0.06038f
C178 VDD.n140 VSS 0.0107f
C179 VDD.n141 VSS 0.0107f
C180 VDD.n142 VSS 0.01058f
C181 VDD.n143 VSS 0.00502f
C182 VDD.n144 VSS 0.01108f
C183 VDD.n145 VSS 0.0097f
C184 VDD.n146 VSS 0.00323f
C185 VDD.n147 VSS 0.0048f
C186 VDD.n148 VSS 0.01058f
C187 VDD.n149 VSS 0.0107f
C188 VDD.n150 VSS 0.00518f
C189 VDD.n151 VSS 0.03759f
C190 VDD.n152 VSS 0.01941f
C191 VDD.n153 VSS 0.01941f
C192 VDD.n154 VSS 0.00518f
C193 VDD.n155 VSS 0.00518f
C194 VDD.n156 VSS 0.00518f
C195 VDD.n157 VSS 0.01537f
C196 VDD.n158 VSS 0.02788f
C197 VDD.n159 VSS 0.01375f
C198 VDD.n160 VSS 0.01941f
C199 VDD.n161 VSS 0.00518f
C200 VDD.n162 VSS 0.00518f
C201 VDD.n163 VSS 0.00518f
C202 VDD.n164 VSS 0.01227f
C203 VDD.n165 VSS 0.47917f
C204 phi1.t0 VSS 0.06925f
C205 phi1.t2 VSS 0.0858f
C206 phi1.t1 VSS 0.05959f
C207 phi1.n0 VSS 1.38719f
C208 phi1.n1 VSS 1.90263f
C209 phi2.t0 VSS 0.06187f
C210 phi2.t2 VSS 0.08244f
C211 phi2.t1 VSS 0.05531f
C212 phi2.n0 VSS 1.31444f
C213 phi2.n1 VSS 1.77311f
C214 in.t1 VSS 0.13727f
C215 in.t0 VSS 0.07705f
C216 in.n0 VSS 1.68008f
C217 out.t2 VSS 1.15215f
C218 out.t3 VSS 1.1115f
C219 out.n0 VSS 0.03748f
C220 out.n1 VSS 0.01968f
C221 out.t1 VSS 0
C222 out.t0 VSS 0
C223 out.n2 VSS 0.00424f
C224 out.n3 VSS 0
.ends
