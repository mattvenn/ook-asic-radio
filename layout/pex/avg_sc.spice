* avg_sc: magic R+C extraction of layout/avg_sc.gds (layout/pex.sh)
.subckt avg_sc in phi1 phi2 out VDD VSS
X0 cs phi1b in.t1 VDD.t0 sky130_fd_pr__pfet_01v8 ad=0.3 pd=2.6 as=0.3 ps=2.6 w=1 l=0.15
X1 cs VSS.t5 sky130_fd_pr__cap_mim_m3_1 l=7 w=7
X2 out.t3 VSS.t0 sky130_fd_pr__cap_mim_m3_1 l=30 w=30
X3 out.t1 phi2b cs VDD.t3 sky130_fd_pr__pfet_01v8 ad=0.3 pd=2.6 as=0.3 ps=2.6 w=1 l=0.15
X4 out.t2 VSS.t1 sky130_fd_pr__cap_mim_m3_1 l=30 w=30
X5 phi1b phi1.t1 VSS.t7 VSS.t6 sky130_fd_pr__nfet_01v8 ad=0.15 pd=1.6 as=0.15 ps=1.6 w=0.5 l=0.15
X6 phi1b phi1.t2 VDD.t5 VDD.t4 sky130_fd_pr__pfet_01v8 ad=0.3 pd=2.6 as=0.3 ps=2.6 w=1 l=0.15
X7 VDD.t2 phi2.t2 phi2b VDD.t1 sky130_fd_pr__pfet_01v8 ad=0.3 pd=2.6 as=0.3 ps=2.6 w=1 l=0.15
X8 out.t0 phi2.t0 cs VSS.t4 sky130_fd_pr__nfet_01v8 ad=0.15 pd=1.6 as=0.15 ps=1.6 w=0.5 l=0.15
X9 VSS.t3 phi2.t1 phi2b VSS.t2 sky130_fd_pr__nfet_01v8 ad=0.15 pd=1.6 as=0.15 ps=1.6 w=0.5 l=0.15
X10 cs phi1.t0 in.t0 VSS.t8 sky130_fd_pr__nfet_01v8 ad=0.15 pd=1.6 as=0.15 ps=1.6 w=0.5 l=0.15
R0 out.n0 out.t1 360.764
R1 out.n0 out.t0 234.784
R2 out.n3 out.n2 3.63439
R3 out.n1 out.n0 1.72411
R4 out out.t3 0.807181
R5 out.n3 out.n1 0.473477
R6 out.n2 out 0.301804
R7 out out.n3 0.0290969
R8 out.n2 out.t2 0.0207703
R9 out.n1 out 0.0193975
R10 in.n0 in.t1 360.483
R11 in.n0 in.t0 235.078
R12 in in.n0 1.67065
R13 phi2.n0 phi2.t2 421.296
R14 phi2 phi2.t0 342.281
R15 phi2.n0 phi2.t1 338.13
R16 phi2 phi2.n1 3.1064
R17 phi2.n1 phi2.n0 1.67065
R18 phi2.n1 phi2 0.16453
R19 phi1.n0 phi1.t2 420.808
R20 phi1 phi1.t0 344.438
R21 phi1.n0 phi1.t1 338.642
R22 phi1 phi1.n1 2.91442
R23 phi1.n1 phi1.n0 1.67065
R24 phi1.n1 phi1 0.16453
R25 VDD.n139 VDD.t5 356.659
R26 VDD.n15 VDD.t2 356.659
R27 VDD.n26 VDD.n25 276
R28 VDD.n128 VDD.n32 276
R29 VDD.n62 VDD.n56 276
R30 VDD.n70 VDD.n4 276
R31 VDD.n164 VDD.n4 185
R32 VDD.n73 VDD.n4 185
R33 VDD.n163 VDD.n5 185
R34 VDD.n74 VDD.n5 185
R35 VDD.n162 VDD.n6 185
R36 VDD.n51 VDD.n6 185
R37 VDD.n82 VDD.n7 185
R38 VDD.n83 VDD.n82 185
R39 VDD.n158 VDD.n9 185
R40 VDD.n84 VDD.n9 185
R41 VDD.n157 VDD.n10 185
R42 VDD.n86 VDD.n10 185
R43 VDD.n156 VDD.n11 185
R44 VDD.n85 VDD.n11 185
R45 VDD.n153 VDD.n12 185
R46 VDD.n94 VDD.n12 185
R47 VDD.n152 VDD.n13 185
R48 VDD.n95 VDD.n13 185
R49 VDD.n97 VDD.n14 185
R50 VDD.n98 VDD.n97 185
R51 VDD.n148 VDD.n16 185
R52 VDD.n96 VDD.n16 185
R53 VDD.n147 VDD.n17 185
R54 VDD.n106 VDD.n17 185
R55 VDD.n107 VDD.n18 185
R56 VDD.n108 VDD.n107 185
R57 VDD.n143 VDD.n20 185
R58 VDD.n109 VDD.n20 185
R59 VDD.n142 VDD.n21 185
R60 VDD.n35 VDD.n21 185
R61 VDD.n141 VDD.n22 185
R62 VDD.n118 VDD.n22 185
R63 VDD.n119 VDD.n23 185
R64 VDD.n120 VDD.n119 185
R65 VDD.n137 VDD.n25 185
R66 VDD.n127 VDD.n25 185
R67 VDD.n70 VDD.n3 185
R68 VDD.n69 VDD.n68 185
R69 VDD.n59 VDD.n58 185
R70 VDD.n72 VDD.n58 185
R71 VDD.n64 VDD.n61 185
R72 VDD.n63 VDD.n62 185
R73 VDD.n129 VDD.n128 185
R74 VDD.n128 VDD.n127 185
R75 VDD.n34 VDD.n33 185
R76 VDD.n120 VDD.n34 185
R77 VDD.n117 VDD.n116 185
R78 VDD.n118 VDD.n117 185
R79 VDD.n37 VDD.n36 185
R80 VDD.n36 VDD.n35 185
R81 VDD.n111 VDD.n110 185
R82 VDD.n110 VDD.n109 185
R83 VDD.n40 VDD.n39 185
R84 VDD.n108 VDD.n40 185
R85 VDD.n105 VDD.n104 185
R86 VDD.n106 VDD.n105 185
R87 VDD.n42 VDD.n41 185
R88 VDD.n96 VDD.n41 185
R89 VDD.n100 VDD.n99 185
R90 VDD.n99 VDD.n98 185
R91 VDD.n45 VDD.n44 185
R92 VDD.n95 VDD.n45 185
R93 VDD.n93 VDD.n92 185
R94 VDD.n94 VDD.n93 185
R95 VDD.n47 VDD.n46 185
R96 VDD.n85 VDD.n46 185
R97 VDD.n88 VDD.n87 185
R98 VDD.n87 VDD.n86 185
R99 VDD.n50 VDD.n49 185
R100 VDD.n84 VDD.n50 185
R101 VDD.n81 VDD.n80 185
R102 VDD.n83 VDD.n81 185
R103 VDD.n53 VDD.n52 185
R104 VDD.n52 VDD.n51 185
R105 VDD.n76 VDD.n75 185
R106 VDD.n75 VDD.n74 185
R107 VDD.n56 VDD.n55 185
R108 VDD.n73 VDD.n56 185
R109 VDD.n130 VDD.n32 185
R110 VDD.n123 VDD.n31 185
R111 VDD.n124 VDD.n28 185
R112 VDD.n122 VDD.n27 185
R113 VDD.n136 VDD.n26 185
R114 VDD.n126 VDD.n26 185
R115 VDD.n122 VDD.n26 108.001
R116 VDD.n124 VDD.n123 108.001
R117 VDD.n75 VDD.n56 108.001
R118 VDD.n75 VDD.n52 108.001
R119 VDD.n81 VDD.n52 108.001
R120 VDD.n81 VDD.n50 108.001
R121 VDD.n87 VDD.n50 108.001
R122 VDD.n87 VDD.n46 108.001
R123 VDD.n93 VDD.n46 108.001
R124 VDD.n93 VDD.n45 108.001
R125 VDD.n99 VDD.n45 108.001
R126 VDD.n99 VDD.n41 108.001
R127 VDD.n105 VDD.n41 108.001
R128 VDD.n105 VDD.n40 108.001
R129 VDD.n110 VDD.n40 108.001
R130 VDD.n110 VDD.n36 108.001
R131 VDD.n117 VDD.n36 108.001
R132 VDD.n117 VDD.n34 108.001
R133 VDD.n128 VDD.n34 108.001
R134 VDD.n69 VDD.n58 108.001
R135 VDD.n61 VDD.n58 108.001
R136 VDD.n5 VDD.n4 108.001
R137 VDD.n6 VDD.n5 108.001
R138 VDD.n82 VDD.n6 108.001
R139 VDD.n82 VDD.n9 108.001
R140 VDD.n10 VDD.n9 108.001
R141 VDD.n11 VDD.n10 108.001
R142 VDD.n12 VDD.n11 108.001
R143 VDD.n13 VDD.n12 108.001
R144 VDD.n97 VDD.n13 108.001
R145 VDD.n97 VDD.n16 108.001
R146 VDD.n17 VDD.n16 108.001
R147 VDD.n107 VDD.n17 108.001
R148 VDD.n107 VDD.n20 108.001
R149 VDD.n21 VDD.n20 108.001
R150 VDD.n22 VDD.n21 108.001
R151 VDD.n119 VDD.n22 108.001
R152 VDD.n119 VDD.n25 108.001
R153 VDD.n73 VDD.n72 99.5243
R154 VDD.n127 VDD.n126 99.5243
R155 VDD.n74 VDD.n73 81.4291
R156 VDD.n83 VDD.n51 81.4291
R157 VDD.n84 VDD.n83 81.4291
R158 VDD.n86 VDD.n84 81.4291
R159 VDD.n86 VDD.n85 81.4291
R160 VDD.n95 VDD.n94 81.4291
R161 VDD.n98 VDD.n95 81.4291
R162 VDD.n98 VDD.n96 81.4291
R163 VDD.n108 VDD.n106 81.4291
R164 VDD.n109 VDD.n108 81.4291
R165 VDD.n109 VDD.n35 81.4291
R166 VDD.n118 VDD.n35 81.4291
R167 VDD.n127 VDD.n120 81.4291
R168 VDD.n72 VDD.n71 71.6014
R169 VDD.n72 VDD.n57 71.6014
R170 VDD.n126 VDD.n121 71.6014
R171 VDD.n126 VDD.n125 71.6014
R172 VDD.n94 VDD.t0 64.4648
R173 VDD.n96 VDD.t1 64.4648
R174 VDD.n74 VDD.t3 50.8934
R175 VDD.n120 VDD.t4 50.8934
R176 VDD.n125 VDD.n124 41.8002
R177 VDD.n121 VDD.n32 41.8002
R178 VDD.n71 VDD.n70 41.8002
R179 VDD.n61 VDD.n57 41.8002
R180 VDD.n71 VDD.n69 41.8002
R181 VDD.n62 VDD.n57 41.8002
R182 VDD.n123 VDD.n121 41.8002
R183 VDD.n125 VDD.n122 41.8002
R184 VDD.t3 VDD.n51 30.5362
R185 VDD.t4 VDD.n118 30.5362
R186 VDD.n164 VDD.n3 29.4405
R187 VDD.n137 VDD.n136 29.4405
R188 VDD.n63 VDD.n55 29.4405
R189 VDD.n130 VDD.n129 29.4405
R190 VDD.n85 VDD.t0 16.9648
R191 VDD.n106 VDD.t1 16.9648
R192 VDD.n164 VDD.n163 11.5205
R193 VDD.n163 VDD.n162 11.5205
R194 VDD.n162 VDD.n7 11.5205
R195 VDD.n158 VDD.n7 11.5205
R196 VDD.n158 VDD.n157 11.5205
R197 VDD.n157 VDD.n156 11.5205
R198 VDD.n156 VDD.n153 11.5205
R199 VDD.n153 VDD.n152 11.5205
R200 VDD.n152 VDD.n14 11.5205
R201 VDD.n148 VDD.n14 11.5205
R202 VDD.n148 VDD.n147 11.5205
R203 VDD.n147 VDD.n18 11.5205
R204 VDD.n143 VDD.n18 11.5205
R205 VDD.n143 VDD.n142 11.5205
R206 VDD.n142 VDD.n141 11.5205
R207 VDD.n141 VDD.n23 11.5205
R208 VDD.n137 VDD.n23 11.5205
R209 VDD.n68 VDD.n3 11.5205
R210 VDD.n68 VDD.n59 11.5205
R211 VDD.n64 VDD.n59 11.5205
R212 VDD.n64 VDD.n63 11.5205
R213 VDD.n76 VDD.n55 11.5205
R214 VDD.n76 VDD.n53 11.5205
R215 VDD.n80 VDD.n53 11.5205
R216 VDD.n80 VDD.n49 11.5205
R217 VDD.n88 VDD.n49 11.5205
R218 VDD.n88 VDD.n47 11.5205
R219 VDD.n92 VDD.n47 11.5205
R220 VDD.n92 VDD.n44 11.5205
R221 VDD.n100 VDD.n44 11.5205
R222 VDD.n100 VDD.n42 11.5205
R223 VDD.n104 VDD.n42 11.5205
R224 VDD.n104 VDD.n39 11.5205
R225 VDD.n111 VDD.n39 11.5205
R226 VDD.n111 VDD.n37 11.5205
R227 VDD.n116 VDD.n37 11.5205
R228 VDD.n116 VDD.n33 11.5205
R229 VDD.n129 VDD.n33 11.5205
R230 VDD.n136 VDD.n27 11.5205
R231 VDD.n28 VDD.n27 11.5205
R232 VDD.n31 VDD.n28 11.5205
R233 VDD.n130 VDD.n31 11.5205
R234 VDD.n131 VDD.n130 9.3005
R235 VDD.n31 VDD.n29 9.3005
R236 VDD.n133 VDD.n28 9.3005
R237 VDD.n134 VDD.n27 9.3005
R238 VDD.n136 VDD.n135 9.3005
R239 VDD.n129 VDD.n30 9.3005
R240 VDD.n114 VDD.n33 9.3005
R241 VDD.n116 VDD.n115 9.3005
R242 VDD.n113 VDD.n37 9.3005
R243 VDD.n112 VDD.n111 9.3005
R244 VDD.n39 VDD.n38 9.3005
R245 VDD.n104 VDD.n103 9.3005
R246 VDD.n102 VDD.n42 9.3005
R247 VDD.n101 VDD.n100 9.3005
R248 VDD.n44 VDD.n43 9.3005
R249 VDD.n92 VDD.n91 9.3005
R250 VDD.n90 VDD.n47 9.3005
R251 VDD.n89 VDD.n88 9.3005
R252 VDD.n49 VDD.n48 9.3005
R253 VDD.n80 VDD.n79 9.3005
R254 VDD.n78 VDD.n53 9.3005
R255 VDD.n77 VDD.n76 9.3005
R256 VDD.n55 VDD.n54 9.3005
R257 VDD.n3 VDD.n1 9.3005
R258 VDD.n68 VDD.n67 9.3005
R259 VDD.n66 VDD.n59 9.3005
R260 VDD.n65 VDD.n64 9.3005
R261 VDD.n63 VDD.n60 9.3005
R262 VDD.n165 VDD.n164 9.3005
R263 VDD.n163 VDD.n2 9.3005
R264 VDD.n162 VDD.n161 9.3005
R265 VDD.n160 VDD.n7 9.3005
R266 VDD.n159 VDD.n158 9.3005
R267 VDD.n157 VDD.n8 9.3005
R268 VDD.n156 VDD.n155 9.3005
R269 VDD.n154 VDD.n153 9.3005
R270 VDD.n152 VDD.n151 9.3005
R271 VDD.n150 VDD.n14 9.3005
R272 VDD.n149 VDD.n148 9.3005
R273 VDD.n147 VDD.n146 9.3005
R274 VDD.n145 VDD.n18 9.3005
R275 VDD.n144 VDD.n143 9.3005
R276 VDD.n142 VDD.n19 9.3005
R277 VDD.n141 VDD.n140 9.3005
R278 VDD.n139 VDD.n23 9.3005
R279 VDD.n138 VDD.n137 9.3005
R280 VDD.n133 VDD.n24 1.0005
R281 VDD.n133 VDD.n132 1.0005
R282 VDD.n167 VDD.n166 0.503799
R283 VDD.n132 VDD.n131 0.363938
R284 VDD.n135 VDD.n24 0.34675
R285 VDD.n60 VDD.n54 0.288
R286 VDD.n135 VDD.n134 0.1805
R287 VDD.n134 VDD.n133 0.1805
R288 VDD.n133 VDD.n29 0.1805
R289 VDD.n131 VDD.n29 0.1805
R290 VDD.n166 VDD.n1 0.1505
R291 VDD VDD.n167 0.138685
R292 VDD.n77 VDD.n54 0.113
R293 VDD.n78 VDD.n77 0.113
R294 VDD.n79 VDD.n78 0.113
R295 VDD.n79 VDD.n48 0.113
R296 VDD.n89 VDD.n48 0.113
R297 VDD.n90 VDD.n89 0.113
R298 VDD.n91 VDD.n90 0.113
R299 VDD.n91 VDD.n43 0.113
R300 VDD.n101 VDD.n43 0.113
R301 VDD.n102 VDD.n101 0.113
R302 VDD.n103 VDD.n102 0.113
R303 VDD.n103 VDD.n38 0.113
R304 VDD.n112 VDD.n38 0.113
R305 VDD.n113 VDD.n112 0.113
R306 VDD.n115 VDD.n113 0.113
R307 VDD.n115 VDD.n114 0.113
R308 VDD.n114 VDD.n30 0.113
R309 VDD.n67 VDD.n1 0.113
R310 VDD.n67 VDD.n66 0.113
R311 VDD.n66 VDD.n65 0.113
R312 VDD.n65 VDD.n60 0.113
R313 VDD.n132 VDD.n30 0.0989375
R314 VDD.n167 VDD.n0 0.0875482
R315 VDD.n166 VDD.n165 0.0371667
R316 VDD.n165 VDD.n2 0.0305
R317 VDD.n161 VDD.n2 0.0305
R318 VDD.n161 VDD.n160 0.0305
R319 VDD.n160 VDD.n159 0.0305
R320 VDD.n159 VDD.n8 0.0305
R321 VDD.n155 VDD.n8 0.0305
R322 VDD.n155 VDD.n154 0.0305
R323 VDD.n151 VDD.n150 0.0305
R324 VDD.n150 VDD.n149 0.0305
R325 VDD.n146 VDD.n145 0.0305
R326 VDD.n145 VDD.n144 0.0305
R327 VDD.n144 VDD.n19 0.0305
R328 VDD.n140 VDD.n19 0.0305
R329 VDD.n140 VDD.n139 0.0305
R330 VDD.n139 VDD.n138 0.0305
R331 VDD.n138 VDD.n24 0.02675
R332 VDD.n146 VDD.n15 0.0255
R333 VDD.n154 VDD.n0 0.0225833
R334 VDD.n151 VDD.n0 0.00841667
R335 VDD.n149 VDD.n15 0.0055
R336 VSS.n120 VSS.n119 67491
R337 VSS.n39 VSS.n38 585
R338 VSS.n38 VSS.n36 585
R339 VSS.n108 VSS.n42 585
R340 VSS.n61 VSS.n42 585
R341 VSS.n107 VSS.n43 585
R342 VSS.n62 VSS.n43 585
R343 VSS.n106 VSS.n44 585
R344 VSS.n64 VSS.n44 585
R345 VSS.n65 VSS.n45 585
R346 VSS.n66 VSS.n65 585
R347 VSS.n102 VSS.n47 585
R348 VSS.n67 VSS.n47 585
R349 VSS.n101 VSS.n48 585
R350 VSS.n68 VSS.n48 585
R351 VSS.n100 VSS.n49 585
R352 VSS.n69 VSS.n49 585
R353 VSS.n70 VSS.n50 585
R354 VSS.n71 VSS.n70 585
R355 VSS.n96 VSS.n52 585
R356 VSS.n73 VSS.n52 585
R357 VSS.n95 VSS.n53 585
R358 VSS.n74 VSS.n53 585
R359 VSS.n94 VSS.n54 585
R360 VSS.n75 VSS.n54 585
R361 VSS.n77 VSS.n55 585
R362 VSS.n78 VSS.n77 585
R363 VSS.n90 VSS.n57 585
R364 VSS.n79 VSS.n57 585
R365 VSS.n89 VSS.n58 585
R366 VSS.n80 VSS.n58 585
R367 VSS.n88 VSS.n59 585
R368 VSS.n81 VSS.n59 585
R369 VSS.n85 VSS.n84 585
R370 VSS.n84 VSS.n83 585
R371 VSS.n60 VSS.n30 585
R372 VSS.n60 VSS.n33 585
R373 VSS.n131 VSS.n27 585
R374 VSS.n122 VSS.n26 585
R375 VSS.n124 VSS.n123 585
R376 VSS.n125 VSS.n31 585
R377 VSS.n132 VSS.n25 585
R378 VSS.n33 VSS.n25 585
R379 VSS.n82 VSS.n23 585
R380 VSS.n83 VSS.n82 585
R381 VSS.n136 VSS.n22 585
R382 VSS.n81 VSS.n22 585
R383 VSS.n137 VSS.n21 585
R384 VSS.n80 VSS.n21 585
R385 VSS.n138 VSS.n20 585
R386 VSS.n79 VSS.n20 585
R387 VSS.n76 VSS.n18 585
R388 VSS.n78 VSS.n76 585
R389 VSS.n142 VSS.n17 585
R390 VSS.n75 VSS.n17 585
R391 VSS.n143 VSS.n16 585
R392 VSS.n74 VSS.n16 585
R393 VSS.n72 VSS.n14 585
R394 VSS.n73 VSS.n72 585
R395 VSS.n147 VSS.n13 585
R396 VSS.n71 VSS.n13 585
R397 VSS.n148 VSS.n12 585
R398 VSS.n69 VSS.n12 585
R399 VSS.n151 VSS.n11 585
R400 VSS.n68 VSS.n11 585
R401 VSS.n152 VSS.n10 585
R402 VSS.n67 VSS.n10 585
R403 VSS.n153 VSS.n9 585
R404 VSS.n66 VSS.n9 585
R405 VSS.n63 VSS.n7 585
R406 VSS.n64 VSS.n63 585
R407 VSS.n157 VSS.n6 585
R408 VSS.n62 VSS.n6 585
R409 VSS.n158 VSS.n5 585
R410 VSS.n61 VSS.n5 585
R411 VSS.n159 VSS.n4 585
R412 VSS.n36 VSS.n4 585
R413 VSS.n117 VSS.n116 585
R414 VSS.n40 VSS.n37 585
R415 VSS.n112 VSS.n111 585
R416 VSS.n34 VSS.n3 585
R417 VSS.n60 VSS.n31 418.625
R418 VSS.n27 VSS.n25 418.625
R419 VSS.n34 VSS.n4 418.625
R420 VSS.n117 VSS.n38 418.625
R421 VSS.n121 VSS.n120 254.01
R422 VSS.n120 VSS.n32 254.01
R423 VSS.n119 VSS.n118 254.01
R424 VSS.n119 VSS.n35 254.01
R425 VSS.n134 VSS.t7 230.63
R426 VSS.n15 VSS.t3 230.63
R427 VSS.n123 VSS.n122 177.3
R428 VSS.n5 VSS.n4 177.3
R429 VSS.n6 VSS.n5 177.3
R430 VSS.n63 VSS.n6 177.3
R431 VSS.n63 VSS.n9 177.3
R432 VSS.n10 VSS.n9 177.3
R433 VSS.n11 VSS.n10 177.3
R434 VSS.n12 VSS.n11 177.3
R435 VSS.n13 VSS.n12 177.3
R436 VSS.n72 VSS.n13 177.3
R437 VSS.n72 VSS.n16 177.3
R438 VSS.n17 VSS.n16 177.3
R439 VSS.n76 VSS.n17 177.3
R440 VSS.n76 VSS.n20 177.3
R441 VSS.n21 VSS.n20 177.3
R442 VSS.n22 VSS.n21 177.3
R443 VSS.n82 VSS.n22 177.3
R444 VSS.n82 VSS.n25 177.3
R445 VSS.n111 VSS.n37 177.3
R446 VSS.n42 VSS.n38 177.3
R447 VSS.n43 VSS.n42 177.3
R448 VSS.n44 VSS.n43 177.3
R449 VSS.n65 VSS.n44 177.3
R450 VSS.n65 VSS.n47 177.3
R451 VSS.n48 VSS.n47 177.3
R452 VSS.n49 VSS.n48 177.3
R453 VSS.n70 VSS.n49 177.3
R454 VSS.n70 VSS.n52 177.3
R455 VSS.n53 VSS.n52 177.3
R456 VSS.n54 VSS.n53 177.3
R457 VSS.n77 VSS.n54 177.3
R458 VSS.n77 VSS.n57 177.3
R459 VSS.n58 VSS.n57 177.3
R460 VSS.n59 VSS.n58 177.3
R461 VSS.n84 VSS.n59 177.3
R462 VSS.n84 VSS.n60 177.3
R463 VSS.n123 VSS.n32 76.985
R464 VSS.n121 VSS.n27 76.985
R465 VSS.n118 VSS.n117 76.985
R466 VSS.n35 VSS.n34 76.985
R467 VSS.n122 VSS.n121 76.985
R468 VSS.n32 VSS.n31 76.985
R469 VSS.n118 VSS.n37 76.985
R470 VSS.n111 VSS.n35 76.985
R471 VSS.n119 VSS.n36 75.6255
R472 VSS.n120 VSS.n33 75.6255
R473 VSS.n61 VSS.n36 61.8755
R474 VSS.n64 VSS.n62 61.8755
R475 VSS.n66 VSS.n64 61.8755
R476 VSS.n67 VSS.n66 61.8755
R477 VSS.n68 VSS.n67 61.8755
R478 VSS.n71 VSS.n69 61.8755
R479 VSS.n73 VSS.n71 61.8755
R480 VSS.n74 VSS.n73 61.8755
R481 VSS.n78 VSS.n75 61.8755
R482 VSS.n79 VSS.n78 61.8755
R483 VSS.n80 VSS.n79 61.8755
R484 VSS.n81 VSS.n80 61.8755
R485 VSS.n83 VSS.n33 61.8755
R486 VSS.n69 VSS.t8 48.9849
R487 VSS.t2 VSS.n74 48.9849
R488 VSS.t4 VSS.n61 38.6724
R489 VSS.n83 VSS.t6 38.6724
R490 VSS.n116 VSS.n39 27.2005
R491 VSS.n125 VSS.n30 27.2005
R492 VSS.n132 VSS.n131 27.2005
R493 VSS.n159 VSS.n3 27.2005
R494 VSS.n62 VSS.t4 23.2036
R495 VSS.t6 VSS.n81 23.2036
R496 VSS.t8 VSS.n68 12.8911
R497 VSS.n75 VSS.t2 12.8911
R498 VSS.n108 VSS.n39 11.5205
R499 VSS.n108 VSS.n107 11.5205
R500 VSS.n107 VSS.n106 11.5205
R501 VSS.n106 VSS.n45 11.5205
R502 VSS.n102 VSS.n45 11.5205
R503 VSS.n102 VSS.n101 11.5205
R504 VSS.n101 VSS.n100 11.5205
R505 VSS.n100 VSS.n50 11.5205
R506 VSS.n96 VSS.n50 11.5205
R507 VSS.n96 VSS.n95 11.5205
R508 VSS.n95 VSS.n94 11.5205
R509 VSS.n94 VSS.n55 11.5205
R510 VSS.n90 VSS.n55 11.5205
R511 VSS.n90 VSS.n89 11.5205
R512 VSS.n89 VSS.n88 11.5205
R513 VSS.n88 VSS.n85 11.5205
R514 VSS.n85 VSS.n30 11.5205
R515 VSS.n125 VSS.n124 11.5205
R516 VSS.n124 VSS.n26 11.5205
R517 VSS.n131 VSS.n26 11.5205
R518 VSS.n159 VSS.n158 11.5205
R519 VSS.n158 VSS.n157 11.5205
R520 VSS.n157 VSS.n7 11.5205
R521 VSS.n153 VSS.n7 11.5205
R522 VSS.n153 VSS.n152 11.5205
R523 VSS.n152 VSS.n151 11.5205
R524 VSS.n151 VSS.n148 11.5205
R525 VSS.n148 VSS.n147 11.5205
R526 VSS.n147 VSS.n14 11.5205
R527 VSS.n143 VSS.n14 11.5205
R528 VSS.n143 VSS.n142 11.5205
R529 VSS.n142 VSS.n18 11.5205
R530 VSS.n138 VSS.n18 11.5205
R531 VSS.n138 VSS.n137 11.5205
R532 VSS.n137 VSS.n136 11.5205
R533 VSS.n136 VSS.n23 11.5205
R534 VSS.n132 VSS.n23 11.5205
R535 VSS.n116 VSS.n40 11.5205
R536 VSS.n112 VSS.n40 11.5205
R537 VSS.n112 VSS.n3 11.5205
R538 VSS.n131 VSS.n130 9.3005
R539 VSS.n129 VSS.n26 9.3005
R540 VSS.n124 VSS.n28 9.3005
R541 VSS.n126 VSS.n125 9.3005
R542 VSS.n116 VSS.n115 9.3005
R543 VSS.n114 VSS.n40 9.3005
R544 VSS.n113 VSS.n112 9.3005
R545 VSS.n3 VSS.n1 9.3005
R546 VSS.n110 VSS.n39 9.3005
R547 VSS.n109 VSS.n108 9.3005
R548 VSS.n107 VSS.n41 9.3005
R549 VSS.n106 VSS.n105 9.3005
R550 VSS.n104 VSS.n45 9.3005
R551 VSS.n103 VSS.n102 9.3005
R552 VSS.n101 VSS.n46 9.3005
R553 VSS.n100 VSS.n99 9.3005
R554 VSS.n98 VSS.n50 9.3005
R555 VSS.n97 VSS.n96 9.3005
R556 VSS.n95 VSS.n51 9.3005
R557 VSS.n94 VSS.n93 9.3005
R558 VSS.n92 VSS.n55 9.3005
R559 VSS.n91 VSS.n90 9.3005
R560 VSS.n89 VSS.n56 9.3005
R561 VSS.n88 VSS.n87 9.3005
R562 VSS.n86 VSS.n85 9.3005
R563 VSS.n30 VSS.n29 9.3005
R564 VSS.n133 VSS.n132 9.3005
R565 VSS.n134 VSS.n23 9.3005
R566 VSS.n136 VSS.n135 9.3005
R567 VSS.n137 VSS.n19 9.3005
R568 VSS.n139 VSS.n138 9.3005
R569 VSS.n140 VSS.n18 9.3005
R570 VSS.n142 VSS.n141 9.3005
R571 VSS.n144 VSS.n143 9.3005
R572 VSS.n145 VSS.n14 9.3005
R573 VSS.n147 VSS.n146 9.3005
R574 VSS.n149 VSS.n148 9.3005
R575 VSS.n151 VSS.n150 9.3005
R576 VSS.n152 VSS.n8 9.3005
R577 VSS.n154 VSS.n153 9.3005
R578 VSS.n155 VSS.n7 9.3005
R579 VSS.n157 VSS.n156 9.3005
R580 VSS.n158 VSS.n2 9.3005
R581 VSS.n160 VSS.n159 9.3005
R582 VSS.n128 VSS.n127 0.792167
R583 VSS.n128 VSS.n24 0.792167
R584 VSS.n162 VSS.n161 0.396118
R585 VSS.n127 VSS.n126 0.328938
R586 VSS.n130 VSS.n24 0.31175
R587 VSS.n115 VSS.n110 0.266125
R588 VSS.n126 VSS.n28 0.1805
R589 VSS.n130 VSS.n129 0.1805
R590 VSS.n161 VSS.n1 0.128625
R591 VSS.n115 VSS.n114 0.113
R592 VSS.n114 VSS.n113 0.113
R593 VSS.n113 VSS.n1 0.113
R594 VSS.n110 VSS.n109 0.113
R595 VSS.n109 VSS.n41 0.113
R596 VSS.n105 VSS.n41 0.113
R597 VSS.n105 VSS.n104 0.113
R598 VSS.n104 VSS.n103 0.113
R599 VSS.n103 VSS.n46 0.113
R600 VSS.n99 VSS.n46 0.113
R601 VSS.n99 VSS.n98 0.113
R602 VSS.n98 VSS.n97 0.113
R603 VSS.n97 VSS.n51 0.113
R604 VSS.n93 VSS.n51 0.113
R605 VSS.n93 VSS.n92 0.113
R606 VSS.n92 VSS.n91 0.113
R607 VSS.n91 VSS.n56 0.113
R608 VSS.n87 VSS.n56 0.113
R609 VSS.n87 VSS.n86 0.113
R610 VSS.n86 VSS.n29 0.113
R611 VSS.t1 VSS.t0 0.110167
R612 VSS.n163 VSS 0.1086
R613 VSS.n127 VSS.n29 0.0989375
R614 VSS.n162 VSS.n0 0.0956744
R615 VSS.n128 VSS.n28 0.0905
R616 VSS.n129 VSS.n128 0.0905
R617 VSS VSS.t1 0.0866667
R618 VSS.n161 VSS.n160 0.0371667
R619 VSS.n160 VSS.n2 0.0305
R620 VSS.n156 VSS.n2 0.0305
R621 VSS.n156 VSS.n155 0.0305
R622 VSS.n155 VSS.n154 0.0305
R623 VSS.n154 VSS.n8 0.0305
R624 VSS.n150 VSS.n8 0.0305
R625 VSS.n150 VSS.n149 0.0305
R626 VSS.n146 VSS.n145 0.0305
R627 VSS.n145 VSS.n144 0.0305
R628 VSS.n141 VSS.n140 0.0305
R629 VSS.n140 VSS.n139 0.0305
R630 VSS.n139 VSS.n19 0.0305
R631 VSS.n135 VSS.n19 0.0305
R632 VSS.n135 VSS.n134 0.0305
R633 VSS.n134 VSS.n133 0.0305
R634 VSS.n133 VSS.n24 0.02675
R635 VSS.n141 VSS.n15 0.0255
R636 VSS VSS.t5 0.024
R637 VSS.n149 VSS.n0 0.0225833
R638 VSS.n163 VSS.n162 0.0124028
R639 VSS.n146 VSS.n0 0.00841667
R640 VSS.n144 VSS.n15 0.0055
R641 VSS VSS.n163 0.00526351
C0 phi2 cs 0.39481f
C1 phi2b VDD 0.95084f
C2 phi1b out 0.00128f
C3 phi2 phi1b 0.23481f
C4 phi1 in 0.38367f
C5 in cs 0.82116f
C6 phi2 out 0.28904f
C7 in phi1b 0.39088f
C8 phi1 VDD 0.60187f
C9 cs VDD 0.55316f
C10 phi1b VDD 0.82206f
C11 in out 1.16652f
C12 phi2 in 0.43393f
C13 phi1 phi2b 0.06334f
C14 phi2b cs 0.39062f
C15 out VDD 0.49264f
C16 phi2 VDD 0.73987f
C17 phi2b phi1b 1.27327f
C18 in VDD 0.86844f
C19 phi2b out 0.28586f
C20 phi1 cs 0.37465f
C21 phi2 phi2b 1.31655f
C22 phi1 phi1b 1.26867f
C23 cs phi1b 0.37332f
C24 in phi2b 0.1108f
C25 phi1 out 0.00148f
C26 phi2 phi1 1.9726f
C27 cs out 2.10604f
C28 out VSS 20.26468f
C29 in VSS 6.44594f
C30 phi2 VSS 4.07702f
C31 phi1 VSS 4.24445f
C32 VDD VSS 8.36197f
C33 cs VSS 3.96231f
C34 phi2b VSS 0.47074f
C35 phi1b VSS 0.56476f
C36 VDD.n0 VSS 0.20688f
C37 VDD.n1 VSS 0.00727f
C38 VDD.n2 VSS 0.02337f
C39 VDD.n3 VSS 0.01274f
C40 VDD.n4 VSS 0.01289f
C41 VDD.n5 VSS 0.00623f
C42 VDD.n6 VSS 0.00623f
C43 VDD.n7 VSS 0.00623f
C44 VDD.n8 VSS 0.02337f
C45 VDD.n9 VSS 0.00623f
C46 VDD.n10 VSS 0.00623f
C47 VDD.n11 VSS 0.00623f
C48 VDD.n12 VSS 0.00623f
C49 VDD.n13 VSS 0.00623f
C50 VDD.n14 VSS 0.00623f
C51 VDD.t2 VSS 0.0113f
C52 VDD.n15 VSS 0.03358f
C53 VDD.n16 VSS 0.00623f
C54 VDD.n17 VSS 0.00623f
C55 VDD.n18 VSS 0.00623f
C56 VDD.n19 VSS 0.02337f
C57 VDD.n20 VSS 0.00623f
C58 VDD.n21 VSS 0.00623f
C59 VDD.n22 VSS 0.00623f
C60 VDD.n23 VSS 0.00623f
C61 VDD.t5 VSS 0.0113f
C62 VDD.n24 VSS 0.02469f
C63 VDD.n25 VSS 0.01289f
C64 VDD.n26 VSS 0.01274f
C65 VDD.n27 VSS 0.00623f
C66 VDD.n28 VSS 0.00623f
C67 VDD.n29 VSS 0.0039f
C68 VDD.n30 VSS 0.00584f
C69 VDD.n31 VSS 0.00623f
C70 VDD.n32 VSS 0.01274f
C71 VDD.n33 VSS 0.00623f
C72 VDD.n34 VSS 0.00623f
C73 VDD.n35 VSS 0.06545f
C74 VDD.n36 VSS 0.00623f
C75 VDD.n37 VSS 0.00623f
C76 VDD.n38 VSS 0.00623f
C77 VDD.n39 VSS 0.00623f
C78 VDD.n40 VSS 0.00623f
C79 VDD.t1 VSS 0.03272f
C80 VDD.n41 VSS 0.00623f
C81 VDD.n42 VSS 0.00623f
C82 VDD.n43 VSS 0.00623f
C83 VDD.n44 VSS 0.00623f
C84 VDD.n45 VSS 0.00623f
C85 VDD.t0 VSS 0.03272f
C86 VDD.n46 VSS 0.00623f
C87 VDD.n47 VSS 0.00623f
C88 VDD.n48 VSS 0.00623f
C89 VDD.n49 VSS 0.00623f
C90 VDD.n50 VSS 0.00623f
C91 VDD.n51 VSS 0.04499f
C92 VDD.n52 VSS 0.00623f
C93 VDD.n53 VSS 0.00623f
C94 VDD.n54 VSS 0.01289f
C95 VDD.n55 VSS 0.01289f
C96 VDD.n56 VSS 0.01289f
C97 VDD.n58 VSS 0.00623f
C98 VDD.n59 VSS 0.00623f
C99 VDD.n60 VSS 0.01274f
C100 VDD.n61 VSS 0.00623f
C101 VDD.n62 VSS 0.01274f
C102 VDD.n63 VSS 0.01274f
C103 VDD.n64 VSS 0.00623f
C104 VDD.n65 VSS 0.00623f
C105 VDD.n66 VSS 0.00623f
C106 VDD.n67 VSS 0.00623f
C107 VDD.n68 VSS 0.00623f
C108 VDD.n69 VSS 0.00623f
C109 VDD.n70 VSS 0.01274f
C110 VDD.n72 VSS 0.16725f
C111 VDD.n73 VSS 0.07272f
C112 VDD.t3 VSS 0.03272f
C113 VDD.n74 VSS 0.05318f
C114 VDD.n75 VSS 0.00623f
C115 VDD.n76 VSS 0.00623f
C116 VDD.n77 VSS 0.00623f
C117 VDD.n78 VSS 0.00623f
C118 VDD.n79 VSS 0.00623f
C119 VDD.n80 VSS 0.00623f
C120 VDD.n81 VSS 0.00623f
C121 VDD.n82 VSS 0.00623f
C122 VDD.n83 VSS 0.06545f
C123 VDD.n84 VSS 0.06545f
C124 VDD.n85 VSS 0.03954f
C125 VDD.n86 VSS 0.06545f
C126 VDD.n87 VSS 0.00623f
C127 VDD.n88 VSS 0.00623f
C128 VDD.n89 VSS 0.00623f
C129 VDD.n90 VSS 0.00623f
C130 VDD.n91 VSS 0.00623f
C131 VDD.n92 VSS 0.00623f
C132 VDD.n93 VSS 0.00623f
C133 VDD.n94 VSS 0.05863f
C134 VDD.n95 VSS 0.06545f
C135 VDD.n96 VSS 0.05863f
C136 VDD.n97 VSS 0.00623f
C137 VDD.n98 VSS 0.06545f
C138 VDD.n99 VSS 0.00623f
C139 VDD.n100 VSS 0.00623f
C140 VDD.n101 VSS 0.00623f
C141 VDD.n102 VSS 0.00623f
C142 VDD.n103 VSS 0.00623f
C143 VDD.n104 VSS 0.00623f
C144 VDD.n105 VSS 0.00623f
C145 VDD.n106 VSS 0.03954f
C146 VDD.n107 VSS 0.00623f
C147 VDD.n108 VSS 0.06545f
C148 VDD.n109 VSS 0.06545f
C149 VDD.n110 VSS 0.00623f
C150 VDD.n111 VSS 0.00623f
C151 VDD.n112 VSS 0.00623f
C152 VDD.n113 VSS 0.00623f
C153 VDD.n114 VSS 0.00623f
C154 VDD.n115 VSS 0.00623f
C155 VDD.n116 VSS 0.00623f
C156 VDD.n117 VSS 0.00623f
C157 VDD.n118 VSS 0.04499f
C158 VDD.t4 VSS 0.03272f
C159 VDD.n119 VSS 0.00623f
C160 VDD.n120 VSS 0.05318f
C161 VDD.n122 VSS 0.00623f
C162 VDD.n123 VSS 0.00623f
C163 VDD.n124 VSS 0.00623f
C164 VDD.n126 VSS 0.16725f
C165 VDD.n127 VSS 0.07272f
C166 VDD.n128 VSS 0.01289f
C167 VDD.n129 VSS 0.01289f
C168 VDD.n130 VSS 0.01274f
C169 VDD.n131 VSS 0.00605f
C170 VDD.n132 VSS 0.01335f
C171 VDD.n133 VSS 0.01169f
C172 VDD.n134 VSS 0.0039f
C173 VDD.n135 VSS 0.00578f
C174 VDD.n136 VSS 0.01274f
C175 VDD.n137 VSS 0.01289f
C176 VDD.n138 VSS 0.02191f
C177 VDD.n139 VSS 0.04527f
C178 VDD.n140 VSS 0.02337f
C179 VDD.n141 VSS 0.00623f
C180 VDD.n142 VSS 0.00623f
C181 VDD.n143 VSS 0.00623f
C182 VDD.n144 VSS 0.02337f
C183 VDD.n145 VSS 0.02337f
C184 VDD.n146 VSS 0.02143f
C185 VDD.n147 VSS 0.00623f
C186 VDD.n148 VSS 0.00623f
C187 VDD.n149 VSS 0.01363f
C188 VDD.n150 VSS 0.02337f
C189 VDD.n151 VSS 0.01477f
C190 VDD.n152 VSS 0.00623f
C191 VDD.n153 VSS 0.00623f
C192 VDD.n154 VSS 0.02029f
C193 VDD.n155 VSS 0.02337f
C194 VDD.n156 VSS 0.00623f
C195 VDD.n157 VSS 0.00623f
C196 VDD.n158 VSS 0.00623f
C197 VDD.n159 VSS 0.02337f
C198 VDD.n160 VSS 0.02337f
C199 VDD.n161 VSS 0.02337f
C200 VDD.n162 VSS 0.00623f
C201 VDD.n163 VSS 0.00623f
C202 VDD.n164 VSS 0.01289f
C203 VDD.n165 VSS 0.02597f
C204 VDD.n166 VSS 0.47849f
C205 VDD.n167 VSS 1.23684f
C206 phi1.t1 VSS 0.04318f
C207 phi1.t2 VSS 0.06629f
C208 phi1.n0 VSS 1.45267f
C209 phi1.t0 VSS 0.04787f
C210 phi1.n1 VSS 0.7534f
C211 phi2.t2 VSS 0.07392f
C212 phi2.t1 VSS 0.04662f
C213 phi2.n0 VSS 1.57312f
C214 phi2.t0 VSS 0.04925f
C215 phi2.n1 VSS 1.0288f
C216 in.t1 VSS 0.05413f
C217 in.t0 VSS 0.03016f
C218 in.n0 VSS 0.82328f
C219 out.t1 VSS 0
C220 out.t0 VSS 0
C221 out.n0 VSS 0.0099f
C222 out.n1 VSS 0.00282f
C223 out.t3 VSS 2.10028f
C224 out.t2 VSS 2.01851f
C225 out.n2 VSS 0.12188f
C226 out.n3 VSS 0.03424f
.ends
