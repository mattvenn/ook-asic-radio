* amp_dp_t: magic R+C extraction of layout/amp_dp_t.gds (layout/pex.sh)
.subckt amp_dp_t inp inn nb outp outn VDD VSS
X0 tail nb.t23 VSS.t34 VSS.t33 sky130_fd_pr__nfet_01v8 ad=0.45 pd=3.3 as=0.45 ps=3.3 w=3 l=0.5
X1 tail nb.t21 VSS.t38 VSS.t37 sky130_fd_pr__nfet_01v8 ad=0.45 pd=3.3 as=0.45 ps=3.3 w=3 l=0.5
X2 outn.t15 inp.t1 tail VSS.t67 sky130_fd_pr__nfet_01v8 ad=0.75 pd=5.3 as=0.75 ps=5.3 w=5 l=0.15
X3 VSS.t36 nb.t22 tail VSS.t35 sky130_fd_pr__nfet_01v8 ad=0.45 pd=3.3 as=0.45 ps=3.3 w=3 l=0.5
X4 VSS.t54 nb.t6 tail VSS.t27 sky130_fd_pr__nfet_01v8 ad=0.45 pd=3.3 as=0.45 ps=3.3 w=3 l=0.5
X5 outn.t12 inp.t7 tail VSS.t61 sky130_fd_pr__nfet_01v8 ad=0.75 pd=5.3 as=1.5 ps=10.6 w=5 l=0.15
X6 tail nb.t7 VSS.t53 VSS.t25 sky130_fd_pr__nfet_01v8 ad=0.45 pd=3.3 as=0.45 ps=3.3 w=3 l=0.5
X7 tail inp.t6 outn.t0 VSS.t62 sky130_fd_pr__nfet_01v8 ad=0.75 pd=5.3 as=0.75 ps=5.3 w=5 l=0.15
X8 tail inp.t0 outn.t8 VSS.t68 sky130_fd_pr__nfet_01v8 ad=1.5 pd=10.6 as=0.75 ps=5.3 w=5 l=0.15
X9 VSS.t60 nb.t0 tail VSS.t39 sky130_fd_pr__nfet_01v8 ad=0.9 pd=6.6 as=0.45 ps=3.3 w=3 l=0.5
X10 outn.t1 inp.t5 tail VSS.t63 sky130_fd_pr__nfet_01v8 ad=0.75 pd=5.3 as=0.75 ps=5.3 w=5 l=0.15
X11 outn.t13 inp.t11 tail VSS.t73 sky130_fd_pr__nfet_01v8 ad=0.75 pd=5.3 as=1.5 ps=10.6 w=5 l=0.15
X12 VSS.t8 nb.t36 tail VSS.t7 sky130_fd_pr__nfet_01v8 ad=0.45 pd=3.3 as=0.45 ps=3.3 w=3 l=0.5
X13 tail inp.t4 outn.t6 VSS.t64 sky130_fd_pr__nfet_01v8 ad=1.5 pd=10.6 as=0.75 ps=5.3 w=5 l=0.15
X14 tail inp.t10 outn.t11 VSS.t74 sky130_fd_pr__nfet_01v8 ad=0.75 pd=5.3 as=0.75 ps=5.3 w=5 l=0.15
X15 tail nb.t37 VSS.t6 VSS.t5 sky130_fd_pr__nfet_01v8 ad=0.45 pd=3.3 as=0.45 ps=3.3 w=3 l=0.5
X16 tail nb.t31 VSS.t18 VSS.t17 sky130_fd_pr__nfet_01v8 ad=0.45 pd=3.3 as=0.45 ps=3.3 w=3 l=0.5
X17 tail nb.t19 VSS.t41 VSS.t1 sky130_fd_pr__nfet_01v8 ad=0.45 pd=3.3 as=0.9 ps=6.6 w=3 l=0.5
X18 outn.t5 inp.t15 tail VSS.t69 sky130_fd_pr__nfet_01v8 ad=0.75 pd=5.3 as=1.5 ps=10.6 w=5 l=0.15
X19 VSS.t16 nb.t32 tail VSS.t15 sky130_fd_pr__nfet_01v8 ad=0.45 pd=3.3 as=0.45 ps=3.3 w=3 l=0.5
X20 VSS.t46 nb.t14 tail VSS.t11 sky130_fd_pr__nfet_01v8 ad=0.45 pd=3.3 as=0.45 ps=3.3 w=3 l=0.5
X21 tail inp.t14 outn.t14 VSS.t70 sky130_fd_pr__nfet_01v8 ad=0.75 pd=5.3 as=0.75 ps=5.3 w=5 l=0.15
X22 outn.t10 inp.t9 tail VSS.t75 sky130_fd_pr__nfet_01v8 ad=0.75 pd=5.3 as=0.75 ps=5.3 w=5 l=0.15
X23 VSS.t32 nb.t24 tail VSS.t31 sky130_fd_pr__nfet_01v8 ad=0.45 pd=3.3 as=0.45 ps=3.3 w=3 l=0.5
X24 tail nb.t9 VSS.t51 VSS.t21 sky130_fd_pr__nfet_01v8 ad=0.45 pd=3.3 as=0.45 ps=3.3 w=3 l=0.5
X25 outp.t16 VDD.t1 VSS.t0 sky130_fd_pr__res_high_po_1p41 l=3.14
X26 outp.t1 inn.t11 tail VSS.t65 sky130_fd_pr__nfet_01v8 ad=0.75 pd=5.3 as=1.5 ps=10.6 w=5 l=0.15
X27 tail nb.t25 VSS.t30 VSS.t29 sky130_fd_pr__nfet_01v8 ad=0.45 pd=3.3 as=0.45 ps=3.3 w=3 l=0.5
X28 tail nb.t15 VSS.t45 VSS.t9 sky130_fd_pr__nfet_01v8 ad=0.45 pd=3.3 as=0.45 ps=3.3 w=3 l=0.5
X29 outn.t7 inp.t13 tail VSS.t71 sky130_fd_pr__nfet_01v8 ad=0.75 pd=5.3 as=0.75 ps=5.3 w=5 l=0.15
X30 tail inn.t10 outp.t15 VSS.t66 sky130_fd_pr__nfet_01v8 ad=0.75 pd=5.3 as=0.75 ps=5.3 w=5 l=0.15
X31 tail inp.t8 outn.t4 VSS.t76 sky130_fd_pr__nfet_01v8 ad=1.5 pd=10.6 as=0.75 ps=5.3 w=5 l=0.15
X32 VSS.t50 nb.t10 tail VSS.t19 sky130_fd_pr__nfet_01v8 ad=0.45 pd=3.3 as=0.45 ps=3.3 w=3 l=0.5
X33 VSS.t52 nb.t8 tail VSS.t23 sky130_fd_pr__nfet_01v8 ad=0.45 pd=3.3 as=0.45 ps=3.3 w=3 l=0.5
X34 tail inp.t12 outn.t3 VSS.t72 sky130_fd_pr__nfet_01v8 ad=1.5 pd=10.6 as=0.75 ps=5.3 w=5 l=0.15
X35 tail nb.t3 VSS.t57 VSS.t33 sky130_fd_pr__nfet_01v8 ad=0.45 pd=3.3 as=0.45 ps=3.3 w=3 l=0.5
X36 tail nb.t1 VSS.t59 VSS.t37 sky130_fd_pr__nfet_01v8 ad=0.45 pd=3.3 as=0.45 ps=3.3 w=3 l=0.5
X37 VSS.t58 nb.t2 tail VSS.t35 sky130_fd_pr__nfet_01v8 ad=0.45 pd=3.3 as=0.45 ps=3.3 w=3 l=0.5
X38 outp.t6 inn.t3 tail VSS.t73 sky130_fd_pr__nfet_01v8 ad=0.75 pd=5.3 as=1.5 ps=10.6 w=5 l=0.15
X39 VSS.t4 nb.t38 tail VSS.t3 sky130_fd_pr__nfet_01v8 ad=0.45 pd=3.3 as=0.45 ps=3.3 w=3 l=0.5
X40 outp.t3 inn.t7 tail VSS.t69 sky130_fd_pr__nfet_01v8 ad=0.75 pd=5.3 as=1.5 ps=10.6 w=5 l=0.15
X41 tail inn.t2 outp.t12 VSS.t74 sky130_fd_pr__nfet_01v8 ad=0.75 pd=5.3 as=0.75 ps=5.3 w=5 l=0.15
X42 tail nb.t33 VSS.t14 VSS.t13 sky130_fd_pr__nfet_01v8 ad=0.45 pd=3.3 as=0.45 ps=3.3 w=3 l=0.5
X43 tail inn.t6 outp.t2 VSS.t70 sky130_fd_pr__nfet_01v8 ad=0.75 pd=5.3 as=0.75 ps=5.3 w=5 l=0.15
X44 outn.t2 inp.t3 tail VSS.t65 sky130_fd_pr__nfet_01v8 ad=0.75 pd=5.3 as=1.5 ps=10.6 w=5 l=0.15
X45 outp.t0 inn.t1 tail VSS.t75 sky130_fd_pr__nfet_01v8 ad=0.75 pd=5.3 as=0.75 ps=5.3 w=5 l=0.15
X46 VSS.t28 nb.t26 tail VSS.t27 sky130_fd_pr__nfet_01v8 ad=0.45 pd=3.3 as=0.45 ps=3.3 w=3 l=0.5
X47 VSS.t44 nb.t16 tail VSS.t7 sky130_fd_pr__nfet_01v8 ad=0.45 pd=3.3 as=0.45 ps=3.3 w=3 l=0.5
X48 tail nb.t17 VSS.t43 VSS.t5 sky130_fd_pr__nfet_01v8 ad=0.45 pd=3.3 as=0.45 ps=3.3 w=3 l=0.5
X49 tail nb.t11 VSS.t49 VSS.t17 sky130_fd_pr__nfet_01v8 ad=0.45 pd=3.3 as=0.45 ps=3.3 w=3 l=0.5
X50 outp.t8 inn.t5 tail VSS.t71 sky130_fd_pr__nfet_01v8 ad=0.75 pd=5.3 as=0.75 ps=5.3 w=5 l=0.15
X51 tail inp.t2 outn.t9 VSS.t66 sky130_fd_pr__nfet_01v8 ad=0.75 pd=5.3 as=0.75 ps=5.3 w=5 l=0.15
X52 tail inn.t0 outp.t13 VSS.t76 sky130_fd_pr__nfet_01v8 ad=1.5 pd=10.6 as=0.75 ps=5.3 w=5 l=0.15
X53 tail nb.t27 VSS.t26 VSS.t25 sky130_fd_pr__nfet_01v8 ad=0.45 pd=3.3 as=0.45 ps=3.3 w=3 l=0.5
X54 VSS.t48 nb.t12 tail VSS.t15 sky130_fd_pr__nfet_01v8 ad=0.45 pd=3.3 as=0.45 ps=3.3 w=3 l=0.5
X55 VSS.t56 nb.t4 tail VSS.t31 sky130_fd_pr__nfet_01v8 ad=0.45 pd=3.3 as=0.45 ps=3.3 w=3 l=0.5
X56 tail inn.t4 outp.t7 VSS.t72 sky130_fd_pr__nfet_01v8 ad=1.5 pd=10.6 as=0.75 ps=5.3 w=5 l=0.15
X57 VSS.t40 nb.t20 tail VSS.t39 sky130_fd_pr__nfet_01v8 ad=0.9 pd=6.6 as=0.45 ps=3.3 w=3 l=0.5
X58 tail nb.t5 VSS.t55 VSS.t29 sky130_fd_pr__nfet_01v8 ad=0.45 pd=3.3 as=0.45 ps=3.3 w=3 l=0.5
X59 outp.t5 inn.t15 tail VSS.t61 sky130_fd_pr__nfet_01v8 ad=0.75 pd=5.3 as=1.5 ps=10.6 w=5 l=0.15
X60 outp.t10 inn.t9 tail VSS.t67 sky130_fd_pr__nfet_01v8 ad=0.75 pd=5.3 as=0.75 ps=5.3 w=5 l=0.15
X61 tail nb.t39 VSS.t2 VSS.t1 sky130_fd_pr__nfet_01v8 ad=0.45 pd=3.3 as=0.9 ps=6.6 w=3 l=0.5
X62 tail inn.t14 outp.t11 VSS.t62 sky130_fd_pr__nfet_01v8 ad=0.75 pd=5.3 as=0.75 ps=5.3 w=5 l=0.15
X63 tail inn.t8 outp.t9 VSS.t68 sky130_fd_pr__nfet_01v8 ad=1.5 pd=10.6 as=0.75 ps=5.3 w=5 l=0.15
X64 VSS.t12 nb.t34 tail VSS.t11 sky130_fd_pr__nfet_01v8 ad=0.45 pd=3.3 as=0.45 ps=3.3 w=3 l=0.5
X65 outp.t14 inn.t13 tail VSS.t63 sky130_fd_pr__nfet_01v8 ad=0.75 pd=5.3 as=0.75 ps=5.3 w=5 l=0.15
X66 tail nb.t35 VSS.t10 VSS.t9 sky130_fd_pr__nfet_01v8 ad=0.45 pd=3.3 as=0.45 ps=3.3 w=3 l=0.5
X67 tail nb.t29 VSS.t22 VSS.t21 sky130_fd_pr__nfet_01v8 ad=0.45 pd=3.3 as=0.45 ps=3.3 w=3 l=0.5
X68 VDD.t0 outn.t16 VSS.t0 sky130_fd_pr__res_high_po_1p41 l=3.14
X69 VSS.t20 nb.t30 tail VSS.t19 sky130_fd_pr__nfet_01v8 ad=0.45 pd=3.3 as=0.45 ps=3.3 w=3 l=0.5
X70 VSS.t42 nb.t18 tail VSS.t3 sky130_fd_pr__nfet_01v8 ad=0.45 pd=3.3 as=0.45 ps=3.3 w=3 l=0.5
X71 tail inn.t12 outp.t4 VSS.t64 sky130_fd_pr__nfet_01v8 ad=1.5 pd=10.6 as=0.75 ps=5.3 w=5 l=0.15
X72 VSS.t24 nb.t28 tail VSS.t23 sky130_fd_pr__nfet_01v8 ad=0.45 pd=3.3 as=0.45 ps=3.3 w=3 l=0.5
X73 tail nb.t13 VSS.t47 VSS.t13 sky130_fd_pr__nfet_01v8 ad=0.45 pd=3.3 as=0.45 ps=3.3 w=3 l=0.5
R0 nb.n19 nb.t0 408.675
R1 nb.n0 nb.t20 408.675
R2 nb.n36 nb.t18 408.567
R3 nb.n34 nb.t16 408.567
R4 nb.n32 nb.t14 408.567
R5 nb.n30 nb.t12 408.567
R6 nb.n28 nb.t10 408.567
R7 nb.n26 nb.t8 408.567
R8 nb.n24 nb.t6 408.567
R9 nb.n22 nb.t4 408.567
R10 nb.n20 nb.t2 408.567
R11 nb.n17 nb.t38 408.567
R12 nb.n15 nb.t36 408.567
R13 nb.n13 nb.t34 408.567
R14 nb.n11 nb.t32 408.567
R15 nb.n9 nb.t30 408.567
R16 nb.n7 nb.t28 408.567
R17 nb.n5 nb.t26 408.567
R18 nb.n3 nb.t24 408.567
R19 nb.n1 nb.t22 408.567
R20 nb.n37 nb.t19 341.087
R21 nb.n35 nb.t17 341.087
R22 nb.n33 nb.t15 341.087
R23 nb.n31 nb.t13 341.087
R24 nb.n29 nb.t11 341.087
R25 nb.n27 nb.t9 341.087
R26 nb.n25 nb.t7 341.087
R27 nb.n23 nb.t5 341.087
R28 nb.n21 nb.t3 341.087
R29 nb.n19 nb.t1 341.087
R30 nb.n18 nb.t39 341.087
R31 nb.n16 nb.t37 341.087
R32 nb.n14 nb.t35 341.087
R33 nb.n12 nb.t33 341.087
R34 nb.n10 nb.t31 341.087
R35 nb.n8 nb.t29 341.087
R36 nb.n6 nb.t27 341.087
R37 nb.n4 nb.t25 341.087
R38 nb.n2 nb.t23 341.087
R39 nb.n0 nb.t21 341.087
R40 nb.n38 nb 5.90675
R41 nb.n38 nb.n37 4.55552
R42 nb.n38 nb.n18 4.55452
R43 nb nb.n38 0.313
R44 nb.n20 nb.n19 0.108027
R45 nb.n21 nb.n20 0.108027
R46 nb.n22 nb.n21 0.108027
R47 nb.n23 nb.n22 0.108027
R48 nb.n24 nb.n23 0.108027
R49 nb.n25 nb.n24 0.108027
R50 nb.n26 nb.n25 0.108027
R51 nb.n27 nb.n26 0.108027
R52 nb.n28 nb.n27 0.108027
R53 nb.n29 nb.n28 0.108027
R54 nb.n30 nb.n29 0.108027
R55 nb.n31 nb.n30 0.108027
R56 nb.n32 nb.n31 0.108027
R57 nb.n33 nb.n32 0.108027
R58 nb.n34 nb.n33 0.108027
R59 nb.n35 nb.n34 0.108027
R60 nb.n36 nb.n35 0.108027
R61 nb.n37 nb.n36 0.108027
R62 nb.n1 nb.n0 0.108027
R63 nb.n2 nb.n1 0.108027
R64 nb.n3 nb.n2 0.108027
R65 nb.n4 nb.n3 0.108027
R66 nb.n5 nb.n4 0.108027
R67 nb.n6 nb.n5 0.108027
R68 nb.n7 nb.n6 0.108027
R69 nb.n8 nb.n7 0.108027
R70 nb.n9 nb.n8 0.108027
R71 nb.n10 nb.n9 0.108027
R72 nb.n11 nb.n10 0.108027
R73 nb.n12 nb.n11 0.108027
R74 nb.n13 nb.n12 0.108027
R75 nb.n14 nb.n13 0.108027
R76 nb.n15 nb.n14 0.108027
R77 nb.n16 nb.n15 0.108027
R78 nb.n17 nb.n16 0.108027
R79 nb.n18 nb.n17 0.108027
R80 outp.n9 outp.n8 32.9839
R81 outp.n16 outp.n15 32.9839
R82 outp.n23 outp.n22 32.9839
R83 outp.n30 outp.n29 32.9839
R84 outp.n44 outp.n41 32.9829
R85 outp.n51 outp.n50 32.9829
R86 outp.n58 outp.n57 32.9829
R87 outp.n65 outp.n64 32.9829
R88 outp.n7 outp.n6 32.592
R89 outp.n14 outp.n13 32.592
R90 outp.n21 outp.n20 32.592
R91 outp.n28 outp.n27 32.592
R92 outp.n43 outp.n42 32.5911
R93 outp.n49 outp.n48 32.5911
R94 outp.n56 outp.n55 32.5911
R95 outp.n63 outp.n62 32.5911
R96 outp.n44 outp.n43 23.4921
R97 outp.n51 outp.n48 23.4921
R98 outp.n58 outp.n55 23.4921
R99 outp.n65 outp.n62 23.4921
R100 outp.n8 outp.n7 23.4886
R101 outp.n15 outp.n14 23.4886
R102 outp.n22 outp.n21 23.4886
R103 outp.n29 outp.n28 23.4886
R104 outp.n50 outp.n49 22.4137
R105 outp.n57 outp.n56 22.4137
R106 outp.n64 outp.n63 22.4137
R107 outp.n42 outp.n41 22.4137
R108 outp.n9 outp.n6 22.4133
R109 outp.n16 outp.n13 22.4133
R110 outp.n23 outp.n20 22.4133
R111 outp.n30 outp.n27 22.4133
R112 outp.n41 outp.n40 9.3005
R113 outp.n50 outp.n47 9.3005
R114 outp.n57 outp.n54 9.3005
R115 outp.n64 outp.n61 9.3005
R116 outp.n10 outp.n9 9.3005
R117 outp.n17 outp.n16 9.3005
R118 outp.n24 outp.n23 9.3005
R119 outp.n31 outp.n30 9.3005
R120 outp.n11 outp.n6 8.1448
R121 outp.n18 outp.n13 8.1448
R122 outp.n25 outp.n20 8.1448
R123 outp.n32 outp.n27 8.1448
R124 outp.n42 outp.n39 8.034
R125 outp.n49 outp.n38 8.034
R126 outp.n56 outp.n37 8.034
R127 outp.n63 outp.n36 8.034
R128 outp.n68 outp.n67 6.21754
R129 outp.n46 outp.n39 4.55338
R130 outp.n53 outp.n38 4.55338
R131 outp.n60 outp.n37 4.55338
R132 outp.n67 outp.n36 4.55338
R133 outp.n12 outp.n5 4.55338
R134 outp.n19 outp.n4 4.55338
R135 outp.n26 outp.n3 4.55338
R136 outp.n33 outp.n2 4.55338
R137 outp.n67 outp.n66 4.5005
R138 outp.n60 outp.n59 4.5005
R139 outp.n53 outp.n52 4.5005
R140 outp.n46 outp.n45 4.5005
R141 outp.n33 outp.n32 4.5005
R142 outp.n26 outp.n25 4.5005
R143 outp.n19 outp.n18 4.5005
R144 outp.n12 outp.n11 4.5005
R145 outp.n35 outp.n34 4.43629
R146 outp.n43 outp.t11 3.6005
R147 outp.n43 outp.t5 3.6005
R148 outp.n48 outp.t4 3.6005
R149 outp.n48 outp.t14 3.6005
R150 outp.n55 outp.t15 3.6005
R151 outp.n55 outp.t1 3.6005
R152 outp.n62 outp.t9 3.6005
R153 outp.n62 outp.t10 3.6005
R154 outp.n7 outp.t2 3.6005
R155 outp.n7 outp.t3 3.6005
R156 outp.n14 outp.t7 3.6005
R157 outp.n14 outp.t8 3.6005
R158 outp.n21 outp.t12 3.6005
R159 outp.n21 outp.t6 3.6005
R160 outp.n28 outp.t13 3.6005
R161 outp.n28 outp.t0 3.6005
R162 outp.n1 outp.n0 3.40008
R163 outp outp.n68 2.50829
R164 outp.n26 outp.n19 2.41121
R165 outp.n1 outp 2.27858
R166 outp.n68 outp.n35 2.16553
R167 outp.n45 outp.n44 1.36089
R168 outp.n52 outp.n51 1.36089
R169 outp.n59 outp.n58 1.36089
R170 outp.n66 outp.n65 1.36089
R171 outp.n8 outp.n5 1.25203
R172 outp.n15 outp.n4 1.25203
R173 outp.n22 outp.n3 1.25203
R174 outp.n29 outp.n2 1.25203
R175 outp.n34 outp.t16 1.01967
R176 outp.n60 outp.n53 0.6255
R177 outp.n34 outp.n33 0.603179
R178 outp.n35 outp.n1 0.454143
R179 outp.n67 outp.n60 0.268357
R180 outp.n53 outp.n46 0.268357
R181 outp.n33 outp.n26 0.268357
R182 outp.n19 outp.n12 0.268357
R183 outp.n0 outp 0.160222
R184 outp.n10 outp.n5 0.132551
R185 outp.n17 outp.n4 0.132551
R186 outp.n24 outp.n3 0.132551
R187 outp.n31 outp.n2 0.132551
R188 outp.n40 outp.n39 0.115885
R189 outp.n47 outp.n38 0.115885
R190 outp.n54 outp.n37 0.115885
R191 outp.n61 outp.n36 0.115885
R192 outp.n45 outp.n40 0.0255
R193 outp.n52 outp.n47 0.0255
R194 outp.n59 outp.n54 0.0255
R195 outp.n66 outp.n61 0.0255
R196 outp.n0 outp 0.0213333
R197 outp.n11 outp.n10 0.00883333
R198 outp.n18 outp.n17 0.00883333
R199 outp.n25 outp.n24 0.00883333
R200 outp.n32 outp.n31 0.00883333
R201 outn.n41 outn.n40 46.3817
R202 outn.n48 outn.n45 46.3817
R203 outn.n55 outn.n52 46.3817
R204 outn.n62 outn.n59 46.3817
R205 outn.n6 outn.n5 46.3802
R206 outn.n13 outn.n12 46.3802
R207 outn.n20 outn.n19 46.3802
R208 outn.n27 outn.n26 46.3802
R209 outn.n7 outn.n6 31.8951
R210 outn.n14 outn.n13 31.8951
R211 outn.n21 outn.n20 31.8951
R212 outn.n28 outn.n27 31.8951
R213 outn.n41 outn.n38 31.8946
R214 outn.n48 outn.n47 31.8946
R215 outn.n55 outn.n54 31.8946
R216 outn.n62 outn.n61 31.8946
R217 outn.n47 outn.n46 25.2715
R218 outn.n54 outn.n53 25.2715
R219 outn.n61 outn.n60 25.2715
R220 outn.n39 outn.n38 25.2715
R221 outn.n7 outn.n4 25.2705
R222 outn.n14 outn.n11 25.2705
R223 outn.n21 outn.n18 25.2705
R224 outn.n28 outn.n25 25.2705
R225 outn.n5 outn.n4 17.9981
R226 outn.n12 outn.n11 17.9981
R227 outn.n19 outn.n18 17.9981
R228 outn.n26 outn.n25 17.9981
R229 outn.n40 outn.n39 17.9957
R230 outn.n46 outn.n45 17.9957
R231 outn.n53 outn.n52 17.9957
R232 outn.n60 outn.n59 17.9957
R233 outn.n38 outn.n37 9.3005
R234 outn.n47 outn.n44 9.3005
R235 outn.n54 outn.n51 9.3005
R236 outn.n61 outn.n58 9.3005
R237 outn.n8 outn.n7 9.3005
R238 outn.n15 outn.n14 9.3005
R239 outn.n22 outn.n21 9.3005
R240 outn.n29 outn.n28 9.3005
R241 outn.n32 outn.n31 5.80087
R242 outn.n9 outn.n4 4.57005
R243 outn.n16 outn.n11 4.57005
R244 outn.n23 outn.n18 4.57005
R245 outn.n30 outn.n25 4.57005
R246 outn.n43 outn.n36 4.55338
R247 outn.n50 outn.n35 4.55338
R248 outn.n57 outn.n34 4.55338
R249 outn.n64 outn.n33 4.55338
R250 outn.n10 outn.n3 4.55338
R251 outn.n17 outn.n2 4.55338
R252 outn.n24 outn.n1 4.55338
R253 outn.n31 outn.n0 4.55338
R254 outn.n64 outn.n63 4.5005
R255 outn.n57 outn.n56 4.5005
R256 outn.n50 outn.n49 4.5005
R257 outn.n43 outn.n42 4.5005
R258 outn.n31 outn.n30 4.5005
R259 outn.n24 outn.n23 4.5005
R260 outn.n17 outn.n16 4.5005
R261 outn.n10 outn.n9 4.5005
R262 outn.n39 outn.n36 4.46085
R263 outn.n46 outn.n35 4.46084
R264 outn.n53 outn.n34 4.46084
R265 outn.n60 outn.n33 4.46084
R266 outn.n66 outn.n65 4.01962
R267 outn.n67 outn 3.73758
R268 outn.n40 outn.t14 3.6005
R269 outn.n40 outn.t5 3.6005
R270 outn.n45 outn.t3 3.6005
R271 outn.n45 outn.t7 3.6005
R272 outn.n52 outn.t11 3.6005
R273 outn.n52 outn.t13 3.6005
R274 outn.n59 outn.t4 3.6005
R275 outn.n59 outn.t10 3.6005
R276 outn.n5 outn.t0 3.6005
R277 outn.n5 outn.t12 3.6005
R278 outn.n12 outn.t6 3.6005
R279 outn.n12 outn.t1 3.6005
R280 outn.n19 outn.t9 3.6005
R281 outn.n19 outn.t2 3.6005
R282 outn.n26 outn.t8 3.6005
R283 outn.n26 outn.t15 3.6005
R284 outn.n32 outn 2.56704
R285 outn.n42 outn.n41 2.52539
R286 outn.n49 outn.n48 2.52539
R287 outn.n56 outn.n55 2.52539
R288 outn.n63 outn.n62 2.52539
R289 outn.n6 outn.n3 2.41467
R290 outn.n13 outn.n2 2.41467
R291 outn.n20 outn.n1 2.41467
R292 outn.n27 outn.n0 2.41467
R293 outn.n57 outn.n50 2.41121
R294 outn outn.n67 2.21983
R295 outn.n66 outn.n32 2.16553
R296 outn.n65 outn.t16 1.01967
R297 outn.n24 outn.n17 0.6255
R298 outn.n65 outn.n64 0.603179
R299 outn.n67 outn.n66 0.454143
R300 outn.n64 outn.n57 0.268357
R301 outn.n50 outn.n43 0.268357
R302 outn.n31 outn.n24 0.268357
R303 outn.n17 outn.n10 0.268357
R304 outn.n37 outn.n36 0.132551
R305 outn.n44 outn.n35 0.132551
R306 outn.n51 outn.n34 0.132551
R307 outn.n58 outn.n33 0.132551
R308 outn.n8 outn.n3 0.115885
R309 outn.n15 outn.n2 0.115885
R310 outn.n22 outn.n1 0.115885
R311 outn.n29 outn.n0 0.115885
R312 outn.n9 outn.n8 0.0255
R313 outn.n16 outn.n15 0.0255
R314 outn.n23 outn.n22 0.0255
R315 outn.n30 outn.n29 0.0255
R316 outn.n42 outn.n37 0.00883333
R317 outn.n49 outn.n44 0.00883333
R318 outn.n56 outn.n51 0.00883333
R319 outn.n63 outn.n58 0.00883333
R320 VDD.n1 VDD.n0 4.71017
R321 VDD.n1 VDD.t0 3.2862
R322 VDD.n0 VDD.t1 3.2862
R323 VDD VDD.n1 0.868357
R324 VDD.n0 VDD 0.868357
R325 inn.n7 inn.t8 1283.35
R326 inn.n3 inn.t0 1283.35
R327 inn.n0 inn.t4 1283.35
R328 inn.n10 inn.t14 1283.29
R329 inn.n12 inn.t12 1283.29
R330 inn.n8 inn.t10 1283.29
R331 inn.n4 inn.t2 1283.29
R332 inn.n1 inn.t6 1283.29
R333 inn.n10 inn.t15 1058.42
R334 inn.n4 inn.t3 1058.42
R335 inn.n1 inn.t7 1058.42
R336 inn.n11 inn.t13 1058.36
R337 inn.n9 inn.t11 1058.36
R338 inn.n7 inn.t9 1058.36
R339 inn.n3 inn.t1 1058.36
R340 inn.n0 inn.t5 1058.36
R341 inn.n14 inn.n13 18.3026
R342 inn.n6 inn.n5 4.68407
R343 inn.n6 inn.n2 2.43407
R344 inn.n14 inn.n6 0.638
R345 inn inn.n14 0.363
R346 inn.n13 inn.n9 0.111387
R347 inn.n13 inn.n12 0.111387
R348 inn.n8 inn.n7 0.0609839
R349 inn.n9 inn.n8 0.0609839
R350 inn.n12 inn.n11 0.0609839
R351 inn.n11 inn.n10 0.0609839
R352 inn.n5 inn.n3 0.0307419
R353 inn.n5 inn.n4 0.0307419
R354 inn.n2 inn.n0 0.0307419
R355 inn.n2 inn.n1 0.0307419
R356 inp.n7 inp.t0 1283.35
R357 inp.n0 inp.t12 1283.35
R358 inp.n3 inp.t8 1283.35
R359 inp.n10 inp.t6 1283.29
R360 inp.n12 inp.t4 1283.29
R361 inp.n8 inp.t2 1283.29
R362 inp.n1 inp.t14 1283.29
R363 inp.n4 inp.t10 1283.29
R364 inp.n10 inp.t7 1058.42
R365 inp.n1 inp.t15 1058.42
R366 inp.n4 inp.t11 1058.42
R367 inp.n11 inp.t5 1058.36
R368 inp.n9 inp.t3 1058.36
R369 inp.n7 inp.t1 1058.36
R370 inp.n0 inp.t13 1058.36
R371 inp.n3 inp.t9 1058.36
R372 inp.n14 inp.n13 18.2368
R373 inp.n6 inp.n5 4.68507
R374 inp.n6 inp.n2 2.43507
R375 inp inp.n14 0.538
R376 inp.n14 inp.n6 0.463
R377 inp.n13 inp.n9 0.111387
R378 inp.n13 inp.n12 0.111387
R379 inp.n8 inp.n7 0.0609839
R380 inp.n9 inp.n8 0.0609839
R381 inp.n12 inp.n11 0.0609839
R382 inp.n11 inp.n10 0.0609839
R383 inp.n2 inp.n0 0.0307419
R384 inp.n2 inp.n1 0.0307419
R385 inp.n5 inp.n3 0.0307419
R386 inp.n5 inp.n4 0.0307419
R387 VSS.n1012 VSS.n114 585
R388 VSS.n1012 VSS.n121 585
R389 VSS.n1013 VSS.n93 585
R390 VSS.n1014 VSS.n1013 585
R391 VSS.n1011 VSS.n92 585
R392 VSS.n1011 VSS.n1010 585
R393 VSS.n167 VSS.n166 585
R394 VSS.n168 VSS.n167 585
R395 VSS.n174 VSS.n86 585
R396 VSS.n887 VSS.n174 585
R397 VSS.n876 VSS.n85 585
R398 VSS.n876 VSS.n184 585
R399 VSS.n877 VSS.n82 585
R400 VSS.n878 VSS.n877 585
R401 VSS.n875 VSS.n186 585
R402 VSS.n875 VSS.n874 585
R403 VSS.n185 VSS.n76 585
R404 VSS.n196 VSS.n185 585
R405 VSS.n194 VSS.n75 585
R406 VSS.n864 VSS.n194 585
R407 VSS.n852 VSS.n72 585
R408 VSS.n852 VSS.n192 585
R409 VSS.n854 VSS.n853 585
R410 VSS.n855 VSS.n854 585
R411 VSS.n851 VSS.n66 585
R412 VSS.n851 VSS.n203 585
R413 VSS.n850 VSS.n65 585
R414 VSS.n850 VSS.t11 585
R415 VSS.n205 VSS.n64 585
R416 VSS.n206 VSS.n205 585
R417 VSS.n841 VSS.n840 585
R418 VSS.n842 VSS.n841 585
R419 VSS.n839 VSS.n55 585
R420 VSS.n839 VSS.n838 585
R421 VSS.n215 VSS.n54 585
R422 VSS.n217 VSS.n215 585
R423 VSS.n223 VSS.n53 585
R424 VSS.n818 VSS.n223 585
R425 VSS.n807 VSS.n46 585
R426 VSS.n807 VSS.n806 585
R427 VSS.n808 VSS.n45 585
R428 VSS.n809 VSS.n808 585
R429 VSS.n805 VSS.n44 585
R430 VSS.n805 VSS.n231 585
R431 VSS.n804 VSS.n235 585
R432 VSS.n804 VSS.n803 585
R433 VSS.n234 VSS.n38 585
R434 VSS.n236 VSS.n234 585
R435 VSS.n794 VSS.n35 585
R436 VSS.n795 VSS.n794 585
R437 VSS.n793 VSS.n34 585
R438 VSS.n793 VSS.n792 585
R439 VSS.n246 VSS.n245 585
R440 VSS.n255 VSS.n246 585
R441 VSS.n253 VSS.n27 585
R442 VSS.n772 VSS.n253 585
R443 VSS.n269 VSS.n267 585
R444 VSS.n267 VSS.n252 585
R445 VSS.n762 VSS.n761 585
R446 VSS.n763 VSS.n762 585
R447 VSS.n268 VSS.n266 585
R448 VSS.n266 VSS.n262 585
R449 VSS.n741 VSS.n274 585
R450 VSS.n755 VSS.n274 585
R451 VSS.n738 VSS.n737 585
R452 VSS.n737 VSS.n736 585
R453 VSS.n286 VSS.n280 585
R454 VSS.t29 VSS.n280 585
R455 VSS.n720 VSS.n719 585
R456 VSS.n721 VSS.n720 585
R457 VSS.n718 VSS.n292 585
R458 VSS.n292 VSS.n291 585
R459 VSS.n299 VSS.n293 585
R460 VSS.n713 VSS.n299 585
R461 VSS.n313 VSS.n311 585
R462 VSS.n311 VSS.n297 585
R463 VSS.n703 VSS.n702 585
R464 VSS.n704 VSS.n703 585
R465 VSS.n312 VSS.n310 585
R466 VSS.n310 VSS.n307 585
R467 VSS.n339 VSS.n323 585
R468 VSS.n695 VSS.n323 585
R469 VSS.n335 VSS.n333 585
R470 VSS.n333 VSS.n321 585
R471 VSS.n686 VSS.n685 585
R472 VSS.n687 VSS.n686 585
R473 VSS.n334 VSS.n332 585
R474 VSS.n332 VSS.n329 585
R475 VSS.n662 VSS.n346 585
R476 VSS.n678 VSS.n346 585
R477 VSS.n359 VSS.n357 585
R478 VSS.n357 VSS.n355 585
R479 VSS.n669 VSS.n668 585
R480 VSS.n670 VSS.n669 585
R481 VSS.n358 VSS.n356 585
R482 VSS.n511 VSS.n510 585
R483 VSS.n508 VSS.n361 585
R484 VSS.n506 VSS.n505 585
R485 VSS.n504 VSS.n362 585
R486 VSS.n503 VSS.n502 585
R487 VSS.n500 VSS.n366 585
R488 VSS.n498 VSS.n497 585
R489 VSS.n496 VSS.n367 585
R490 VSS.n495 VSS.n494 585
R491 VSS.n492 VSS.n372 585
R492 VSS.n490 VSS.n489 585
R493 VSS.n488 VSS.n373 585
R494 VSS.n487 VSS.n486 585
R495 VSS.n484 VSS.n378 585
R496 VSS.n482 VSS.n481 585
R497 VSS.n480 VSS.n379 585
R498 VSS.n479 VSS.n478 585
R499 VSS.n476 VSS.n384 585
R500 VSS.n474 VSS.n473 585
R501 VSS.n472 VSS.n385 585
R502 VSS.n471 VSS.n470 585
R503 VSS.n468 VSS.n390 585
R504 VSS.n466 VSS.n465 585
R505 VSS.n464 VSS.n391 585
R506 VSS.n463 VSS.n462 585
R507 VSS.n460 VSS.n396 585
R508 VSS.n458 VSS.n457 585
R509 VSS.n456 VSS.n397 585
R510 VSS.n455 VSS.n454 585
R511 VSS.n452 VSS.n402 585
R512 VSS.n450 VSS.n449 585
R513 VSS.n448 VSS.n403 585
R514 VSS.n447 VSS.n446 585
R515 VSS.n444 VSS.n408 585
R516 VSS.n442 VSS.n441 585
R517 VSS.n440 VSS.n409 585
R518 VSS.n409 VSS.n352 585
R519 VSS.n1004 VSS.n1003 585
R520 VSS.n997 VSS.n895 585
R521 VSS.n999 VSS.n998 585
R522 VSS.n996 VSS.n995 585
R523 VSS.n994 VSS.n993 585
R524 VSS.n987 VSS.n897 585
R525 VSS.n989 VSS.n988 585
R526 VSS.n986 VSS.n985 585
R527 VSS.n984 VSS.n983 585
R528 VSS.n977 VSS.n899 585
R529 VSS.n979 VSS.n978 585
R530 VSS.n976 VSS.n975 585
R531 VSS.n974 VSS.n973 585
R532 VSS.n967 VSS.n901 585
R533 VSS.n969 VSS.n968 585
R534 VSS.n966 VSS.n965 585
R535 VSS.n964 VSS.n963 585
R536 VSS.n957 VSS.n903 585
R537 VSS.n959 VSS.n958 585
R538 VSS.n956 VSS.n955 585
R539 VSS.n954 VSS.n953 585
R540 VSS.n947 VSS.n905 585
R541 VSS.n949 VSS.n948 585
R542 VSS.n946 VSS.n945 585
R543 VSS.n944 VSS.n943 585
R544 VSS.n937 VSS.n907 585
R545 VSS.n939 VSS.n938 585
R546 VSS.n936 VSS.n935 585
R547 VSS.n934 VSS.n933 585
R548 VSS.n927 VSS.n909 585
R549 VSS.n929 VSS.n928 585
R550 VSS.n926 VSS.n925 585
R551 VSS.n924 VSS.n923 585
R552 VSS.n917 VSS.n911 585
R553 VSS.n919 VSS.n918 585
R554 VSS.n916 VSS.n915 585
R555 VSS.n914 VSS.n122 585
R556 VSS.n1117 VSS.n122 585
R557 VSS.n1006 VSS.n1005 585
R558 VSS.n1005 VSS.n121 585
R559 VSS.n1007 VSS.n165 585
R560 VSS.n1014 VSS.n165 585
R561 VSS.n1009 VSS.n1008 585
R562 VSS.n1010 VSS.n1009 585
R563 VSS.n170 VSS.n169 585
R564 VSS.n169 VSS.n168 585
R565 VSS.n889 VSS.n888 585
R566 VSS.n888 VSS.n887 585
R567 VSS.n173 VSS.n172 585
R568 VSS.n184 VSS.n173 585
R569 VSS.n871 VSS.n182 585
R570 VSS.n878 VSS.n182 585
R571 VSS.n873 VSS.n872 585
R572 VSS.n874 VSS.n873 585
R573 VSS.n188 VSS.n187 585
R574 VSS.n196 VSS.n187 585
R575 VSS.n866 VSS.n865 585
R576 VSS.n865 VSS.n864 585
R577 VSS.n191 VSS.n190 585
R578 VSS.n192 VSS.n191 585
R579 VSS.n829 VSS.n204 585
R580 VSS.n855 VSS.n204 585
R581 VSS.n831 VSS.n830 585
R582 VSS.n830 VSS.n203 585
R583 VSS.n832 VSS.n207 585
R584 VSS.t11 VSS.n207 585
R585 VSS.n834 VSS.n833 585
R586 VSS.n833 VSS.n206 585
R587 VSS.n835 VSS.n214 585
R588 VSS.n842 VSS.n214 585
R589 VSS.n837 VSS.n836 585
R590 VSS.n838 VSS.n837 585
R591 VSS.n219 VSS.n218 585
R592 VSS.n218 VSS.n217 585
R593 VSS.n820 VSS.n819 585
R594 VSS.n819 VSS.n818 585
R595 VSS.n222 VSS.n221 585
R596 VSS.n806 VSS.n222 585
R597 VSS.n783 VSS.n233 585
R598 VSS.n809 VSS.n233 585
R599 VSS.n785 VSS.n784 585
R600 VSS.n784 VSS.n231 585
R601 VSS.n786 VSS.n237 585
R602 VSS.n803 VSS.n237 585
R603 VSS.n788 VSS.n787 585
R604 VSS.n787 VSS.n236 585
R605 VSS.n789 VSS.n244 585
R606 VSS.n795 VSS.n244 585
R607 VSS.n791 VSS.n790 585
R608 VSS.n792 VSS.n791 585
R609 VSS.n248 VSS.n247 585
R610 VSS.n255 VSS.n247 585
R611 VSS.n774 VSS.n773 585
R612 VSS.n773 VSS.n772 585
R613 VSS.n251 VSS.n250 585
R614 VSS.n252 VSS.n251 585
R615 VSS.n730 VSS.n265 585
R616 VSS.n763 VSS.n265 585
R617 VSS.n732 VSS.n731 585
R618 VSS.n731 VSS.n262 585
R619 VSS.n733 VSS.n273 585
R620 VSS.n755 VSS.n273 585
R621 VSS.n735 VSS.n734 585
R622 VSS.n736 VSS.n735 585
R623 VSS.n287 VSS.n281 585
R624 VSS.t29 VSS.n281 585
R625 VSS.n723 VSS.n722 585
R626 VSS.n722 VSS.n721 585
R627 VSS.n290 VSS.n289 585
R628 VSS.n291 VSS.n290 585
R629 VSS.n424 VSS.n298 585
R630 VSS.n713 VSS.n298 585
R631 VSS.n426 VSS.n425 585
R632 VSS.n425 VSS.n297 585
R633 VSS.n427 VSS.n309 585
R634 VSS.n704 VSS.n309 585
R635 VSS.n429 VSS.n428 585
R636 VSS.n428 VSS.n307 585
R637 VSS.n430 VSS.n322 585
R638 VSS.n695 VSS.n322 585
R639 VSS.n432 VSS.n431 585
R640 VSS.n431 VSS.n321 585
R641 VSS.n433 VSS.n331 585
R642 VSS.n687 VSS.n331 585
R643 VSS.n435 VSS.n434 585
R644 VSS.n434 VSS.n329 585
R645 VSS.n436 VSS.n345 585
R646 VSS.n678 VSS.n345 585
R647 VSS.n438 VSS.n437 585
R648 VSS.n437 VSS.n355 585
R649 VSS.n439 VSS.n354 585
R650 VSS.n670 VSS.n354 585
R651 VSS.n672 VSS.n671 585
R652 VSS.n671 VSS.n670 585
R653 VSS.n348 VSS.n347 585
R654 VSS.n355 VSS.n347 585
R655 VSS.n677 VSS.n676 585
R656 VSS.n678 VSS.n677 585
R657 VSS.n328 VSS.n327 585
R658 VSS.n329 VSS.n328 585
R659 VSS.n689 VSS.n688 585
R660 VSS.n688 VSS.n687 585
R661 VSS.n325 VSS.n324 585
R662 VSS.n324 VSS.n321 585
R663 VSS.n694 VSS.n693 585
R664 VSS.n695 VSS.n694 585
R665 VSS.n306 VSS.n305 585
R666 VSS.n307 VSS.n306 585
R667 VSS.n706 VSS.n705 585
R668 VSS.n705 VSS.n704 585
R669 VSS.n302 VSS.n300 585
R670 VSS.n300 VSS.n297 585
R671 VSS.n712 VSS.n711 585
R672 VSS.n713 VSS.n712 585
R673 VSS.n303 VSS.n301 585
R674 VSS.n301 VSS.n291 585
R675 VSS.n279 VSS.n278 585
R676 VSS.n721 VSS.n279 585
R677 VSS.n749 VSS.n748 585
R678 VSS.n748 VSS.t29 585
R679 VSS.n276 VSS.n275 585
R680 VSS.n736 VSS.n275 585
R681 VSS.n754 VSS.n753 585
R682 VSS.n755 VSS.n754 585
R683 VSS.n261 VSS.n260 585
R684 VSS.n262 VSS.n261 585
R685 VSS.n765 VSS.n764 585
R686 VSS.n764 VSS.n763 585
R687 VSS.n257 VSS.n254 585
R688 VSS.n254 VSS.n252 585
R689 VSS.n771 VSS.n770 585
R690 VSS.n772 VSS.n771 585
R691 VSS.n258 VSS.n256 585
R692 VSS.n256 VSS.n255 585
R693 VSS.n242 VSS.n241 585
R694 VSS.n792 VSS.n242 585
R695 VSS.n797 VSS.n796 585
R696 VSS.n796 VSS.n795 585
R697 VSS.n239 VSS.n238 585
R698 VSS.n238 VSS.n236 585
R699 VSS.n802 VSS.n801 585
R700 VSS.n803 VSS.n802 585
R701 VSS.n230 VSS.n229 585
R702 VSS.n231 VSS.n230 585
R703 VSS.n811 VSS.n810 585
R704 VSS.n810 VSS.n809 585
R705 VSS.n226 VSS.n224 585
R706 VSS.n806 VSS.n224 585
R707 VSS.n817 VSS.n816 585
R708 VSS.n818 VSS.n817 585
R709 VSS.n227 VSS.n225 585
R710 VSS.n225 VSS.n217 585
R711 VSS.n213 VSS.n212 585
R712 VSS.n838 VSS.n213 585
R713 VSS.n844 VSS.n843 585
R714 VSS.n843 VSS.n842 585
R715 VSS.n210 VSS.n209 585
R716 VSS.n209 VSS.n206 585
R717 VSS.n849 VSS.n848 585
R718 VSS.t11 VSS.n849 585
R719 VSS.n202 VSS.n201 585
R720 VSS.n203 VSS.n202 585
R721 VSS.n857 VSS.n856 585
R722 VSS.n856 VSS.n855 585
R723 VSS.n198 VSS.n195 585
R724 VSS.n195 VSS.n192 585
R725 VSS.n863 VSS.n862 585
R726 VSS.n864 VSS.n863 585
R727 VSS.n199 VSS.n197 585
R728 VSS.n197 VSS.n196 585
R729 VSS.n181 VSS.n180 585
R730 VSS.n874 VSS.n181 585
R731 VSS.n880 VSS.n879 585
R732 VSS.n879 VSS.n878 585
R733 VSS.n177 VSS.n175 585
R734 VSS.n184 VSS.n175 585
R735 VSS.n886 VSS.n885 585
R736 VSS.n887 VSS.n886 585
R737 VSS.n178 VSS.n176 585
R738 VSS.n176 VSS.n168 585
R739 VSS.n163 VSS.n162 585
R740 VSS.n1010 VSS.n163 585
R741 VSS.n1016 VSS.n1015 585
R742 VSS.n1015 VSS.n1014 585
R743 VSS.n159 VSS.n157 585
R744 VSS.n157 VSS.n121 585
R745 VSS.n1125 VSS.n117 585
R746 VSS.n1119 VSS.n116 585
R747 VSS.n1121 VSS.n1120 585
R748 VSS.n1064 VSS.n119 585
R749 VSS.n1067 VSS.n1065 585
R750 VSS.n1068 VSS.n1063 585
R751 VSS.n1069 VSS.n1062 585
R752 VSS.n1060 VSS.n1059 585
R753 VSS.n1073 VSS.n1058 585
R754 VSS.n1074 VSS.n1057 585
R755 VSS.n1075 VSS.n1056 585
R756 VSS.n1054 VSS.n1053 585
R757 VSS.n1079 VSS.n1052 585
R758 VSS.n1080 VSS.n1051 585
R759 VSS.n1081 VSS.n1050 585
R760 VSS.n1048 VSS.n1047 585
R761 VSS.n1085 VSS.n1046 585
R762 VSS.n1086 VSS.n1045 585
R763 VSS.n1087 VSS.n1044 585
R764 VSS.n1042 VSS.n1041 585
R765 VSS.n1091 VSS.n1040 585
R766 VSS.n1092 VSS.n1039 585
R767 VSS.n1093 VSS.n1038 585
R768 VSS.n1036 VSS.n1035 585
R769 VSS.n1097 VSS.n1034 585
R770 VSS.n1098 VSS.n1033 585
R771 VSS.n1099 VSS.n1032 585
R772 VSS.n1030 VSS.n1029 585
R773 VSS.n1103 VSS.n1028 585
R774 VSS.n1104 VSS.n1027 585
R775 VSS.n1105 VSS.n1026 585
R776 VSS.n1024 VSS.n1023 585
R777 VSS.n1109 VSS.n1022 585
R778 VSS.n1110 VSS.n1021 585
R779 VSS.n1111 VSS.n1020 585
R780 VSS.n160 VSS.n158 585
R781 VSS.n1116 VSS.n1115 585
R782 VSS.n1117 VSS.n1116 585
R783 VSS.n1126 VSS.n115 585
R784 VSS.n121 VSS.n115 585
R785 VSS.n164 VSS.n91 585
R786 VSS.n1014 VSS.n164 585
R787 VSS.n1131 VSS.n90 585
R788 VSS.n1010 VSS.n90 585
R789 VSS.n1132 VSS.n89 585
R790 VSS.n168 VSS.n89 585
R791 VSS.n1133 VSS.n88 585
R792 VSS.n887 VSS.n88 585
R793 VSS.n183 VSS.n81 585
R794 VSS.n184 VSS.n183 585
R795 VSS.n1138 VSS.n80 585
R796 VSS.n878 VSS.n80 585
R797 VSS.n1139 VSS.n79 585
R798 VSS.n874 VSS.n79 585
R799 VSS.n1140 VSS.n78 585
R800 VSS.n196 VSS.n78 585
R801 VSS.n193 VSS.n71 585
R802 VSS.n864 VSS.n193 585
R803 VSS.n1145 VSS.n70 585
R804 VSS.n192 VSS.n70 585
R805 VSS.n1146 VSS.n69 585
R806 VSS.n855 VSS.n69 585
R807 VSS.n1147 VSS.n68 585
R808 VSS.n203 VSS.n68 585
R809 VSS.n208 VSS.n60 585
R810 VSS.t11 VSS.n208 585
R811 VSS.n1151 VSS.n59 585
R812 VSS.n206 VSS.n59 585
R813 VSS.n1152 VSS.n58 585
R814 VSS.n842 VSS.n58 585
R815 VSS.n1153 VSS.n57 585
R816 VSS.n838 VSS.n57 585
R817 VSS.n216 VSS.n52 585
R818 VSS.n217 VSS.n216 585
R819 VSS.n1157 VSS.n51 585
R820 VSS.n818 VSS.n51 585
R821 VSS.n1158 VSS.n50 585
R822 VSS.n806 VSS.n50 585
R823 VSS.n232 VSS.n43 585
R824 VSS.n809 VSS.n232 585
R825 VSS.n1162 VSS.n42 585
R826 VSS.n231 VSS.n42 585
R827 VSS.n1163 VSS.n41 585
R828 VSS.n803 VSS.n41 585
R829 VSS.n1164 VSS.n40 585
R830 VSS.n236 VSS.n40 585
R831 VSS.n243 VSS.n33 585
R832 VSS.n795 VSS.n243 585
R833 VSS.n1168 VSS.n32 585
R834 VSS.n792 VSS.n32 585
R835 VSS.n1169 VSS.n31 585
R836 VSS.n255 VSS.n31 585
R837 VSS.n1170 VSS.n30 585
R838 VSS.n772 VSS.n30 585
R839 VSS.n263 VSS.n29 585
R840 VSS.n263 VSS.n252 585
R841 VSS.n759 VSS.n264 585
R842 VSS.n763 VSS.n264 585
R843 VSS.n758 VSS.n757 585
R844 VSS.n757 VSS.n262 585
R845 VSS.n756 VSS.n271 585
R846 VSS.n756 VSS.n755 585
R847 VSS.n284 VSS.n272 585
R848 VSS.n736 VSS.n272 585
R849 VSS.n747 VSS.n746 585
R850 VSS.t29 VSS.n747 585
R851 VSS.n283 VSS.n282 585
R852 VSS.n721 VSS.n282 585
R853 VSS.n716 VSS.n715 585
R854 VSS.n715 VSS.n291 585
R855 VSS.n714 VSS.n295 585
R856 VSS.n714 VSS.n713 585
R857 VSS.n699 VSS.n296 585
R858 VSS.n297 VSS.n296 585
R859 VSS.n700 VSS.n308 585
R860 VSS.n704 VSS.n308 585
R861 VSS.n698 VSS.n697 585
R862 VSS.n697 VSS.n307 585
R863 VSS.n696 VSS.n319 585
R864 VSS.n696 VSS.n695 585
R865 VSS.n682 VSS.n320 585
R866 VSS.n321 VSS.n320 585
R867 VSS.n683 VSS.n330 585
R868 VSS.n687 VSS.n330 585
R869 VSS.n681 VSS.n680 585
R870 VSS.n680 VSS.n329 585
R871 VSS.n679 VSS.n343 585
R872 VSS.n679 VSS.n678 585
R873 VSS.n665 VSS.n344 585
R874 VSS.n355 VSS.n344 585
R875 VSS.n666 VSS.n353 585
R876 VSS.n670 VSS.n353 585
R877 VSS.n351 VSS.n350 585
R878 VSS.n575 VSS.n574 585
R879 VSS.n572 VSS.n571 585
R880 VSS.n571 VSS.n352 585
R881 VSS.n580 VSS.n579 585
R882 VSS.n582 VSS.n570 585
R883 VSS.n585 VSS.n584 585
R884 VSS.n568 VSS.n567 585
R885 VSS.n590 VSS.n589 585
R886 VSS.n592 VSS.n566 585
R887 VSS.n595 VSS.n594 585
R888 VSS.n564 VSS.n563 585
R889 VSS.n600 VSS.n599 585
R890 VSS.n602 VSS.n562 585
R891 VSS.n605 VSS.n604 585
R892 VSS.n560 VSS.n559 585
R893 VSS.n610 VSS.n609 585
R894 VSS.n612 VSS.n558 585
R895 VSS.n615 VSS.n614 585
R896 VSS.n556 VSS.n555 585
R897 VSS.n620 VSS.n619 585
R898 VSS.n622 VSS.n554 585
R899 VSS.n625 VSS.n624 585
R900 VSS.n552 VSS.n551 585
R901 VSS.n630 VSS.n629 585
R902 VSS.n632 VSS.n550 585
R903 VSS.n635 VSS.n634 585
R904 VSS.n548 VSS.n547 585
R905 VSS.n640 VSS.n639 585
R906 VSS.n642 VSS.n546 585
R907 VSS.n645 VSS.n644 585
R908 VSS.n544 VSS.n543 585
R909 VSS.n651 VSS.n650 585
R910 VSS.n653 VSS.n542 585
R911 VSS.n654 VSS.n539 585
R912 VSS.n657 VSS.n656 585
R913 VSS.n541 VSS.n536 585
R914 VSS.n661 VSS.n537 585
R915 VSS.n1012 VSS.n122 458.026
R916 VSS.n1005 VSS.n1004 458.026
R917 VSS.n409 VSS.n354 458.026
R918 VSS.n669 VSS.n356 458.026
R919 VSS.n1116 VSS.n157 458.026
R920 VSS.n117 VSS.n115 458.026
R921 VSS.n537 VSS.n353 458.026
R922 VSS.n671 VSS.n351 458.026
R923 VSS.n533 VSS.n532 256.483
R924 VSS.n523 VSS.n522 256.483
R925 VSS.n112 VSS.n111 256.483
R926 VSS.n102 VSS.n101 256.483
R927 VSS.n509 VSS.n352 254.01
R928 VSS.n507 VSS.n352 254.01
R929 VSS.n501 VSS.n352 254.01
R930 VSS.n499 VSS.n352 254.01
R931 VSS.n493 VSS.n352 254.01
R932 VSS.n491 VSS.n352 254.01
R933 VSS.n485 VSS.n352 254.01
R934 VSS.n483 VSS.n352 254.01
R935 VSS.n477 VSS.n352 254.01
R936 VSS.n475 VSS.n352 254.01
R937 VSS.n469 VSS.n352 254.01
R938 VSS.n467 VSS.n352 254.01
R939 VSS.n461 VSS.n352 254.01
R940 VSS.n459 VSS.n352 254.01
R941 VSS.n453 VSS.n352 254.01
R942 VSS.n451 VSS.n352 254.01
R943 VSS.n445 VSS.n352 254.01
R944 VSS.n443 VSS.n352 254.01
R945 VSS.n1117 VSS.n140 254.01
R946 VSS.n1117 VSS.n139 254.01
R947 VSS.n1117 VSS.n138 254.01
R948 VSS.n1117 VSS.n137 254.01
R949 VSS.n1117 VSS.n136 254.01
R950 VSS.n1117 VSS.n135 254.01
R951 VSS.n1117 VSS.n134 254.01
R952 VSS.n1117 VSS.n133 254.01
R953 VSS.n1117 VSS.n132 254.01
R954 VSS.n1117 VSS.n131 254.01
R955 VSS.n1117 VSS.n130 254.01
R956 VSS.n1117 VSS.n129 254.01
R957 VSS.n1117 VSS.n128 254.01
R958 VSS.n1117 VSS.n127 254.01
R959 VSS.n1117 VSS.n126 254.01
R960 VSS.n1117 VSS.n125 254.01
R961 VSS.n1117 VSS.n124 254.01
R962 VSS.n1117 VSS.n123 254.01
R963 VSS.n1118 VSS.n1117 254.01
R964 VSS.n1117 VSS.n120 254.01
R965 VSS.n1117 VSS.n141 254.01
R966 VSS.n1117 VSS.n142 254.01
R967 VSS.n1117 VSS.n143 254.01
R968 VSS.n1117 VSS.n144 254.01
R969 VSS.n1117 VSS.n145 254.01
R970 VSS.n1117 VSS.n146 254.01
R971 VSS.n1117 VSS.n147 254.01
R972 VSS.n1117 VSS.n148 254.01
R973 VSS.n1117 VSS.n149 254.01
R974 VSS.n1117 VSS.n150 254.01
R975 VSS.n1117 VSS.n151 254.01
R976 VSS.n1117 VSS.n152 254.01
R977 VSS.n1117 VSS.n153 254.01
R978 VSS.n1117 VSS.n154 254.01
R979 VSS.n1117 VSS.n155 254.01
R980 VSS.n1117 VSS.n156 254.01
R981 VSS.n573 VSS.n352 254.01
R982 VSS.n581 VSS.n352 254.01
R983 VSS.n583 VSS.n352 254.01
R984 VSS.n591 VSS.n352 254.01
R985 VSS.n593 VSS.n352 254.01
R986 VSS.n601 VSS.n352 254.01
R987 VSS.n603 VSS.n352 254.01
R988 VSS.n611 VSS.n352 254.01
R989 VSS.n613 VSS.n352 254.01
R990 VSS.n621 VSS.n352 254.01
R991 VSS.n623 VSS.n352 254.01
R992 VSS.n631 VSS.n352 254.01
R993 VSS.n633 VSS.n352 254.01
R994 VSS.n641 VSS.n352 254.01
R995 VSS.n643 VSS.n352 254.01
R996 VSS.n652 VSS.n352 254.01
R997 VSS.n655 VSS.n352 254.01
R998 VSS.n540 VSS.n352 254.01
R999 VSS.n532 VSS.n531 185
R1000 VSS.n528 VSS.n527 185
R1001 VSS.n518 VSS.n517 185
R1002 VSS.n522 VSS.n521 185
R1003 VSS.n111 VSS.n110 185
R1004 VSS.n107 VSS.n106 185
R1005 VSS.n97 VSS.n96 185
R1006 VSS.n101 VSS.n100 185
R1007 VSS.n519 VSS.t40 180.934
R1008 VSS.n98 VSS.t2 180.934
R1009 VSS.n529 VSS.t60 180.934
R1010 VSS.n108 VSS.t41 180.934
R1011 VSS.n915 VSS.n122 177.3
R1012 VSS.n918 VSS.n917 177.3
R1013 VSS.n925 VSS.n924 177.3
R1014 VSS.n928 VSS.n927 177.3
R1015 VSS.n935 VSS.n934 177.3
R1016 VSS.n938 VSS.n937 177.3
R1017 VSS.n945 VSS.n944 177.3
R1018 VSS.n948 VSS.n947 177.3
R1019 VSS.n955 VSS.n954 177.3
R1020 VSS.n958 VSS.n957 177.3
R1021 VSS.n965 VSS.n964 177.3
R1022 VSS.n968 VSS.n967 177.3
R1023 VSS.n975 VSS.n974 177.3
R1024 VSS.n978 VSS.n977 177.3
R1025 VSS.n985 VSS.n984 177.3
R1026 VSS.n988 VSS.n987 177.3
R1027 VSS.n995 VSS.n994 177.3
R1028 VSS.n998 VSS.n997 177.3
R1029 VSS.n437 VSS.n354 177.3
R1030 VSS.n437 VSS.n345 177.3
R1031 VSS.n434 VSS.n345 177.3
R1032 VSS.n434 VSS.n331 177.3
R1033 VSS.n431 VSS.n331 177.3
R1034 VSS.n431 VSS.n322 177.3
R1035 VSS.n428 VSS.n322 177.3
R1036 VSS.n428 VSS.n309 177.3
R1037 VSS.n425 VSS.n309 177.3
R1038 VSS.n425 VSS.n298 177.3
R1039 VSS.n298 VSS.n290 177.3
R1040 VSS.n722 VSS.n290 177.3
R1041 VSS.n722 VSS.n281 177.3
R1042 VSS.n735 VSS.n281 177.3
R1043 VSS.n735 VSS.n273 177.3
R1044 VSS.n731 VSS.n273 177.3
R1045 VSS.n731 VSS.n265 177.3
R1046 VSS.n265 VSS.n251 177.3
R1047 VSS.n773 VSS.n251 177.3
R1048 VSS.n773 VSS.n247 177.3
R1049 VSS.n791 VSS.n247 177.3
R1050 VSS.n791 VSS.n244 177.3
R1051 VSS.n787 VSS.n244 177.3
R1052 VSS.n787 VSS.n237 177.3
R1053 VSS.n784 VSS.n237 177.3
R1054 VSS.n784 VSS.n233 177.3
R1055 VSS.n233 VSS.n222 177.3
R1056 VSS.n819 VSS.n222 177.3
R1057 VSS.n819 VSS.n218 177.3
R1058 VSS.n837 VSS.n218 177.3
R1059 VSS.n837 VSS.n214 177.3
R1060 VSS.n833 VSS.n214 177.3
R1061 VSS.n833 VSS.n207 177.3
R1062 VSS.n830 VSS.n207 177.3
R1063 VSS.n830 VSS.n204 177.3
R1064 VSS.n204 VSS.n191 177.3
R1065 VSS.n865 VSS.n191 177.3
R1066 VSS.n865 VSS.n187 177.3
R1067 VSS.n873 VSS.n187 177.3
R1068 VSS.n873 VSS.n182 177.3
R1069 VSS.n182 VSS.n173 177.3
R1070 VSS.n888 VSS.n173 177.3
R1071 VSS.n888 VSS.n169 177.3
R1072 VSS.n1009 VSS.n169 177.3
R1073 VSS.n1009 VSS.n165 177.3
R1074 VSS.n1005 VSS.n165 177.3
R1075 VSS.n510 VSS.n508 177.3
R1076 VSS.n506 VSS.n362 177.3
R1077 VSS.n502 VSS.n500 177.3
R1078 VSS.n498 VSS.n367 177.3
R1079 VSS.n494 VSS.n492 177.3
R1080 VSS.n490 VSS.n373 177.3
R1081 VSS.n486 VSS.n484 177.3
R1082 VSS.n482 VSS.n379 177.3
R1083 VSS.n478 VSS.n476 177.3
R1084 VSS.n474 VSS.n385 177.3
R1085 VSS.n470 VSS.n468 177.3
R1086 VSS.n466 VSS.n391 177.3
R1087 VSS.n462 VSS.n460 177.3
R1088 VSS.n458 VSS.n397 177.3
R1089 VSS.n454 VSS.n452 177.3
R1090 VSS.n450 VSS.n403 177.3
R1091 VSS.n446 VSS.n444 177.3
R1092 VSS.n442 VSS.n409 177.3
R1093 VSS.n669 VSS.n357 177.3
R1094 VSS.n357 VSS.n346 177.3
R1095 VSS.n346 VSS.n332 177.3
R1096 VSS.n686 VSS.n332 177.3
R1097 VSS.n686 VSS.n333 177.3
R1098 VSS.n333 VSS.n323 177.3
R1099 VSS.n323 VSS.n310 177.3
R1100 VSS.n703 VSS.n310 177.3
R1101 VSS.n703 VSS.n311 177.3
R1102 VSS.n311 VSS.n299 177.3
R1103 VSS.n299 VSS.n292 177.3
R1104 VSS.n720 VSS.n292 177.3
R1105 VSS.n720 VSS.n280 177.3
R1106 VSS.n737 VSS.n280 177.3
R1107 VSS.n737 VSS.n274 177.3
R1108 VSS.n274 VSS.n266 177.3
R1109 VSS.n762 VSS.n266 177.3
R1110 VSS.n762 VSS.n267 177.3
R1111 VSS.n267 VSS.n253 177.3
R1112 VSS.n253 VSS.n246 177.3
R1113 VSS.n793 VSS.n246 177.3
R1114 VSS.n794 VSS.n793 177.3
R1115 VSS.n794 VSS.n234 177.3
R1116 VSS.n804 VSS.n234 177.3
R1117 VSS.n805 VSS.n804 177.3
R1118 VSS.n808 VSS.n805 177.3
R1119 VSS.n808 VSS.n807 177.3
R1120 VSS.n807 VSS.n223 177.3
R1121 VSS.n223 VSS.n215 177.3
R1122 VSS.n839 VSS.n215 177.3
R1123 VSS.n841 VSS.n839 177.3
R1124 VSS.n841 VSS.n205 177.3
R1125 VSS.n850 VSS.n205 177.3
R1126 VSS.n851 VSS.n850 177.3
R1127 VSS.n854 VSS.n851 177.3
R1128 VSS.n854 VSS.n852 177.3
R1129 VSS.n852 VSS.n194 177.3
R1130 VSS.n194 VSS.n185 177.3
R1131 VSS.n875 VSS.n185 177.3
R1132 VSS.n877 VSS.n875 177.3
R1133 VSS.n877 VSS.n876 177.3
R1134 VSS.n876 VSS.n174 177.3
R1135 VSS.n174 VSS.n167 177.3
R1136 VSS.n1011 VSS.n167 177.3
R1137 VSS.n1013 VSS.n1011 177.3
R1138 VSS.n1013 VSS.n1012 177.3
R1139 VSS.n1116 VSS.n158 177.3
R1140 VSS.n1021 VSS.n1020 177.3
R1141 VSS.n1023 VSS.n1022 177.3
R1142 VSS.n1027 VSS.n1026 177.3
R1143 VSS.n1029 VSS.n1028 177.3
R1144 VSS.n1033 VSS.n1032 177.3
R1145 VSS.n1035 VSS.n1034 177.3
R1146 VSS.n1039 VSS.n1038 177.3
R1147 VSS.n1041 VSS.n1040 177.3
R1148 VSS.n1045 VSS.n1044 177.3
R1149 VSS.n1047 VSS.n1046 177.3
R1150 VSS.n1051 VSS.n1050 177.3
R1151 VSS.n1053 VSS.n1052 177.3
R1152 VSS.n1057 VSS.n1056 177.3
R1153 VSS.n1059 VSS.n1058 177.3
R1154 VSS.n1063 VSS.n1062 177.3
R1155 VSS.n1065 VSS.n1064 177.3
R1156 VSS.n1120 VSS.n1119 177.3
R1157 VSS.n353 VSS.n344 177.3
R1158 VSS.n679 VSS.n344 177.3
R1159 VSS.n680 VSS.n679 177.3
R1160 VSS.n680 VSS.n330 177.3
R1161 VSS.n330 VSS.n320 177.3
R1162 VSS.n696 VSS.n320 177.3
R1163 VSS.n697 VSS.n696 177.3
R1164 VSS.n697 VSS.n308 177.3
R1165 VSS.n308 VSS.n296 177.3
R1166 VSS.n714 VSS.n296 177.3
R1167 VSS.n715 VSS.n714 177.3
R1168 VSS.n715 VSS.n282 177.3
R1169 VSS.n747 VSS.n282 177.3
R1170 VSS.n747 VSS.n272 177.3
R1171 VSS.n756 VSS.n272 177.3
R1172 VSS.n757 VSS.n756 177.3
R1173 VSS.n757 VSS.n264 177.3
R1174 VSS.n264 VSS.n263 177.3
R1175 VSS.n263 VSS.n30 177.3
R1176 VSS.n31 VSS.n30 177.3
R1177 VSS.n32 VSS.n31 177.3
R1178 VSS.n243 VSS.n32 177.3
R1179 VSS.n243 VSS.n40 177.3
R1180 VSS.n41 VSS.n40 177.3
R1181 VSS.n42 VSS.n41 177.3
R1182 VSS.n232 VSS.n42 177.3
R1183 VSS.n232 VSS.n50 177.3
R1184 VSS.n51 VSS.n50 177.3
R1185 VSS.n216 VSS.n51 177.3
R1186 VSS.n216 VSS.n57 177.3
R1187 VSS.n58 VSS.n57 177.3
R1188 VSS.n59 VSS.n58 177.3
R1189 VSS.n208 VSS.n59 177.3
R1190 VSS.n208 VSS.n68 177.3
R1191 VSS.n69 VSS.n68 177.3
R1192 VSS.n70 VSS.n69 177.3
R1193 VSS.n193 VSS.n70 177.3
R1194 VSS.n193 VSS.n78 177.3
R1195 VSS.n79 VSS.n78 177.3
R1196 VSS.n80 VSS.n79 177.3
R1197 VSS.n183 VSS.n80 177.3
R1198 VSS.n183 VSS.n88 177.3
R1199 VSS.n89 VSS.n88 177.3
R1200 VSS.n90 VSS.n89 177.3
R1201 VSS.n164 VSS.n90 177.3
R1202 VSS.n164 VSS.n115 177.3
R1203 VSS.n574 VSS.n571 177.3
R1204 VSS.n580 VSS.n571 177.3
R1205 VSS.n584 VSS.n582 177.3
R1206 VSS.n590 VSS.n567 177.3
R1207 VSS.n594 VSS.n592 177.3
R1208 VSS.n600 VSS.n563 177.3
R1209 VSS.n604 VSS.n602 177.3
R1210 VSS.n610 VSS.n559 177.3
R1211 VSS.n614 VSS.n612 177.3
R1212 VSS.n620 VSS.n555 177.3
R1213 VSS.n624 VSS.n622 177.3
R1214 VSS.n630 VSS.n551 177.3
R1215 VSS.n634 VSS.n632 177.3
R1216 VSS.n640 VSS.n547 177.3
R1217 VSS.n644 VSS.n642 177.3
R1218 VSS.n651 VSS.n543 177.3
R1219 VSS.n654 VSS.n653 177.3
R1220 VSS.n656 VSS.n541 177.3
R1221 VSS.n671 VSS.n347 177.3
R1222 VSS.n677 VSS.n347 177.3
R1223 VSS.n677 VSS.n328 177.3
R1224 VSS.n688 VSS.n328 177.3
R1225 VSS.n688 VSS.n324 177.3
R1226 VSS.n694 VSS.n324 177.3
R1227 VSS.n694 VSS.n306 177.3
R1228 VSS.n705 VSS.n306 177.3
R1229 VSS.n705 VSS.n300 177.3
R1230 VSS.n712 VSS.n300 177.3
R1231 VSS.n712 VSS.n301 177.3
R1232 VSS.n301 VSS.n279 177.3
R1233 VSS.n748 VSS.n279 177.3
R1234 VSS.n748 VSS.n275 177.3
R1235 VSS.n754 VSS.n275 177.3
R1236 VSS.n754 VSS.n261 177.3
R1237 VSS.n764 VSS.n261 177.3
R1238 VSS.n764 VSS.n254 177.3
R1239 VSS.n771 VSS.n254 177.3
R1240 VSS.n771 VSS.n256 177.3
R1241 VSS.n256 VSS.n242 177.3
R1242 VSS.n796 VSS.n242 177.3
R1243 VSS.n796 VSS.n238 177.3
R1244 VSS.n802 VSS.n238 177.3
R1245 VSS.n802 VSS.n230 177.3
R1246 VSS.n810 VSS.n230 177.3
R1247 VSS.n810 VSS.n224 177.3
R1248 VSS.n817 VSS.n224 177.3
R1249 VSS.n817 VSS.n225 177.3
R1250 VSS.n225 VSS.n213 177.3
R1251 VSS.n843 VSS.n213 177.3
R1252 VSS.n843 VSS.n209 177.3
R1253 VSS.n849 VSS.n209 177.3
R1254 VSS.n849 VSS.n202 177.3
R1255 VSS.n856 VSS.n202 177.3
R1256 VSS.n856 VSS.n195 177.3
R1257 VSS.n863 VSS.n195 177.3
R1258 VSS.n863 VSS.n197 177.3
R1259 VSS.n197 VSS.n181 177.3
R1260 VSS.n879 VSS.n181 177.3
R1261 VSS.n879 VSS.n175 177.3
R1262 VSS.n886 VSS.n175 177.3
R1263 VSS.n886 VSS.n176 177.3
R1264 VSS.n176 VSS.n163 177.3
R1265 VSS.n1015 VSS.n163 177.3
R1266 VSS.n1015 VSS.n157 177.3
R1267 VSS.n532 VSS.n527 144
R1268 VSS.n522 VSS.n517 144
R1269 VSS.n111 VSS.n106 144
R1270 VSS.n101 VSS.n96 144
R1271 VSS.n918 VSS.n123 76.985
R1272 VSS.n924 VSS.n124 76.985
R1273 VSS.n928 VSS.n125 76.985
R1274 VSS.n934 VSS.n126 76.985
R1275 VSS.n938 VSS.n127 76.985
R1276 VSS.n944 VSS.n128 76.985
R1277 VSS.n948 VSS.n129 76.985
R1278 VSS.n954 VSS.n130 76.985
R1279 VSS.n958 VSS.n131 76.985
R1280 VSS.n964 VSS.n132 76.985
R1281 VSS.n968 VSS.n133 76.985
R1282 VSS.n974 VSS.n134 76.985
R1283 VSS.n978 VSS.n135 76.985
R1284 VSS.n984 VSS.n136 76.985
R1285 VSS.n988 VSS.n137 76.985
R1286 VSS.n994 VSS.n138 76.985
R1287 VSS.n998 VSS.n139 76.985
R1288 VSS.n1004 VSS.n140 76.985
R1289 VSS.n509 VSS.n356 76.985
R1290 VSS.n508 VSS.n507 76.985
R1291 VSS.n501 VSS.n362 76.985
R1292 VSS.n500 VSS.n499 76.985
R1293 VSS.n493 VSS.n367 76.985
R1294 VSS.n492 VSS.n491 76.985
R1295 VSS.n485 VSS.n373 76.985
R1296 VSS.n484 VSS.n483 76.985
R1297 VSS.n477 VSS.n379 76.985
R1298 VSS.n476 VSS.n475 76.985
R1299 VSS.n469 VSS.n385 76.985
R1300 VSS.n468 VSS.n467 76.985
R1301 VSS.n461 VSS.n391 76.985
R1302 VSS.n460 VSS.n459 76.985
R1303 VSS.n453 VSS.n397 76.985
R1304 VSS.n452 VSS.n451 76.985
R1305 VSS.n445 VSS.n403 76.985
R1306 VSS.n444 VSS.n443 76.985
R1307 VSS.n510 VSS.n509 76.985
R1308 VSS.n507 VSS.n506 76.985
R1309 VSS.n502 VSS.n501 76.985
R1310 VSS.n499 VSS.n498 76.985
R1311 VSS.n494 VSS.n493 76.985
R1312 VSS.n491 VSS.n490 76.985
R1313 VSS.n486 VSS.n485 76.985
R1314 VSS.n483 VSS.n482 76.985
R1315 VSS.n478 VSS.n477 76.985
R1316 VSS.n475 VSS.n474 76.985
R1317 VSS.n470 VSS.n469 76.985
R1318 VSS.n467 VSS.n466 76.985
R1319 VSS.n462 VSS.n461 76.985
R1320 VSS.n459 VSS.n458 76.985
R1321 VSS.n454 VSS.n453 76.985
R1322 VSS.n451 VSS.n450 76.985
R1323 VSS.n446 VSS.n445 76.985
R1324 VSS.n443 VSS.n442 76.985
R1325 VSS.n997 VSS.n140 76.985
R1326 VSS.n995 VSS.n139 76.985
R1327 VSS.n987 VSS.n138 76.985
R1328 VSS.n985 VSS.n137 76.985
R1329 VSS.n977 VSS.n136 76.985
R1330 VSS.n975 VSS.n135 76.985
R1331 VSS.n967 VSS.n134 76.985
R1332 VSS.n965 VSS.n133 76.985
R1333 VSS.n957 VSS.n132 76.985
R1334 VSS.n955 VSS.n131 76.985
R1335 VSS.n947 VSS.n130 76.985
R1336 VSS.n945 VSS.n129 76.985
R1337 VSS.n937 VSS.n128 76.985
R1338 VSS.n935 VSS.n127 76.985
R1339 VSS.n927 VSS.n126 76.985
R1340 VSS.n925 VSS.n125 76.985
R1341 VSS.n917 VSS.n124 76.985
R1342 VSS.n915 VSS.n123 76.985
R1343 VSS.n1020 VSS.n156 76.985
R1344 VSS.n1022 VSS.n155 76.985
R1345 VSS.n1026 VSS.n154 76.985
R1346 VSS.n1028 VSS.n153 76.985
R1347 VSS.n1032 VSS.n152 76.985
R1348 VSS.n1034 VSS.n151 76.985
R1349 VSS.n1038 VSS.n150 76.985
R1350 VSS.n1040 VSS.n149 76.985
R1351 VSS.n1044 VSS.n148 76.985
R1352 VSS.n1046 VSS.n147 76.985
R1353 VSS.n1050 VSS.n146 76.985
R1354 VSS.n1052 VSS.n145 76.985
R1355 VSS.n1056 VSS.n144 76.985
R1356 VSS.n1058 VSS.n143 76.985
R1357 VSS.n1062 VSS.n142 76.985
R1358 VSS.n1065 VSS.n141 76.985
R1359 VSS.n1120 VSS.n120 76.985
R1360 VSS.n1118 VSS.n117 76.985
R1361 VSS.n573 VSS.n351 76.985
R1362 VSS.n581 VSS.n580 76.985
R1363 VSS.n584 VSS.n583 76.985
R1364 VSS.n591 VSS.n590 76.985
R1365 VSS.n594 VSS.n593 76.985
R1366 VSS.n601 VSS.n600 76.985
R1367 VSS.n604 VSS.n603 76.985
R1368 VSS.n611 VSS.n610 76.985
R1369 VSS.n614 VSS.n613 76.985
R1370 VSS.n621 VSS.n620 76.985
R1371 VSS.n624 VSS.n623 76.985
R1372 VSS.n631 VSS.n630 76.985
R1373 VSS.n634 VSS.n633 76.985
R1374 VSS.n641 VSS.n640 76.985
R1375 VSS.n644 VSS.n643 76.985
R1376 VSS.n652 VSS.n651 76.985
R1377 VSS.n655 VSS.n654 76.985
R1378 VSS.n541 VSS.n540 76.985
R1379 VSS.n1119 VSS.n1118 76.985
R1380 VSS.n1064 VSS.n120 76.985
R1381 VSS.n1063 VSS.n141 76.985
R1382 VSS.n1059 VSS.n142 76.985
R1383 VSS.n1057 VSS.n143 76.985
R1384 VSS.n1053 VSS.n144 76.985
R1385 VSS.n1051 VSS.n145 76.985
R1386 VSS.n1047 VSS.n146 76.985
R1387 VSS.n1045 VSS.n147 76.985
R1388 VSS.n1041 VSS.n148 76.985
R1389 VSS.n1039 VSS.n149 76.985
R1390 VSS.n1035 VSS.n150 76.985
R1391 VSS.n1033 VSS.n151 76.985
R1392 VSS.n1029 VSS.n152 76.985
R1393 VSS.n1027 VSS.n153 76.985
R1394 VSS.n1023 VSS.n154 76.985
R1395 VSS.n1021 VSS.n155 76.985
R1396 VSS.n158 VSS.n156 76.985
R1397 VSS.n574 VSS.n573 76.985
R1398 VSS.n582 VSS.n581 76.985
R1399 VSS.n583 VSS.n567 76.985
R1400 VSS.n592 VSS.n591 76.985
R1401 VSS.n593 VSS.n563 76.985
R1402 VSS.n602 VSS.n601 76.985
R1403 VSS.n603 VSS.n559 76.985
R1404 VSS.n612 VSS.n611 76.985
R1405 VSS.n613 VSS.n555 76.985
R1406 VSS.n622 VSS.n621 76.985
R1407 VSS.n623 VSS.n551 76.985
R1408 VSS.n632 VSS.n631 76.985
R1409 VSS.n633 VSS.n547 76.985
R1410 VSS.n642 VSS.n641 76.985
R1411 VSS.n643 VSS.n543 76.985
R1412 VSS.n653 VSS.n652 76.985
R1413 VSS.n656 VSS.n655 76.985
R1414 VSS.n540 VSS.n537 76.985
R1415 VSS.t60 VSS.n527 72.0005
R1416 VSS.t40 VSS.n517 72.0005
R1417 VSS.t41 VSS.n106 72.0005
R1418 VSS.t2 VSS.n96 72.0005
R1419 VSS.n670 VSS.n352 36.032
R1420 VSS.n1117 VSS.n121 36.032
R1421 VSS.n914 VSS.n114 29.7605
R1422 VSS.n1006 VSS.n1003 29.7605
R1423 VSS.n440 VSS.n439 29.7605
R1424 VSS.n668 VSS.n358 29.7605
R1425 VSS.n672 VSS.n350 29.7605
R1426 VSS.n1115 VSS.n159 29.7605
R1427 VSS.n1126 VSS.n1125 29.7605
R1428 VSS.n666 VSS.n661 29.7605
R1429 VSS.n531 VSS.n526 27.1064
R1430 VSS.n531 VSS.n528 27.1064
R1431 VSS.n521 VSS.n518 27.1064
R1432 VSS.n521 VSS.n516 27.1064
R1433 VSS.n110 VSS.n105 27.1064
R1434 VSS.n110 VSS.n107 27.1064
R1435 VSS.n100 VSS.n97 27.1064
R1436 VSS.n100 VSS.n95 27.1064
R1437 VSS.n534 VSS.n533 25.7818
R1438 VSS.n524 VSS.n523 25.7818
R1439 VSS.n113 VSS.n112 25.7818
R1440 VSS.n103 VSS.n102 25.7818
R1441 VSS.n670 VSS.n355 24.9454
R1442 VSS.n678 VSS.n329 24.9454
R1443 VSS.n687 VSS.n329 24.9454
R1444 VSS.n695 VSS.n321 24.9454
R1445 VSS.n704 VSS.n307 24.9454
R1446 VSS.n713 VSS.n297 24.9454
R1447 VSS.n721 VSS.n291 24.9454
R1448 VSS.n763 VSS.n262 24.9454
R1449 VSS.n772 VSS.n252 24.9454
R1450 VSS.n803 VSS.n236 24.9454
R1451 VSS.n809 VSS.n231 24.9454
R1452 VSS.n838 VSS.n217 24.9454
R1453 VSS.t11 VSS.n206 24.9454
R1454 VSS.t11 VSS.n203 24.9454
R1455 VSS.n855 VSS.n203 24.9454
R1456 VSS.n864 VSS.n192 24.9454
R1457 VSS.n878 VSS.n184 24.9454
R1458 VSS.n887 VSS.n168 24.9454
R1459 VSS.n1010 VSS.n168 24.9454
R1460 VSS.n1014 VSS.n121 24.9454
R1461 VSS.n1165 VSS.n37 24.9139
R1462 VSS.n341 VSS.n338 24.9139
R1463 VSS.n317 VSS.n316 24.9139
R1464 VSS.n743 VSS.n740 24.9139
R1465 VSS.n1172 VSS.n26 24.9139
R1466 VSS.n49 VSS.n48 24.9139
R1467 VSS.n63 VSS.n62 24.9139
R1468 VSS.n1143 VSS.n74 24.9139
R1469 VSS.n1136 VSS.n84 24.9139
R1470 VSS.n1165 VSS.n36 24.9139
R1471 VSS.n341 VSS.n337 24.9139
R1472 VSS.n317 VSS.n315 24.9139
R1473 VSS.n743 VSS.n739 24.9139
R1474 VSS.n1172 VSS.n25 24.9139
R1475 VSS.n49 VSS.n47 24.9139
R1476 VSS.n63 VSS.n61 24.9139
R1477 VSS.n1143 VSS.n73 24.9139
R1478 VSS.n1136 VSS.n83 24.9139
R1479 VSS.n795 VSS.t65 23.2131
R1480 VSS.t29 VSS.t75 22.5202
R1481 VSS.n355 VSS.t39 22.1737
R1482 VSS.t19 VSS.n231 22.1737
R1483 VSS.n184 VSS.t3 22.1737
R1484 VSS.n1014 VSS.t1 22.1737
R1485 VSS.n713 VSS.t31 19.4021
R1486 VSS.t27 VSS.n262 19.4021
R1487 VSS.t62 VSS.t13 19.0556
R1488 VSS.t61 VSS.n206 18.3627
R1489 VSS.n792 VSS.t66 16.9769
R1490 VSS.t35 VSS.n307 16.6304
R1491 VSS.n806 VSS.t17 16.6304
R1492 VSS.n736 VSS.t74 16.284
R1493 VSS.n874 VSS.t70 16.284
R1494 VSS.t9 VSS.t72 15.5911
R1495 VSS.n736 VSS.t73 14.8981
R1496 VSS.n874 VSS.t69 14.8981
R1497 VSS.n792 VSS.t67 14.2052
R1498 VSS.n704 VSS.t33 13.8588
R1499 VSS.t25 VSS.n252 13.8588
R1500 VSS.n818 VSS.t15 13.8588
R1501 VSS.n196 VSS.t7 13.8588
R1502 VSS.n806 VSS.t64 12.8194
R1503 VSS.t0 VSS.n321 12.1265
R1504 VSS.t23 VSS.t68 12.1265
R1505 VSS.n818 VSS.t64 12.1265
R1506 VSS.n916 VSS.n914 11.5205
R1507 VSS.n919 VSS.n916 11.5205
R1508 VSS.n919 VSS.n911 11.5205
R1509 VSS.n923 VSS.n911 11.5205
R1510 VSS.n926 VSS.n923 11.5205
R1511 VSS.n929 VSS.n926 11.5205
R1512 VSS.n929 VSS.n909 11.5205
R1513 VSS.n933 VSS.n909 11.5205
R1514 VSS.n936 VSS.n933 11.5205
R1515 VSS.n939 VSS.n936 11.5205
R1516 VSS.n939 VSS.n907 11.5205
R1517 VSS.n943 VSS.n907 11.5205
R1518 VSS.n946 VSS.n943 11.5205
R1519 VSS.n949 VSS.n946 11.5205
R1520 VSS.n949 VSS.n905 11.5205
R1521 VSS.n953 VSS.n905 11.5205
R1522 VSS.n956 VSS.n953 11.5205
R1523 VSS.n959 VSS.n956 11.5205
R1524 VSS.n959 VSS.n903 11.5205
R1525 VSS.n963 VSS.n903 11.5205
R1526 VSS.n966 VSS.n963 11.5205
R1527 VSS.n969 VSS.n966 11.5205
R1528 VSS.n969 VSS.n901 11.5205
R1529 VSS.n973 VSS.n901 11.5205
R1530 VSS.n976 VSS.n973 11.5205
R1531 VSS.n979 VSS.n976 11.5205
R1532 VSS.n979 VSS.n899 11.5205
R1533 VSS.n983 VSS.n899 11.5205
R1534 VSS.n986 VSS.n983 11.5205
R1535 VSS.n989 VSS.n986 11.5205
R1536 VSS.n989 VSS.n897 11.5205
R1537 VSS.n993 VSS.n897 11.5205
R1538 VSS.n996 VSS.n993 11.5205
R1539 VSS.n999 VSS.n996 11.5205
R1540 VSS.n999 VSS.n895 11.5205
R1541 VSS.n1003 VSS.n895 11.5205
R1542 VSS.n439 VSS.n438 11.5205
R1543 VSS.n438 VSS.n436 11.5205
R1544 VSS.n436 VSS.n435 11.5205
R1545 VSS.n435 VSS.n433 11.5205
R1546 VSS.n433 VSS.n432 11.5205
R1547 VSS.n432 VSS.n430 11.5205
R1548 VSS.n430 VSS.n429 11.5205
R1549 VSS.n429 VSS.n427 11.5205
R1550 VSS.n427 VSS.n426 11.5205
R1551 VSS.n426 VSS.n424 11.5205
R1552 VSS.n424 VSS.n289 11.5205
R1553 VSS.n723 VSS.n289 11.5205
R1554 VSS.n723 VSS.n287 11.5205
R1555 VSS.n734 VSS.n287 11.5205
R1556 VSS.n734 VSS.n733 11.5205
R1557 VSS.n733 VSS.n732 11.5205
R1558 VSS.n732 VSS.n730 11.5205
R1559 VSS.n730 VSS.n250 11.5205
R1560 VSS.n774 VSS.n250 11.5205
R1561 VSS.n774 VSS.n248 11.5205
R1562 VSS.n790 VSS.n248 11.5205
R1563 VSS.n790 VSS.n789 11.5205
R1564 VSS.n789 VSS.n788 11.5205
R1565 VSS.n788 VSS.n786 11.5205
R1566 VSS.n786 VSS.n785 11.5205
R1567 VSS.n785 VSS.n783 11.5205
R1568 VSS.n783 VSS.n221 11.5205
R1569 VSS.n820 VSS.n221 11.5205
R1570 VSS.n820 VSS.n219 11.5205
R1571 VSS.n836 VSS.n219 11.5205
R1572 VSS.n836 VSS.n835 11.5205
R1573 VSS.n835 VSS.n834 11.5205
R1574 VSS.n834 VSS.n832 11.5205
R1575 VSS.n832 VSS.n831 11.5205
R1576 VSS.n831 VSS.n829 11.5205
R1577 VSS.n829 VSS.n190 11.5205
R1578 VSS.n866 VSS.n190 11.5205
R1579 VSS.n866 VSS.n188 11.5205
R1580 VSS.n872 VSS.n188 11.5205
R1581 VSS.n872 VSS.n871 11.5205
R1582 VSS.n871 VSS.n172 11.5205
R1583 VSS.n889 VSS.n172 11.5205
R1584 VSS.n889 VSS.n170 11.5205
R1585 VSS.n1008 VSS.n170 11.5205
R1586 VSS.n1008 VSS.n1007 11.5205
R1587 VSS.n1007 VSS.n1006 11.5205
R1588 VSS.n511 VSS.n358 11.5205
R1589 VSS.n511 VSS.n361 11.5205
R1590 VSS.n505 VSS.n361 11.5205
R1591 VSS.n505 VSS.n504 11.5205
R1592 VSS.n504 VSS.n503 11.5205
R1593 VSS.n503 VSS.n366 11.5205
R1594 VSS.n497 VSS.n366 11.5205
R1595 VSS.n497 VSS.n496 11.5205
R1596 VSS.n496 VSS.n495 11.5205
R1597 VSS.n495 VSS.n372 11.5205
R1598 VSS.n489 VSS.n372 11.5205
R1599 VSS.n489 VSS.n488 11.5205
R1600 VSS.n488 VSS.n487 11.5205
R1601 VSS.n487 VSS.n378 11.5205
R1602 VSS.n481 VSS.n378 11.5205
R1603 VSS.n481 VSS.n480 11.5205
R1604 VSS.n480 VSS.n479 11.5205
R1605 VSS.n479 VSS.n384 11.5205
R1606 VSS.n473 VSS.n384 11.5205
R1607 VSS.n473 VSS.n472 11.5205
R1608 VSS.n472 VSS.n471 11.5205
R1609 VSS.n471 VSS.n390 11.5205
R1610 VSS.n465 VSS.n390 11.5205
R1611 VSS.n465 VSS.n464 11.5205
R1612 VSS.n464 VSS.n463 11.5205
R1613 VSS.n463 VSS.n396 11.5205
R1614 VSS.n457 VSS.n396 11.5205
R1615 VSS.n457 VSS.n456 11.5205
R1616 VSS.n456 VSS.n455 11.5205
R1617 VSS.n455 VSS.n402 11.5205
R1618 VSS.n449 VSS.n402 11.5205
R1619 VSS.n449 VSS.n448 11.5205
R1620 VSS.n448 VSS.n447 11.5205
R1621 VSS.n447 VSS.n408 11.5205
R1622 VSS.n441 VSS.n408 11.5205
R1623 VSS.n441 VSS.n440 11.5205
R1624 VSS.n668 VSS.n359 11.5205
R1625 VSS.n662 VSS.n359 11.5205
R1626 VSS.n662 VSS.n334 11.5205
R1627 VSS.n685 VSS.n334 11.5205
R1628 VSS.n685 VSS.n335 11.5205
R1629 VSS.n339 VSS.n335 11.5205
R1630 VSS.n339 VSS.n312 11.5205
R1631 VSS.n702 VSS.n312 11.5205
R1632 VSS.n702 VSS.n313 11.5205
R1633 VSS.n313 VSS.n293 11.5205
R1634 VSS.n718 VSS.n293 11.5205
R1635 VSS.n719 VSS.n718 11.5205
R1636 VSS.n719 VSS.n286 11.5205
R1637 VSS.n738 VSS.n286 11.5205
R1638 VSS.n741 VSS.n738 11.5205
R1639 VSS.n741 VSS.n268 11.5205
R1640 VSS.n761 VSS.n268 11.5205
R1641 VSS.n761 VSS.n269 11.5205
R1642 VSS.n269 VSS.n27 11.5205
R1643 VSS.n245 VSS.n27 11.5205
R1644 VSS.n245 VSS.n34 11.5205
R1645 VSS.n35 VSS.n34 11.5205
R1646 VSS.n38 VSS.n35 11.5205
R1647 VSS.n235 VSS.n38 11.5205
R1648 VSS.n235 VSS.n44 11.5205
R1649 VSS.n45 VSS.n44 11.5205
R1650 VSS.n46 VSS.n45 11.5205
R1651 VSS.n53 VSS.n46 11.5205
R1652 VSS.n54 VSS.n53 11.5205
R1653 VSS.n55 VSS.n54 11.5205
R1654 VSS.n840 VSS.n55 11.5205
R1655 VSS.n840 VSS.n64 11.5205
R1656 VSS.n65 VSS.n64 11.5205
R1657 VSS.n66 VSS.n65 11.5205
R1658 VSS.n853 VSS.n66 11.5205
R1659 VSS.n853 VSS.n72 11.5205
R1660 VSS.n75 VSS.n72 11.5205
R1661 VSS.n76 VSS.n75 11.5205
R1662 VSS.n186 VSS.n76 11.5205
R1663 VSS.n186 VSS.n82 11.5205
R1664 VSS.n85 VSS.n82 11.5205
R1665 VSS.n86 VSS.n85 11.5205
R1666 VSS.n166 VSS.n86 11.5205
R1667 VSS.n166 VSS.n92 11.5205
R1668 VSS.n93 VSS.n92 11.5205
R1669 VSS.n114 VSS.n93 11.5205
R1670 VSS.n672 VSS.n348 11.5205
R1671 VSS.n676 VSS.n348 11.5205
R1672 VSS.n676 VSS.n327 11.5205
R1673 VSS.n689 VSS.n327 11.5205
R1674 VSS.n689 VSS.n325 11.5205
R1675 VSS.n693 VSS.n325 11.5205
R1676 VSS.n693 VSS.n305 11.5205
R1677 VSS.n706 VSS.n305 11.5205
R1678 VSS.n706 VSS.n302 11.5205
R1679 VSS.n711 VSS.n302 11.5205
R1680 VSS.n711 VSS.n303 11.5205
R1681 VSS.n303 VSS.n278 11.5205
R1682 VSS.n749 VSS.n278 11.5205
R1683 VSS.n749 VSS.n276 11.5205
R1684 VSS.n753 VSS.n276 11.5205
R1685 VSS.n753 VSS.n260 11.5205
R1686 VSS.n765 VSS.n260 11.5205
R1687 VSS.n765 VSS.n257 11.5205
R1688 VSS.n770 VSS.n257 11.5205
R1689 VSS.n770 VSS.n258 11.5205
R1690 VSS.n258 VSS.n241 11.5205
R1691 VSS.n797 VSS.n241 11.5205
R1692 VSS.n797 VSS.n239 11.5205
R1693 VSS.n801 VSS.n239 11.5205
R1694 VSS.n801 VSS.n229 11.5205
R1695 VSS.n811 VSS.n229 11.5205
R1696 VSS.n811 VSS.n226 11.5205
R1697 VSS.n816 VSS.n226 11.5205
R1698 VSS.n816 VSS.n227 11.5205
R1699 VSS.n227 VSS.n212 11.5205
R1700 VSS.n844 VSS.n212 11.5205
R1701 VSS.n844 VSS.n210 11.5205
R1702 VSS.n848 VSS.n210 11.5205
R1703 VSS.n848 VSS.n201 11.5205
R1704 VSS.n857 VSS.n201 11.5205
R1705 VSS.n857 VSS.n198 11.5205
R1706 VSS.n862 VSS.n198 11.5205
R1707 VSS.n862 VSS.n199 11.5205
R1708 VSS.n199 VSS.n180 11.5205
R1709 VSS.n880 VSS.n180 11.5205
R1710 VSS.n880 VSS.n177 11.5205
R1711 VSS.n885 VSS.n177 11.5205
R1712 VSS.n885 VSS.n178 11.5205
R1713 VSS.n178 VSS.n162 11.5205
R1714 VSS.n1016 VSS.n162 11.5205
R1715 VSS.n1016 VSS.n159 11.5205
R1716 VSS.n1115 VSS.n160 11.5205
R1717 VSS.n1111 VSS.n160 11.5205
R1718 VSS.n1111 VSS.n1110 11.5205
R1719 VSS.n1110 VSS.n1109 11.5205
R1720 VSS.n1109 VSS.n1024 11.5205
R1721 VSS.n1105 VSS.n1024 11.5205
R1722 VSS.n1105 VSS.n1104 11.5205
R1723 VSS.n1104 VSS.n1103 11.5205
R1724 VSS.n1103 VSS.n1030 11.5205
R1725 VSS.n1099 VSS.n1030 11.5205
R1726 VSS.n1099 VSS.n1098 11.5205
R1727 VSS.n1098 VSS.n1097 11.5205
R1728 VSS.n1097 VSS.n1036 11.5205
R1729 VSS.n1093 VSS.n1036 11.5205
R1730 VSS.n1093 VSS.n1092 11.5205
R1731 VSS.n1092 VSS.n1091 11.5205
R1732 VSS.n1091 VSS.n1042 11.5205
R1733 VSS.n1087 VSS.n1042 11.5205
R1734 VSS.n1087 VSS.n1086 11.5205
R1735 VSS.n1086 VSS.n1085 11.5205
R1736 VSS.n1085 VSS.n1048 11.5205
R1737 VSS.n1081 VSS.n1048 11.5205
R1738 VSS.n1081 VSS.n1080 11.5205
R1739 VSS.n1080 VSS.n1079 11.5205
R1740 VSS.n1079 VSS.n1054 11.5205
R1741 VSS.n1075 VSS.n1054 11.5205
R1742 VSS.n1075 VSS.n1074 11.5205
R1743 VSS.n1074 VSS.n1073 11.5205
R1744 VSS.n1073 VSS.n1060 11.5205
R1745 VSS.n1069 VSS.n1060 11.5205
R1746 VSS.n1069 VSS.n1068 11.5205
R1747 VSS.n1068 VSS.n1067 11.5205
R1748 VSS.n1067 VSS.n119 11.5205
R1749 VSS.n1121 VSS.n119 11.5205
R1750 VSS.n1121 VSS.n116 11.5205
R1751 VSS.n1125 VSS.n116 11.5205
R1752 VSS.n666 VSS.n665 11.5205
R1753 VSS.n665 VSS.n343 11.5205
R1754 VSS.n681 VSS.n343 11.5205
R1755 VSS.n683 VSS.n681 11.5205
R1756 VSS.n683 VSS.n682 11.5205
R1757 VSS.n682 VSS.n319 11.5205
R1758 VSS.n698 VSS.n319 11.5205
R1759 VSS.n700 VSS.n698 11.5205
R1760 VSS.n700 VSS.n699 11.5205
R1761 VSS.n699 VSS.n295 11.5205
R1762 VSS.n716 VSS.n295 11.5205
R1763 VSS.n716 VSS.n283 11.5205
R1764 VSS.n746 VSS.n283 11.5205
R1765 VSS.n746 VSS.n284 11.5205
R1766 VSS.n284 VSS.n271 11.5205
R1767 VSS.n758 VSS.n271 11.5205
R1768 VSS.n759 VSS.n758 11.5205
R1769 VSS.n759 VSS.n29 11.5205
R1770 VSS.n1170 VSS.n29 11.5205
R1771 VSS.n1170 VSS.n1169 11.5205
R1772 VSS.n1169 VSS.n1168 11.5205
R1773 VSS.n1168 VSS.n33 11.5205
R1774 VSS.n1164 VSS.n33 11.5205
R1775 VSS.n1164 VSS.n1163 11.5205
R1776 VSS.n1163 VSS.n1162 11.5205
R1777 VSS.n1162 VSS.n43 11.5205
R1778 VSS.n1158 VSS.n43 11.5205
R1779 VSS.n1158 VSS.n1157 11.5205
R1780 VSS.n1157 VSS.n52 11.5205
R1781 VSS.n1153 VSS.n52 11.5205
R1782 VSS.n1153 VSS.n1152 11.5205
R1783 VSS.n1152 VSS.n1151 11.5205
R1784 VSS.n1151 VSS.n60 11.5205
R1785 VSS.n1147 VSS.n60 11.5205
R1786 VSS.n1147 VSS.n1146 11.5205
R1787 VSS.n1146 VSS.n1145 11.5205
R1788 VSS.n1145 VSS.n71 11.5205
R1789 VSS.n1140 VSS.n71 11.5205
R1790 VSS.n1140 VSS.n1139 11.5205
R1791 VSS.n1139 VSS.n1138 11.5205
R1792 VSS.n1138 VSS.n81 11.5205
R1793 VSS.n1133 VSS.n81 11.5205
R1794 VSS.n1133 VSS.n1132 11.5205
R1795 VSS.n1132 VSS.n1131 11.5205
R1796 VSS.n1131 VSS.n91 11.5205
R1797 VSS.n1126 VSS.n91 11.5205
R1798 VSS.n575 VSS.n350 11.5205
R1799 VSS.n575 VSS.n572 11.5205
R1800 VSS.n579 VSS.n572 11.5205
R1801 VSS.n579 VSS.n570 11.5205
R1802 VSS.n585 VSS.n570 11.5205
R1803 VSS.n585 VSS.n568 11.5205
R1804 VSS.n589 VSS.n568 11.5205
R1805 VSS.n589 VSS.n566 11.5205
R1806 VSS.n595 VSS.n566 11.5205
R1807 VSS.n595 VSS.n564 11.5205
R1808 VSS.n599 VSS.n564 11.5205
R1809 VSS.n599 VSS.n562 11.5205
R1810 VSS.n605 VSS.n562 11.5205
R1811 VSS.n605 VSS.n560 11.5205
R1812 VSS.n609 VSS.n560 11.5205
R1813 VSS.n609 VSS.n558 11.5205
R1814 VSS.n615 VSS.n558 11.5205
R1815 VSS.n615 VSS.n556 11.5205
R1816 VSS.n619 VSS.n556 11.5205
R1817 VSS.n619 VSS.n554 11.5205
R1818 VSS.n625 VSS.n554 11.5205
R1819 VSS.n625 VSS.n552 11.5205
R1820 VSS.n629 VSS.n552 11.5205
R1821 VSS.n629 VSS.n550 11.5205
R1822 VSS.n635 VSS.n550 11.5205
R1823 VSS.n635 VSS.n548 11.5205
R1824 VSS.n639 VSS.n548 11.5205
R1825 VSS.n639 VSS.n546 11.5205
R1826 VSS.n645 VSS.n546 11.5205
R1827 VSS.n645 VSS.n544 11.5205
R1828 VSS.n650 VSS.n544 11.5205
R1829 VSS.n650 VSS.n542 11.5205
R1830 VSS.n542 VSS.n539 11.5205
R1831 VSS.n657 VSS.n539 11.5205
R1832 VSS.n657 VSS.n536 11.5205
R1833 VSS.n661 VSS.n536 11.5205
R1834 VSS.t33 VSS.n297 11.0871
R1835 VSS.n763 VSS.t25 11.0871
R1836 VSS.n255 VSS.t67 10.7407
R1837 VSS.t37 VSS.t0 10.0477
R1838 VSS.n755 VSS.t73 10.0477
R1839 VSS.n521 VSS.n520 9.3005
R1840 VSS.n516 VSS.n515 9.3005
R1841 VSS.n526 VSS.n525 9.3005
R1842 VSS.n531 VSS.n530 9.3005
R1843 VSS.n100 VSS.n99 9.3005
R1844 VSS.n95 VSS.n94 9.3005
R1845 VSS.n105 VSS.n104 9.3005
R1846 VSS.n110 VSS.n109 9.3005
R1847 VSS.n438 VSS.n414 9.3005
R1848 VSS.n436 VSS.n415 9.3005
R1849 VSS.n435 VSS.n416 9.3005
R1850 VSS.n433 VSS.n417 9.3005
R1851 VSS.n432 VSS.n418 9.3005
R1852 VSS.n430 VSS.n419 9.3005
R1853 VSS.n429 VSS.n420 9.3005
R1854 VSS.n427 VSS.n421 9.3005
R1855 VSS.n426 VSS.n422 9.3005
R1856 VSS.n424 VSS.n423 9.3005
R1857 VSS.n289 VSS.n288 9.3005
R1858 VSS.n724 VSS.n723 9.3005
R1859 VSS.n725 VSS.n287 9.3005
R1860 VSS.n734 VSS.n726 9.3005
R1861 VSS.n733 VSS.n727 9.3005
R1862 VSS.n732 VSS.n728 9.3005
R1863 VSS.n730 VSS.n729 9.3005
R1864 VSS.n250 VSS.n249 9.3005
R1865 VSS.n775 VSS.n774 9.3005
R1866 VSS.n776 VSS.n248 9.3005
R1867 VSS.n790 VSS.n777 9.3005
R1868 VSS.n789 VSS.n778 9.3005
R1869 VSS.n788 VSS.n779 9.3005
R1870 VSS.n786 VSS.n780 9.3005
R1871 VSS.n785 VSS.n781 9.3005
R1872 VSS.n783 VSS.n782 9.3005
R1873 VSS.n221 VSS.n220 9.3005
R1874 VSS.n821 VSS.n820 9.3005
R1875 VSS.n822 VSS.n219 9.3005
R1876 VSS.n836 VSS.n823 9.3005
R1877 VSS.n835 VSS.n824 9.3005
R1878 VSS.n834 VSS.n825 9.3005
R1879 VSS.n832 VSS.n826 9.3005
R1880 VSS.n831 VSS.n827 9.3005
R1881 VSS.n829 VSS.n828 9.3005
R1882 VSS.n190 VSS.n189 9.3005
R1883 VSS.n867 VSS.n866 9.3005
R1884 VSS.n868 VSS.n188 9.3005
R1885 VSS.n872 VSS.n869 9.3005
R1886 VSS.n871 VSS.n870 9.3005
R1887 VSS.n172 VSS.n171 9.3005
R1888 VSS.n890 VSS.n889 9.3005
R1889 VSS.n891 VSS.n170 9.3005
R1890 VSS.n1008 VSS.n892 9.3005
R1891 VSS.n1007 VSS.n893 9.3005
R1892 VSS.n1006 VSS.n894 9.3005
R1893 VSS.n439 VSS.n413 9.3005
R1894 VSS.n513 VSS.n358 9.3005
R1895 VSS.n512 VSS.n511 9.3005
R1896 VSS.n361 VSS.n360 9.3005
R1897 VSS.n505 VSS.n363 9.3005
R1898 VSS.n504 VSS.n364 9.3005
R1899 VSS.n503 VSS.n365 9.3005
R1900 VSS.n368 VSS.n366 9.3005
R1901 VSS.n497 VSS.n369 9.3005
R1902 VSS.n496 VSS.n370 9.3005
R1903 VSS.n495 VSS.n371 9.3005
R1904 VSS.n374 VSS.n372 9.3005
R1905 VSS.n489 VSS.n375 9.3005
R1906 VSS.n488 VSS.n376 9.3005
R1907 VSS.n487 VSS.n377 9.3005
R1908 VSS.n380 VSS.n378 9.3005
R1909 VSS.n481 VSS.n381 9.3005
R1910 VSS.n480 VSS.n382 9.3005
R1911 VSS.n479 VSS.n383 9.3005
R1912 VSS.n386 VSS.n384 9.3005
R1913 VSS.n473 VSS.n387 9.3005
R1914 VSS.n472 VSS.n388 9.3005
R1915 VSS.n471 VSS.n389 9.3005
R1916 VSS.n392 VSS.n390 9.3005
R1917 VSS.n465 VSS.n393 9.3005
R1918 VSS.n464 VSS.n394 9.3005
R1919 VSS.n463 VSS.n395 9.3005
R1920 VSS.n398 VSS.n396 9.3005
R1921 VSS.n457 VSS.n399 9.3005
R1922 VSS.n456 VSS.n400 9.3005
R1923 VSS.n455 VSS.n401 9.3005
R1924 VSS.n404 VSS.n402 9.3005
R1925 VSS.n449 VSS.n405 9.3005
R1926 VSS.n448 VSS.n406 9.3005
R1927 VSS.n447 VSS.n407 9.3005
R1928 VSS.n410 VSS.n408 9.3005
R1929 VSS.n441 VSS.n411 9.3005
R1930 VSS.n440 VSS.n412 9.3005
R1931 VSS.n350 VSS.n349 9.3005
R1932 VSS.n576 VSS.n575 9.3005
R1933 VSS.n577 VSS.n572 9.3005
R1934 VSS.n579 VSS.n578 9.3005
R1935 VSS.n570 VSS.n569 9.3005
R1936 VSS.n586 VSS.n585 9.3005
R1937 VSS.n587 VSS.n568 9.3005
R1938 VSS.n589 VSS.n588 9.3005
R1939 VSS.n566 VSS.n565 9.3005
R1940 VSS.n596 VSS.n595 9.3005
R1941 VSS.n597 VSS.n564 9.3005
R1942 VSS.n599 VSS.n598 9.3005
R1943 VSS.n562 VSS.n561 9.3005
R1944 VSS.n606 VSS.n605 9.3005
R1945 VSS.n607 VSS.n560 9.3005
R1946 VSS.n609 VSS.n608 9.3005
R1947 VSS.n558 VSS.n557 9.3005
R1948 VSS.n616 VSS.n615 9.3005
R1949 VSS.n617 VSS.n556 9.3005
R1950 VSS.n619 VSS.n618 9.3005
R1951 VSS.n554 VSS.n553 9.3005
R1952 VSS.n626 VSS.n625 9.3005
R1953 VSS.n627 VSS.n552 9.3005
R1954 VSS.n629 VSS.n628 9.3005
R1955 VSS.n550 VSS.n549 9.3005
R1956 VSS.n636 VSS.n635 9.3005
R1957 VSS.n637 VSS.n548 9.3005
R1958 VSS.n639 VSS.n638 9.3005
R1959 VSS.n546 VSS.n545 9.3005
R1960 VSS.n646 VSS.n645 9.3005
R1961 VSS.n647 VSS.n544 9.3005
R1962 VSS.n650 VSS.n649 9.3005
R1963 VSS.n648 VSS.n542 9.3005
R1964 VSS.n539 VSS.n538 9.3005
R1965 VSS.n658 VSS.n657 9.3005
R1966 VSS.n659 VSS.n536 9.3005
R1967 VSS.n661 VSS.n660 9.3005
R1968 VSS.n673 VSS.n672 9.3005
R1969 VSS.n674 VSS.n348 9.3005
R1970 VSS.n676 VSS.n675 9.3005
R1971 VSS.n327 VSS.n326 9.3005
R1972 VSS.n690 VSS.n689 9.3005
R1973 VSS.n691 VSS.n325 9.3005
R1974 VSS.n693 VSS.n692 9.3005
R1975 VSS.n305 VSS.n304 9.3005
R1976 VSS.n707 VSS.n706 9.3005
R1977 VSS.n708 VSS.n302 9.3005
R1978 VSS.n711 VSS.n710 9.3005
R1979 VSS.n709 VSS.n303 9.3005
R1980 VSS.n278 VSS.n277 9.3005
R1981 VSS.n750 VSS.n749 9.3005
R1982 VSS.n751 VSS.n276 9.3005
R1983 VSS.n753 VSS.n752 9.3005
R1984 VSS.n260 VSS.n259 9.3005
R1985 VSS.n766 VSS.n765 9.3005
R1986 VSS.n767 VSS.n257 9.3005
R1987 VSS.n770 VSS.n769 9.3005
R1988 VSS.n768 VSS.n258 9.3005
R1989 VSS.n241 VSS.n240 9.3005
R1990 VSS.n798 VSS.n797 9.3005
R1991 VSS.n799 VSS.n239 9.3005
R1992 VSS.n801 VSS.n800 9.3005
R1993 VSS.n229 VSS.n228 9.3005
R1994 VSS.n812 VSS.n811 9.3005
R1995 VSS.n813 VSS.n226 9.3005
R1996 VSS.n816 VSS.n815 9.3005
R1997 VSS.n814 VSS.n227 9.3005
R1998 VSS.n212 VSS.n211 9.3005
R1999 VSS.n845 VSS.n844 9.3005
R2000 VSS.n846 VSS.n210 9.3005
R2001 VSS.n848 VSS.n847 9.3005
R2002 VSS.n201 VSS.n200 9.3005
R2003 VSS.n858 VSS.n857 9.3005
R2004 VSS.n859 VSS.n198 9.3005
R2005 VSS.n862 VSS.n861 9.3005
R2006 VSS.n860 VSS.n199 9.3005
R2007 VSS.n180 VSS.n179 9.3005
R2008 VSS.n881 VSS.n880 9.3005
R2009 VSS.n882 VSS.n177 9.3005
R2010 VSS.n885 VSS.n884 9.3005
R2011 VSS.n883 VSS.n178 9.3005
R2012 VSS.n162 VSS.n161 9.3005
R2013 VSS.n1017 VSS.n1016 9.3005
R2014 VSS.n1018 VSS.n159 9.3005
R2015 VSS.n1125 VSS.n1124 9.3005
R2016 VSS.n1123 VSS.n116 9.3005
R2017 VSS.n1122 VSS.n1121 9.3005
R2018 VSS.n119 VSS.n118 9.3005
R2019 VSS.n1067 VSS.n1066 9.3005
R2020 VSS.n1068 VSS.n1061 9.3005
R2021 VSS.n1070 VSS.n1069 9.3005
R2022 VSS.n1071 VSS.n1060 9.3005
R2023 VSS.n1073 VSS.n1072 9.3005
R2024 VSS.n1074 VSS.n1055 9.3005
R2025 VSS.n1076 VSS.n1075 9.3005
R2026 VSS.n1077 VSS.n1054 9.3005
R2027 VSS.n1079 VSS.n1078 9.3005
R2028 VSS.n1080 VSS.n1049 9.3005
R2029 VSS.n1082 VSS.n1081 9.3005
R2030 VSS.n1083 VSS.n1048 9.3005
R2031 VSS.n1085 VSS.n1084 9.3005
R2032 VSS.n1086 VSS.n1043 9.3005
R2033 VSS.n1088 VSS.n1087 9.3005
R2034 VSS.n1089 VSS.n1042 9.3005
R2035 VSS.n1091 VSS.n1090 9.3005
R2036 VSS.n1092 VSS.n1037 9.3005
R2037 VSS.n1094 VSS.n1093 9.3005
R2038 VSS.n1095 VSS.n1036 9.3005
R2039 VSS.n1097 VSS.n1096 9.3005
R2040 VSS.n1098 VSS.n1031 9.3005
R2041 VSS.n1100 VSS.n1099 9.3005
R2042 VSS.n1101 VSS.n1030 9.3005
R2043 VSS.n1103 VSS.n1102 9.3005
R2044 VSS.n1104 VSS.n1025 9.3005
R2045 VSS.n1106 VSS.n1105 9.3005
R2046 VSS.n1107 VSS.n1024 9.3005
R2047 VSS.n1109 VSS.n1108 9.3005
R2048 VSS.n1110 VSS.n1019 9.3005
R2049 VSS.n1112 VSS.n1111 9.3005
R2050 VSS.n1113 VSS.n160 9.3005
R2051 VSS.n1115 VSS.n1114 9.3005
R2052 VSS.n1003 VSS.n1002 9.3005
R2053 VSS.n1001 VSS.n895 9.3005
R2054 VSS.n1000 VSS.n999 9.3005
R2055 VSS.n996 VSS.n896 9.3005
R2056 VSS.n993 VSS.n992 9.3005
R2057 VSS.n991 VSS.n897 9.3005
R2058 VSS.n990 VSS.n989 9.3005
R2059 VSS.n986 VSS.n898 9.3005
R2060 VSS.n983 VSS.n982 9.3005
R2061 VSS.n981 VSS.n899 9.3005
R2062 VSS.n980 VSS.n979 9.3005
R2063 VSS.n976 VSS.n900 9.3005
R2064 VSS.n973 VSS.n972 9.3005
R2065 VSS.n971 VSS.n901 9.3005
R2066 VSS.n970 VSS.n969 9.3005
R2067 VSS.n966 VSS.n902 9.3005
R2068 VSS.n963 VSS.n962 9.3005
R2069 VSS.n961 VSS.n903 9.3005
R2070 VSS.n960 VSS.n959 9.3005
R2071 VSS.n956 VSS.n904 9.3005
R2072 VSS.n953 VSS.n952 9.3005
R2073 VSS.n951 VSS.n905 9.3005
R2074 VSS.n950 VSS.n949 9.3005
R2075 VSS.n946 VSS.n906 9.3005
R2076 VSS.n943 VSS.n942 9.3005
R2077 VSS.n941 VSS.n907 9.3005
R2078 VSS.n940 VSS.n939 9.3005
R2079 VSS.n936 VSS.n908 9.3005
R2080 VSS.n933 VSS.n932 9.3005
R2081 VSS.n931 VSS.n909 9.3005
R2082 VSS.n930 VSS.n929 9.3005
R2083 VSS.n926 VSS.n910 9.3005
R2084 VSS.n923 VSS.n922 9.3005
R2085 VSS.n921 VSS.n911 9.3005
R2086 VSS.n920 VSS.n919 9.3005
R2087 VSS.n916 VSS.n912 9.3005
R2088 VSS.n914 VSS.n913 9.3005
R2089 VSS.n668 VSS.n667 9.3005
R2090 VSS.n664 VSS.n359 9.3005
R2091 VSS.n663 VSS.n662 9.3005
R2092 VSS.n336 VSS.n334 9.3005
R2093 VSS.n685 VSS.n684 9.3005
R2094 VSS.n342 VSS.n335 9.3005
R2095 VSS.n340 VSS.n339 9.3005
R2096 VSS.n314 VSS.n312 9.3005
R2097 VSS.n702 VSS.n701 9.3005
R2098 VSS.n318 VSS.n313 9.3005
R2099 VSS.n294 VSS.n293 9.3005
R2100 VSS.n718 VSS.n717 9.3005
R2101 VSS.n719 VSS.n285 9.3005
R2102 VSS.n745 VSS.n286 9.3005
R2103 VSS.n744 VSS.n738 9.3005
R2104 VSS.n742 VSS.n741 9.3005
R2105 VSS.n270 VSS.n268 9.3005
R2106 VSS.n761 VSS.n760 9.3005
R2107 VSS.n269 VSS.n24 9.3005
R2108 VSS.n1171 VSS.n27 9.3005
R2109 VSS.n245 VSS.n28 9.3005
R2110 VSS.n1167 VSS.n34 9.3005
R2111 VSS.n1166 VSS.n35 9.3005
R2112 VSS.n1165 VSS.n38 9.3005
R2113 VSS.n235 VSS.n39 9.3005
R2114 VSS.n1161 VSS.n44 9.3005
R2115 VSS.n1160 VSS.n45 9.3005
R2116 VSS.n1159 VSS.n46 9.3005
R2117 VSS.n1156 VSS.n53 9.3005
R2118 VSS.n1155 VSS.n54 9.3005
R2119 VSS.n1154 VSS.n55 9.3005
R2120 VSS.n840 VSS.n56 9.3005
R2121 VSS.n1150 VSS.n64 9.3005
R2122 VSS.n1149 VSS.n65 9.3005
R2123 VSS.n1148 VSS.n66 9.3005
R2124 VSS.n853 VSS.n67 9.3005
R2125 VSS.n1144 VSS.n72 9.3005
R2126 VSS.n1142 VSS.n75 9.3005
R2127 VSS.n1141 VSS.n76 9.3005
R2128 VSS.n186 VSS.n77 9.3005
R2129 VSS.n1137 VSS.n82 9.3005
R2130 VSS.n1135 VSS.n85 9.3005
R2131 VSS.n1134 VSS.n86 9.3005
R2132 VSS.n166 VSS.n87 9.3005
R2133 VSS.n1130 VSS.n92 9.3005
R2134 VSS.n1129 VSS.n93 9.3005
R2135 VSS.n1127 VSS.n114 9.3005
R2136 VSS.n1127 VSS.n1126 9.3005
R2137 VSS.n1129 VSS.n91 9.3005
R2138 VSS.n1131 VSS.n1130 9.3005
R2139 VSS.n1132 VSS.n87 9.3005
R2140 VSS.n1134 VSS.n1133 9.3005
R2141 VSS.n1135 VSS.n81 9.3005
R2142 VSS.n1138 VSS.n1137 9.3005
R2143 VSS.n1139 VSS.n77 9.3005
R2144 VSS.n1141 VSS.n1140 9.3005
R2145 VSS.n1142 VSS.n71 9.3005
R2146 VSS.n1145 VSS.n1144 9.3005
R2147 VSS.n1146 VSS.n67 9.3005
R2148 VSS.n1148 VSS.n1147 9.3005
R2149 VSS.n1149 VSS.n60 9.3005
R2150 VSS.n1151 VSS.n1150 9.3005
R2151 VSS.n1152 VSS.n56 9.3005
R2152 VSS.n1154 VSS.n1153 9.3005
R2153 VSS.n1155 VSS.n52 9.3005
R2154 VSS.n1157 VSS.n1156 9.3005
R2155 VSS.n1159 VSS.n1158 9.3005
R2156 VSS.n1160 VSS.n43 9.3005
R2157 VSS.n1162 VSS.n1161 9.3005
R2158 VSS.n1163 VSS.n39 9.3005
R2159 VSS.n1165 VSS.n1164 9.3005
R2160 VSS.n1166 VSS.n33 9.3005
R2161 VSS.n1168 VSS.n1167 9.3005
R2162 VSS.n1169 VSS.n28 9.3005
R2163 VSS.n1171 VSS.n1170 9.3005
R2164 VSS.n29 VSS.n24 9.3005
R2165 VSS.n760 VSS.n759 9.3005
R2166 VSS.n758 VSS.n270 9.3005
R2167 VSS.n742 VSS.n271 9.3005
R2168 VSS.n744 VSS.n284 9.3005
R2169 VSS.n746 VSS.n745 9.3005
R2170 VSS.n285 VSS.n283 9.3005
R2171 VSS.n717 VSS.n716 9.3005
R2172 VSS.n295 VSS.n294 9.3005
R2173 VSS.n699 VSS.n318 9.3005
R2174 VSS.n701 VSS.n700 9.3005
R2175 VSS.n698 VSS.n314 9.3005
R2176 VSS.n340 VSS.n319 9.3005
R2177 VSS.n682 VSS.n342 9.3005
R2178 VSS.n684 VSS.n683 9.3005
R2179 VSS.n681 VSS.n336 9.3005
R2180 VSS.n663 VSS.n343 9.3005
R2181 VSS.n665 VSS.n664 9.3005
R2182 VSS.n667 VSS.n666 9.3005
R2183 VSS.n533 VSS.n526 9.2683
R2184 VSS.n523 VSS.n516 9.2683
R2185 VSS.n112 VSS.n105 9.2683
R2186 VSS.n102 VSS.n95 9.2683
R2187 VSS.t29 VSS.t74 8.66192
R2188 VSS.t7 VSS.t71 8.66192
R2189 VSS.n196 VSS.t70 8.66192
R2190 VSS.n695 VSS.t35 8.31546
R2191 VSS.n255 VSS.t23 8.31546
R2192 VSS.n809 VSS.t17 8.31546
R2193 VSS.n878 VSS.t5 8.31546
R2194 VSS.n842 VSS.t61 6.58318
R2195 VSS.n529 VSS.n528 6.31057
R2196 VSS.n108 VSS.n107 6.31057
R2197 VSS.n519 VSS.n518 6.31055
R2198 VSS.n98 VSS.n97 6.31055
R2199 VSS.n37 VSS.t51 6.0005
R2200 VSS.n37 VSS.t50 6.0005
R2201 VSS.n36 VSS.t22 6.0005
R2202 VSS.n36 VSS.t20 6.0005
R2203 VSS.n338 VSS.t59 6.0005
R2204 VSS.n338 VSS.t58 6.0005
R2205 VSS.n337 VSS.t38 6.0005
R2206 VSS.n337 VSS.t36 6.0005
R2207 VSS.n316 VSS.t57 6.0005
R2208 VSS.n316 VSS.t56 6.0005
R2209 VSS.n315 VSS.t34 6.0005
R2210 VSS.n315 VSS.t32 6.0005
R2211 VSS.n740 VSS.t55 6.0005
R2212 VSS.n740 VSS.t54 6.0005
R2213 VSS.n739 VSS.t30 6.0005
R2214 VSS.n739 VSS.t28 6.0005
R2215 VSS.n26 VSS.t53 6.0005
R2216 VSS.n26 VSS.t52 6.0005
R2217 VSS.n25 VSS.t26 6.0005
R2218 VSS.n25 VSS.t24 6.0005
R2219 VSS.n48 VSS.t49 6.0005
R2220 VSS.n48 VSS.t48 6.0005
R2221 VSS.n47 VSS.t18 6.0005
R2222 VSS.n47 VSS.t16 6.0005
R2223 VSS.n62 VSS.t47 6.0005
R2224 VSS.n62 VSS.t46 6.0005
R2225 VSS.n61 VSS.t14 6.0005
R2226 VSS.n61 VSS.t12 6.0005
R2227 VSS.n74 VSS.t45 6.0005
R2228 VSS.n74 VSS.t44 6.0005
R2229 VSS.n73 VSS.t10 6.0005
R2230 VSS.n73 VSS.t8 6.0005
R2231 VSS.n84 VSS.t43 6.0005
R2232 VSS.n84 VSS.t42 6.0005
R2233 VSS.n83 VSS.t6 6.0005
R2234 VSS.n83 VSS.t4 6.0005
R2235 VSS.t63 VSS.n217 5.89026
R2236 VSS.n755 VSS.t27 5.54381
R2237 VSS.n842 VSS.t13 5.54381
R2238 VSS.n855 VSS.t9 5.54381
R2239 VSS.t66 VSS.t21 5.19735
R2240 VSS.t15 VSS.t63 5.19735
R2241 VSS.n772 VSS.t68 4.50444
R2242 VSS.t76 VSS.n291 3.81152
R2243 VSS.t72 VSS.n192 3.81152
R2244 VSS.n1220 VSS.n1219 3.48626
R2245 VSS.n1176 VSS.n1175 3.4105
R2246 VSS.n21 VSS.n20 3.4105
R2247 VSS.n1181 VSS.n1180 3.4105
R2248 VSS.n1182 VSS.n19 3.4105
R2249 VSS.n1184 VSS.n1183 3.4105
R2250 VSS.n17 VSS.n16 3.4105
R2251 VSS.n1189 VSS.n1188 3.4105
R2252 VSS.n1190 VSS.n15 3.4105
R2253 VSS.n1192 VSS.n1191 3.4105
R2254 VSS.n13 VSS.n12 3.4105
R2255 VSS.n1197 VSS.n1196 3.4105
R2256 VSS.n1198 VSS.n11 3.4105
R2257 VSS.n1200 VSS.n1199 3.4105
R2258 VSS.n9 VSS.n8 3.4105
R2259 VSS.n1205 VSS.n1204 3.4105
R2260 VSS.n1206 VSS.n7 3.4105
R2261 VSS.n1208 VSS.n1207 3.4105
R2262 VSS.n5 VSS.n4 3.4105
R2263 VSS.n1214 VSS.n1213 3.4105
R2264 VSS.n1215 VSS.n3 3.4105
R2265 VSS.n1217 VSS.n1216 3.4105
R2266 VSS.n1177 VSS.n1176 3.4105
R2267 VSS.n1178 VSS.n21 3.4105
R2268 VSS.n1180 VSS.n1179 3.4105
R2269 VSS.n19 VSS.n18 3.4105
R2270 VSS.n1185 VSS.n1184 3.4105
R2271 VSS.n1186 VSS.n17 3.4105
R2272 VSS.n1188 VSS.n1187 3.4105
R2273 VSS.n15 VSS.n14 3.4105
R2274 VSS.n1193 VSS.n1192 3.4105
R2275 VSS.n1194 VSS.n13 3.4105
R2276 VSS.n1196 VSS.n1195 3.4105
R2277 VSS.n11 VSS.n10 3.4105
R2278 VSS.n1201 VSS.n1200 3.4105
R2279 VSS.n1202 VSS.n9 3.4105
R2280 VSS.n1204 VSS.n1203 3.4105
R2281 VSS.n7 VSS.n6 3.4105
R2282 VSS.n1209 VSS.n1208 3.4105
R2283 VSS.n1210 VSS.n5 3.4105
R2284 VSS.n1213 VSS.n1212 3.4105
R2285 VSS.n1211 VSS.n3 3.4105
R2286 VSS.n1217 VSS.n2 3.4105
R2287 VSS.n1219 VSS.n1218 3.4105
R2288 VSS.n1221 VSS.n1220 2.85775
R2289 VSS.n678 VSS.t39 2.77215
R2290 VSS.n687 VSS.t37 2.77215
R2291 VSS.n795 VSS.t21 2.77215
R2292 VSS.n803 VSS.t19 2.77215
R2293 VSS.n887 VSS.t3 2.77215
R2294 VSS.n1010 VSS.t1 2.77215
R2295 VSS.n721 VSS.t75 2.4257
R2296 VSS.n864 VSS.t71 2.4257
R2297 VSS.n1216 VSS.n1 1.79814
R2298 VSS.t31 VSS.t76 1.73278
R2299 VSS.t65 VSS.n236 1.73278
R2300 VSS.t69 VSS.t5 1.73278
R2301 VSS.n520 VSS.n519 1.16652
R2302 VSS.n99 VSS.n98 1.16652
R2303 VSS.n530 VSS.n529 1.1665
R2304 VSS.n109 VSS.n108 1.1665
R2305 VSS.n1174 VSS.n23 0.477192
R2306 VSS.n23 VSS.n22 0.476221
R2307 VSS.n838 VSS.t62 0.346957
R2308 VSS.n535 VSS.n524 0.296333
R2309 VSS.n535 VSS.n534 0.296333
R2310 VSS.n1128 VSS.n103 0.296333
R2311 VSS.n1128 VSS.n113 0.296333
R2312 VSS.n413 VSS.n412 0.291125
R2313 VSS.n1002 VSS.n894 0.291125
R2314 VSS.n673 VSS.n349 0.291125
R2315 VSS.n1114 VSS.n1018 0.291125
R2316 VSS.n1221 VSS 0.270841
R2317 VSS.n520 VSS.n515 0.1505
R2318 VSS.n524 VSS.n515 0.1505
R2319 VSS.n534 VSS.n525 0.1505
R2320 VSS.n530 VSS.n525 0.1505
R2321 VSS.n99 VSS.n94 0.1505
R2322 VSS.n103 VSS.n94 0.1505
R2323 VSS.n113 VSS.n104 0.1505
R2324 VSS.n109 VSS.n104 0.1505
R2325 VSS.n1222 VSS.n1221 0.140339
R2326 VSS.n514 VSS.n513 0.128625
R2327 VSS.n660 VSS.n514 0.128625
R2328 VSS.n1124 VSS.n0 0.128625
R2329 VSS.n913 VSS.n0 0.128625
R2330 VSS.n513 VSS.n512 0.113
R2331 VSS.n512 VSS.n360 0.113
R2332 VSS.n363 VSS.n360 0.113
R2333 VSS.n364 VSS.n363 0.113
R2334 VSS.n365 VSS.n364 0.113
R2335 VSS.n368 VSS.n365 0.113
R2336 VSS.n369 VSS.n368 0.113
R2337 VSS.n370 VSS.n369 0.113
R2338 VSS.n371 VSS.n370 0.113
R2339 VSS.n374 VSS.n371 0.113
R2340 VSS.n375 VSS.n374 0.113
R2341 VSS.n376 VSS.n375 0.113
R2342 VSS.n377 VSS.n376 0.113
R2343 VSS.n380 VSS.n377 0.113
R2344 VSS.n381 VSS.n380 0.113
R2345 VSS.n382 VSS.n381 0.113
R2346 VSS.n383 VSS.n382 0.113
R2347 VSS.n386 VSS.n383 0.113
R2348 VSS.n387 VSS.n386 0.113
R2349 VSS.n388 VSS.n387 0.113
R2350 VSS.n389 VSS.n388 0.113
R2351 VSS.n392 VSS.n389 0.113
R2352 VSS.n393 VSS.n392 0.113
R2353 VSS.n394 VSS.n393 0.113
R2354 VSS.n395 VSS.n394 0.113
R2355 VSS.n398 VSS.n395 0.113
R2356 VSS.n399 VSS.n398 0.113
R2357 VSS.n400 VSS.n399 0.113
R2358 VSS.n401 VSS.n400 0.113
R2359 VSS.n404 VSS.n401 0.113
R2360 VSS.n405 VSS.n404 0.113
R2361 VSS.n406 VSS.n405 0.113
R2362 VSS.n407 VSS.n406 0.113
R2363 VSS.n410 VSS.n407 0.113
R2364 VSS.n411 VSS.n410 0.113
R2365 VSS.n412 VSS.n411 0.113
R2366 VSS.n414 VSS.n413 0.113
R2367 VSS.n415 VSS.n414 0.113
R2368 VSS.n416 VSS.n415 0.113
R2369 VSS.n417 VSS.n416 0.113
R2370 VSS.n418 VSS.n417 0.113
R2371 VSS.n419 VSS.n418 0.113
R2372 VSS.n420 VSS.n419 0.113
R2373 VSS.n421 VSS.n420 0.113
R2374 VSS.n422 VSS.n421 0.113
R2375 VSS.n423 VSS.n422 0.113
R2376 VSS.n423 VSS.n288 0.113
R2377 VSS.n724 VSS.n288 0.113
R2378 VSS.n725 VSS.n724 0.113
R2379 VSS.n726 VSS.n725 0.113
R2380 VSS.n727 VSS.n726 0.113
R2381 VSS.n728 VSS.n727 0.113
R2382 VSS.n729 VSS.n728 0.113
R2383 VSS.n729 VSS.n249 0.113
R2384 VSS.n775 VSS.n249 0.113
R2385 VSS.n776 VSS.n775 0.113
R2386 VSS.n777 VSS.n776 0.113
R2387 VSS.n778 VSS.n777 0.113
R2388 VSS.n779 VSS.n778 0.113
R2389 VSS.n780 VSS.n779 0.113
R2390 VSS.n781 VSS.n780 0.113
R2391 VSS.n782 VSS.n781 0.113
R2392 VSS.n782 VSS.n220 0.113
R2393 VSS.n821 VSS.n220 0.113
R2394 VSS.n822 VSS.n821 0.113
R2395 VSS.n823 VSS.n822 0.113
R2396 VSS.n824 VSS.n823 0.113
R2397 VSS.n825 VSS.n824 0.113
R2398 VSS.n826 VSS.n825 0.113
R2399 VSS.n827 VSS.n826 0.113
R2400 VSS.n828 VSS.n827 0.113
R2401 VSS.n828 VSS.n189 0.113
R2402 VSS.n867 VSS.n189 0.113
R2403 VSS.n868 VSS.n867 0.113
R2404 VSS.n869 VSS.n868 0.113
R2405 VSS.n870 VSS.n869 0.113
R2406 VSS.n870 VSS.n171 0.113
R2407 VSS.n890 VSS.n171 0.113
R2408 VSS.n891 VSS.n890 0.113
R2409 VSS.n892 VSS.n891 0.113
R2410 VSS.n893 VSS.n892 0.113
R2411 VSS.n894 VSS.n893 0.113
R2412 VSS.n576 VSS.n349 0.113
R2413 VSS.n577 VSS.n576 0.113
R2414 VSS.n578 VSS.n577 0.113
R2415 VSS.n578 VSS.n569 0.113
R2416 VSS.n586 VSS.n569 0.113
R2417 VSS.n587 VSS.n586 0.113
R2418 VSS.n588 VSS.n587 0.113
R2419 VSS.n588 VSS.n565 0.113
R2420 VSS.n596 VSS.n565 0.113
R2421 VSS.n597 VSS.n596 0.113
R2422 VSS.n598 VSS.n597 0.113
R2423 VSS.n598 VSS.n561 0.113
R2424 VSS.n606 VSS.n561 0.113
R2425 VSS.n607 VSS.n606 0.113
R2426 VSS.n608 VSS.n607 0.113
R2427 VSS.n608 VSS.n557 0.113
R2428 VSS.n616 VSS.n557 0.113
R2429 VSS.n617 VSS.n616 0.113
R2430 VSS.n618 VSS.n617 0.113
R2431 VSS.n618 VSS.n553 0.113
R2432 VSS.n626 VSS.n553 0.113
R2433 VSS.n627 VSS.n626 0.113
R2434 VSS.n628 VSS.n627 0.113
R2435 VSS.n628 VSS.n549 0.113
R2436 VSS.n636 VSS.n549 0.113
R2437 VSS.n637 VSS.n636 0.113
R2438 VSS.n638 VSS.n637 0.113
R2439 VSS.n638 VSS.n545 0.113
R2440 VSS.n646 VSS.n545 0.113
R2441 VSS.n647 VSS.n646 0.113
R2442 VSS.n649 VSS.n647 0.113
R2443 VSS.n649 VSS.n648 0.113
R2444 VSS.n648 VSS.n538 0.113
R2445 VSS.n658 VSS.n538 0.113
R2446 VSS.n659 VSS.n658 0.113
R2447 VSS.n660 VSS.n659 0.113
R2448 VSS.n674 VSS.n673 0.113
R2449 VSS.n675 VSS.n674 0.113
R2450 VSS.n675 VSS.n326 0.113
R2451 VSS.n690 VSS.n326 0.113
R2452 VSS.n691 VSS.n690 0.113
R2453 VSS.n692 VSS.n691 0.113
R2454 VSS.n692 VSS.n304 0.113
R2455 VSS.n707 VSS.n304 0.113
R2456 VSS.n708 VSS.n707 0.113
R2457 VSS.n710 VSS.n708 0.113
R2458 VSS.n710 VSS.n709 0.113
R2459 VSS.n709 VSS.n277 0.113
R2460 VSS.n750 VSS.n277 0.113
R2461 VSS.n751 VSS.n750 0.113
R2462 VSS.n752 VSS.n751 0.113
R2463 VSS.n752 VSS.n259 0.113
R2464 VSS.n766 VSS.n259 0.113
R2465 VSS.n767 VSS.n766 0.113
R2466 VSS.n769 VSS.n767 0.113
R2467 VSS.n769 VSS.n768 0.113
R2468 VSS.n768 VSS.n240 0.113
R2469 VSS.n798 VSS.n240 0.113
R2470 VSS.n799 VSS.n798 0.113
R2471 VSS.n800 VSS.n799 0.113
R2472 VSS.n800 VSS.n228 0.113
R2473 VSS.n812 VSS.n228 0.113
R2474 VSS.n813 VSS.n812 0.113
R2475 VSS.n815 VSS.n813 0.113
R2476 VSS.n815 VSS.n814 0.113
R2477 VSS.n814 VSS.n211 0.113
R2478 VSS.n845 VSS.n211 0.113
R2479 VSS.n846 VSS.n845 0.113
R2480 VSS.n847 VSS.n846 0.113
R2481 VSS.n847 VSS.n200 0.113
R2482 VSS.n858 VSS.n200 0.113
R2483 VSS.n859 VSS.n858 0.113
R2484 VSS.n861 VSS.n859 0.113
R2485 VSS.n861 VSS.n860 0.113
R2486 VSS.n860 VSS.n179 0.113
R2487 VSS.n881 VSS.n179 0.113
R2488 VSS.n882 VSS.n881 0.113
R2489 VSS.n884 VSS.n882 0.113
R2490 VSS.n884 VSS.n883 0.113
R2491 VSS.n883 VSS.n161 0.113
R2492 VSS.n1017 VSS.n161 0.113
R2493 VSS.n1018 VSS.n1017 0.113
R2494 VSS.n1114 VSS.n1113 0.113
R2495 VSS.n1113 VSS.n1112 0.113
R2496 VSS.n1112 VSS.n1019 0.113
R2497 VSS.n1108 VSS.n1019 0.113
R2498 VSS.n1108 VSS.n1107 0.113
R2499 VSS.n1107 VSS.n1106 0.113
R2500 VSS.n1106 VSS.n1025 0.113
R2501 VSS.n1102 VSS.n1025 0.113
R2502 VSS.n1102 VSS.n1101 0.113
R2503 VSS.n1101 VSS.n1100 0.113
R2504 VSS.n1100 VSS.n1031 0.113
R2505 VSS.n1096 VSS.n1031 0.113
R2506 VSS.n1096 VSS.n1095 0.113
R2507 VSS.n1095 VSS.n1094 0.113
R2508 VSS.n1094 VSS.n1037 0.113
R2509 VSS.n1090 VSS.n1037 0.113
R2510 VSS.n1090 VSS.n1089 0.113
R2511 VSS.n1089 VSS.n1088 0.113
R2512 VSS.n1088 VSS.n1043 0.113
R2513 VSS.n1084 VSS.n1043 0.113
R2514 VSS.n1084 VSS.n1083 0.113
R2515 VSS.n1083 VSS.n1082 0.113
R2516 VSS.n1082 VSS.n1049 0.113
R2517 VSS.n1078 VSS.n1049 0.113
R2518 VSS.n1078 VSS.n1077 0.113
R2519 VSS.n1077 VSS.n1076 0.113
R2520 VSS.n1076 VSS.n1055 0.113
R2521 VSS.n1072 VSS.n1055 0.113
R2522 VSS.n1072 VSS.n1071 0.113
R2523 VSS.n1071 VSS.n1070 0.113
R2524 VSS.n1070 VSS.n1061 0.113
R2525 VSS.n1066 VSS.n1061 0.113
R2526 VSS.n1066 VSS.n118 0.113
R2527 VSS.n1122 VSS.n118 0.113
R2528 VSS.n1123 VSS.n1122 0.113
R2529 VSS.n1124 VSS.n1123 0.113
R2530 VSS.n913 VSS.n912 0.113
R2531 VSS.n920 VSS.n912 0.113
R2532 VSS.n921 VSS.n920 0.113
R2533 VSS.n922 VSS.n921 0.113
R2534 VSS.n922 VSS.n910 0.113
R2535 VSS.n930 VSS.n910 0.113
R2536 VSS.n931 VSS.n930 0.113
R2537 VSS.n932 VSS.n931 0.113
R2538 VSS.n932 VSS.n908 0.113
R2539 VSS.n940 VSS.n908 0.113
R2540 VSS.n941 VSS.n940 0.113
R2541 VSS.n942 VSS.n941 0.113
R2542 VSS.n942 VSS.n906 0.113
R2543 VSS.n950 VSS.n906 0.113
R2544 VSS.n951 VSS.n950 0.113
R2545 VSS.n952 VSS.n951 0.113
R2546 VSS.n952 VSS.n904 0.113
R2547 VSS.n960 VSS.n904 0.113
R2548 VSS.n961 VSS.n960 0.113
R2549 VSS.n962 VSS.n961 0.113
R2550 VSS.n962 VSS.n902 0.113
R2551 VSS.n970 VSS.n902 0.113
R2552 VSS.n971 VSS.n970 0.113
R2553 VSS.n972 VSS.n971 0.113
R2554 VSS.n972 VSS.n900 0.113
R2555 VSS.n980 VSS.n900 0.113
R2556 VSS.n981 VSS.n980 0.113
R2557 VSS.n982 VSS.n981 0.113
R2558 VSS.n982 VSS.n898 0.113
R2559 VSS.n990 VSS.n898 0.113
R2560 VSS.n991 VSS.n990 0.113
R2561 VSS.n992 VSS.n991 0.113
R2562 VSS.n992 VSS.n896 0.113
R2563 VSS.n1000 VSS.n896 0.113
R2564 VSS.n1001 VSS.n1000 0.113
R2565 VSS.n1002 VSS.n1001 0.113
R2566 VSS.n1175 VSS.n1174 0.0762576
R2567 VSS.n1175 VSS.n20 0.0762576
R2568 VSS.n1181 VSS.n20 0.0762576
R2569 VSS.n1182 VSS.n1181 0.0762576
R2570 VSS.n1183 VSS.n1182 0.0762576
R2571 VSS.n1183 VSS.n16 0.0762576
R2572 VSS.n1189 VSS.n16 0.0762576
R2573 VSS.n1190 VSS.n1189 0.0762576
R2574 VSS.n1191 VSS.n1190 0.0762576
R2575 VSS.n1191 VSS.n12 0.0762576
R2576 VSS.n1197 VSS.n12 0.0762576
R2577 VSS.n1198 VSS.n1197 0.0762576
R2578 VSS.n1199 VSS.n1198 0.0762576
R2579 VSS.n1199 VSS.n8 0.0762576
R2580 VSS.n1205 VSS.n8 0.0762576
R2581 VSS.n1206 VSS.n1205 0.0762576
R2582 VSS.n1207 VSS.n1206 0.0762576
R2583 VSS.n1207 VSS.n4 0.0762576
R2584 VSS.n1214 VSS.n4 0.0762576
R2585 VSS.n1215 VSS.n1214 0.0762576
R2586 VSS.n1216 VSS.n1215 0.0762576
R2587 VSS.n1177 VSS.n22 0.0762576
R2588 VSS.n1178 VSS.n1177 0.0762576
R2589 VSS.n1179 VSS.n1178 0.0762576
R2590 VSS.n1179 VSS.n18 0.0762576
R2591 VSS.n1185 VSS.n18 0.0762576
R2592 VSS.n1186 VSS.n1185 0.0762576
R2593 VSS.n1187 VSS.n1186 0.0762576
R2594 VSS.n1187 VSS.n14 0.0762576
R2595 VSS.n1193 VSS.n14 0.0762576
R2596 VSS.n1194 VSS.n1193 0.0762576
R2597 VSS.n1195 VSS.n1194 0.0762576
R2598 VSS.n1195 VSS.n10 0.0762576
R2599 VSS.n1201 VSS.n10 0.0762576
R2600 VSS.n1202 VSS.n1201 0.0762576
R2601 VSS.n1203 VSS.n1202 0.0762576
R2602 VSS.n1203 VSS.n6 0.0762576
R2603 VSS.n1209 VSS.n6 0.0762576
R2604 VSS.n1210 VSS.n1209 0.0762576
R2605 VSS.n1212 VSS.n1210 0.0762576
R2606 VSS.n1212 VSS.n1211 0.0762576
R2607 VSS.n1211 VSS.n2 0.0762576
R2608 VSS.n1219 VSS.n2 0.0762576
R2609 VSS.n1173 VSS.n22 0.0386356
R2610 VSS.n1174 VSS.n1173 0.0386356
R2611 VSS.n1176 VSS.n23 0.0381135
R2612 VSS.n667 VSS.n514 0.0237143
R2613 VSS.n1127 VSS.n0 0.0237143
R2614 VSS.n664 VSS.n663 0.0165714
R2615 VSS.n663 VSS.n336 0.0165714
R2616 VSS.n684 VSS.n336 0.0165714
R2617 VSS.n684 VSS.n342 0.0165714
R2618 VSS.n340 VSS.n314 0.0165714
R2619 VSS.n701 VSS.n314 0.0165714
R2620 VSS.n701 VSS.n318 0.0165714
R2621 VSS.n717 VSS.n294 0.0165714
R2622 VSS.n717 VSS.n285 0.0165714
R2623 VSS.n745 VSS.n285 0.0165714
R2624 VSS.n745 VSS.n744 0.0165714
R2625 VSS.n742 VSS.n270 0.0165714
R2626 VSS.n760 VSS.n270 0.0165714
R2627 VSS.n760 VSS.n24 0.0165714
R2628 VSS.n1171 VSS.n28 0.0165714
R2629 VSS.n1167 VSS.n28 0.0165714
R2630 VSS.n1167 VSS.n1166 0.0165714
R2631 VSS.n1166 VSS.n1165 0.0165714
R2632 VSS.n1165 VSS.n39 0.0165714
R2633 VSS.n1161 VSS.n39 0.0165714
R2634 VSS.n1161 VSS.n1160 0.0165714
R2635 VSS.n1160 VSS.n1159 0.0165714
R2636 VSS.n1156 VSS.n1155 0.0165714
R2637 VSS.n1155 VSS.n1154 0.0165714
R2638 VSS.n1154 VSS.n56 0.0165714
R2639 VSS.n1150 VSS.n1149 0.0165714
R2640 VSS.n1149 VSS.n1148 0.0165714
R2641 VSS.n1148 VSS.n67 0.0165714
R2642 VSS.n1144 VSS.n67 0.0165714
R2643 VSS.n1142 VSS.n1141 0.0165714
R2644 VSS.n1141 VSS.n77 0.0165714
R2645 VSS.n1137 VSS.n77 0.0165714
R2646 VSS.n1135 VSS.n1134 0.0165714
R2647 VSS.n1134 VSS.n87 0.0165714
R2648 VSS.n1130 VSS.n87 0.0165714
R2649 VSS.n1130 VSS.n1129 0.0165714
R2650 VSS.n743 VSS.n742 0.0147857
R2651 VSS.n63 VSS.n56 0.0147857
R2652 VSS VSS.n1222 0.0138929
R2653 VSS.n667 VSS.n535 0.013
R2654 VSS.n341 VSS.n340 0.013
R2655 VSS.n1137 VSS.n1136 0.013
R2656 VSS.n1128 VSS.n1127 0.013
R2657 VSS.n318 VSS.n317 0.0112143
R2658 VSS.n1143 VSS.n1142 0.0112143
R2659 VSS.n1176 VSS.n21 0.0099
R2660 VSS.n1180 VSS.n21 0.0099
R2661 VSS.n1180 VSS.n19 0.0099
R2662 VSS.n1184 VSS.n19 0.0099
R2663 VSS.n1184 VSS.n17 0.0099
R2664 VSS.n1188 VSS.n17 0.0099
R2665 VSS.n1188 VSS.n15 0.0099
R2666 VSS.n1192 VSS.n15 0.0099
R2667 VSS.n1192 VSS.n13 0.0099
R2668 VSS.n1196 VSS.n13 0.0099
R2669 VSS.n1196 VSS.n11 0.0099
R2670 VSS.n1200 VSS.n11 0.0099
R2671 VSS.n1200 VSS.n9 0.0099
R2672 VSS.n1204 VSS.n9 0.0099
R2673 VSS.n1204 VSS.n7 0.0099
R2674 VSS.n1208 VSS.n7 0.0099
R2675 VSS.n1208 VSS.n5 0.0099
R2676 VSS.n1213 VSS.n5 0.0099
R2677 VSS.n1213 VSS.n3 0.0099
R2678 VSS.n1217 VSS.n3 0.0099
R2679 VSS.n1218 VSS.n1217 0.0099
R2680 VSS.n1156 VSS.n49 0.00942857
R2681 VSS.n1222 VSS.n0 0.00942857
R2682 VSS.n1173 VSS.n24 0.0083125
R2683 VSS.n1172 VSS.n1171 0.00764286
R2684 VSS.n1159 VSS.n49 0.00764286
R2685 VSS.n317 VSS.n294 0.00585714
R2686 VSS.n1144 VSS.n1143 0.00585714
R2687 VSS.n1220 VSS.n1 0.00574517
R2688 VSS.n1218 VSS.n1 0.00564204
R2689 VSS.n664 VSS.n535 0.00407143
R2690 VSS.n342 VSS.n341 0.00407143
R2691 VSS.n1136 VSS.n1135 0.00407143
R2692 VSS.n1129 VSS.n1128 0.00407143
R2693 VSS.n744 VSS.n743 0.00228571
R2694 VSS.n1150 VSS.n63 0.00228571
R2695 VSS.n1173 VSS.n1172 0.00161607
C0 tail VDD 0.01113f
C1 inn outn 0.20956f
C2 outp VDD 7.29059f
C3 inp VDD 0.18552f
C4 nb VDD 0.07534f
C5 inn tail 1.36166f
C6 tail outn 14.6749f
C7 outp inn 1.32777f
C8 inp inn 4.56531f
C9 outp outn 2.07011f
C10 inp outn 1.37804f
C11 nb inn 0.29329f
C12 nb outn 0.35687f
C13 outp tail 14.6004f
C14 inp tail 1.74265f
C15 outp inp 0.23155f
C16 nb tail 8.73187f
C17 outp nb 0.24858f
C18 nb inp 0.36393f
C19 inn VDD 2.75548f
C20 VDD outn 7.77538f
C21 nb VSS 26.11019f
C22 outp VSS 7.61333f
C23 outn VSS 7.95398f
C24 VDD VSS 22.70611f
C25 inn VSS 5.25374f
C26 inp VSS 5.72791f
C27 tail VSS 18.1133f
C28 inp.t12 VSS 0.1155f
C29 inp.t13 VSS 0.10638f
C30 inp.n0 VSS 0.23759f
C31 inp.t15 VSS 0.10638f
C32 inp.t14 VSS 0.1155f
C33 inp.n1 VSS 0.23842f
C34 inp.n2 VSS 0.04355f
C35 inp.t8 VSS 0.1155f
C36 inp.t9 VSS 0.10638f
C37 inp.n3 VSS 0.23759f
C38 inp.t11 VSS 0.10638f
C39 inp.t10 VSS 0.1155f
C40 inp.n4 VSS 0.23842f
C41 inp.n5 VSS 0.2978f
C42 inp.n6 VSS 0.86441f
C43 inp.t0 VSS 0.1155f
C44 inp.t1 VSS 0.10638f
C45 inp.n7 VSS 0.25618f
C46 inp.t2 VSS 0.1155f
C47 inp.n8 VSS 0.13658f
C48 inp.t3 VSS 0.10638f
C49 inp.n9 VSS 0.15803f
C50 inp.t7 VSS 0.10638f
C51 inp.t6 VSS 0.1155f
C52 inp.n10 VSS 0.25701f
C53 inp.t5 VSS 0.10638f
C54 inp.n11 VSS 0.12705f
C55 inp.t4 VSS 0.1155f
C56 inp.n12 VSS 0.16757f
C57 inp.n13 VSS 1.81944f
C58 inp.n14 VSS 1.5168f
C59 inn.t4 VSS 0.14342f
C60 inn.t5 VSS 0.13208f
C61 inn.n0 VSS 0.29501f
C62 inn.t7 VSS 0.13209f
C63 inn.t6 VSS 0.14341f
C64 inn.n1 VSS 0.29603f
C65 inn.n2 VSS 0.05407f
C66 inn.t0 VSS 0.14342f
C67 inn.t1 VSS 0.13208f
C68 inn.n3 VSS 0.29501f
C69 inn.t3 VSS 0.13209f
C70 inn.t2 VSS 0.14341f
C71 inn.n4 VSS 0.29603f
C72 inn.n5 VSS 0.36982f
C73 inn.n6 VSS 1.11185f
C74 inn.t8 VSS 0.14342f
C75 inn.t9 VSS 0.13208f
C76 inn.n7 VSS 0.31809f
C77 inn.t10 VSS 0.14341f
C78 inn.n8 VSS 0.16959f
C79 inn.t11 VSS 0.13208f
C80 inn.n9 VSS 0.19622f
C81 inn.t15 VSS 0.13209f
C82 inn.t14 VSS 0.14341f
C83 inn.n10 VSS 0.31912f
C84 inn.t13 VSS 0.13208f
C85 inn.n11 VSS 0.15775f
C86 inn.t12 VSS 0.14341f
C87 inn.n12 VSS 0.20806f
C88 inn.n13 VSS 2.2556f
C89 inn.n14 VSS 1.88684f
C90 VDD.t0 VSS 1.1356f
C91 VDD.t1 VSS 1.1356f
C92 VDD.n0 VSS 7.42476f
C93 VDD.n1 VSS 7.42497f
C94 outn.n0 VSS 0.16064f
C95 outn.n1 VSS 0.16064f
C96 outn.n2 VSS 0.16064f
C97 outn.n3 VSS 0.16064f
C98 outn.n4 VSS 0.02183f
C99 outn.t0 VSS 0.12828f
C100 outn.t12 VSS 0.12828f
C101 outn.n5 VSS 0.27181f
C102 outn.n6 VSS 0.03351f
C103 outn.n7 VSS 0.02904f
C104 outn.n8 VSS 0.01655f
C105 outn.n9 VSS 0.36937f
C106 outn.n10 VSS 0.11f
C107 outn.n11 VSS 0.02183f
C108 outn.t6 VSS 0.12828f
C109 outn.t1 VSS 0.12828f
C110 outn.n12 VSS 0.27181f
C111 outn.n13 VSS 0.03351f
C112 outn.n14 VSS 0.02904f
C113 outn.n15 VSS 0.01655f
C114 outn.n16 VSS 0.36937f
C115 outn.n17 VSS 0.23931f
C116 outn.n18 VSS 0.02183f
C117 outn.t9 VSS 0.12828f
C118 outn.t2 VSS 0.12828f
C119 outn.n19 VSS 0.27181f
C120 outn.n20 VSS 0.03351f
C121 outn.n21 VSS 0.02904f
C122 outn.n22 VSS 0.01655f
C123 outn.n23 VSS 0.36937f
C124 outn.n24 VSS 0.23931f
C125 outn.n25 VSS 0.02183f
C126 outn.t8 VSS 0.12828f
C127 outn.t15 VSS 0.12828f
C128 outn.n26 VSS 0.27181f
C129 outn.n27 VSS 0.03351f
C130 outn.n28 VSS 0.02904f
C131 outn.n29 VSS 0.01655f
C132 outn.n30 VSS 0.36937f
C133 outn.n31 VSS 1.00681f
C134 outn.n32 VSS 3.0704f
C135 outn.n33 VSS 0.36657f
C136 outn.n34 VSS 0.36657f
C137 outn.n35 VSS 0.36657f
C138 outn.n36 VSS 0.36657f
C139 outn.n37 VSS 0.01664f
C140 outn.n38 VSS 0.02904f
C141 outn.t14 VSS 0.12828f
C142 outn.n39 VSS 0.01323f
C143 outn.t5 VSS 0.12828f
C144 outn.n40 VSS 0.27176f
C145 outn.n41 VSS 0.04039f
C146 outn.n42 VSS 0.16512f
C147 outn.n43 VSS 0.11f
C148 outn.n44 VSS 0.01664f
C149 outn.t3 VSS 0.12828f
C150 outn.t7 VSS 0.12828f
C151 outn.n45 VSS 0.27176f
C152 outn.n46 VSS 0.01323f
C153 outn.n47 VSS 0.02904f
C154 outn.n48 VSS 0.04039f
C155 outn.n49 VSS 0.16512f
C156 outn.n50 VSS 0.67034f
C157 outn.n51 VSS 0.01664f
C158 outn.t11 VSS 0.12828f
C159 outn.t13 VSS 0.12828f
C160 outn.n52 VSS 0.27176f
C161 outn.n53 VSS 0.01323f
C162 outn.n54 VSS 0.02904f
C163 outn.n55 VSS 0.04039f
C164 outn.n56 VSS 0.16512f
C165 outn.n57 VSS 0.67034f
C166 outn.n58 VSS 0.01664f
C167 outn.t4 VSS 0.12828f
C168 outn.t10 VSS 0.12828f
C169 outn.n59 VSS 0.27176f
C170 outn.n60 VSS 0.01323f
C171 outn.n61 VSS 0.02904f
C172 outn.n62 VSS 0.04039f
C173 outn.n63 VSS 0.16512f
C174 outn.n64 VSS 0.24618f
C175 outn.t16 VSS 1.94044f
C176 outn.n65 VSS 2.33754f
C177 outn.n66 VSS 1.62562f
C178 outn.n67 VSS 1.65903f
C179 outp.n0 VSS 0.19083f
C180 outp.n1 VSS 1.58635f
C181 outp.n2 VSS 0.31658f
C182 outp.n3 VSS 0.31658f
C183 outp.n4 VSS 0.31658f
C184 outp.n5 VSS 0.31658f
C185 outp.n6 VSS 0.01192f
C186 outp.t2 VSS 0.12208f
C187 outp.t3 VSS 0.12208f
C188 outp.n7 VSS 0.25863f
C189 outp.n8 VSS 0.04487f
C190 outp.n9 VSS 0.02763f
C191 outp.n10 VSS 0.01584f
C192 outp.n11 VSS 0.18366f
C193 outp.n12 VSS 0.10468f
C194 outp.n13 VSS 0.01192f
C195 outp.t7 VSS 0.12208f
C196 outp.t8 VSS 0.12208f
C197 outp.n14 VSS 0.25863f
C198 outp.n15 VSS 0.04487f
C199 outp.n16 VSS 0.02763f
C200 outp.n17 VSS 0.01584f
C201 outp.n18 VSS 0.18366f
C202 outp.n19 VSS 0.63794f
C203 outp.n20 VSS 0.01192f
C204 outp.t12 VSS 0.12208f
C205 outp.t6 VSS 0.12208f
C206 outp.n21 VSS 0.25863f
C207 outp.n22 VSS 0.04487f
C208 outp.n23 VSS 0.02763f
C209 outp.n24 VSS 0.01584f
C210 outp.n25 VSS 0.18366f
C211 outp.n26 VSS 0.63794f
C212 outp.n27 VSS 0.01192f
C213 outp.t13 VSS 0.12208f
C214 outp.t0 VSS 0.12208f
C215 outp.n28 VSS 0.25863f
C216 outp.n29 VSS 0.04487f
C217 outp.n30 VSS 0.02763f
C218 outp.n31 VSS 0.01584f
C219 outp.n32 VSS 0.18366f
C220 outp.n33 VSS 0.23428f
C221 outp.t16 VSS 1.84664f
C222 outp.n34 VSS 2.52928f
C223 outp.n35 VSS 1.62516f
C224 outp.n36 VSS 0.17518f
C225 outp.n37 VSS 0.17518f
C226 outp.n38 VSS 0.17518f
C227 outp.n39 VSS 0.17518f
C228 outp.n40 VSS 0.01575f
C229 outp.n41 VSS 0.02763f
C230 outp.t11 VSS 0.12208f
C231 outp.n42 VSS 0.00959f
C232 outp.t5 VSS 0.12208f
C233 outp.n43 VSS 0.25867f
C234 outp.n44 VSS 0.06978f
C235 outp.n45 VSS 0.30252f
C236 outp.n46 VSS 0.10468f
C237 outp.n47 VSS 0.01575f
C238 outp.t4 VSS 0.12208f
C239 outp.t14 VSS 0.12208f
C240 outp.n48 VSS 0.25867f
C241 outp.n49 VSS 0.00959f
C242 outp.n50 VSS 0.02763f
C243 outp.n51 VSS 0.06978f
C244 outp.n52 VSS 0.30252f
C245 outp.n53 VSS 0.22774f
C246 outp.n54 VSS 0.01575f
C247 outp.t15 VSS 0.12208f
C248 outp.t1 VSS 0.12208f
C249 outp.n55 VSS 0.25867f
C250 outp.n56 VSS 0.00959f
C251 outp.n57 VSS 0.02763f
C252 outp.n58 VSS 0.06978f
C253 outp.n59 VSS 0.30252f
C254 outp.n60 VSS 0.22774f
C255 outp.n61 VSS 0.01575f
C256 outp.t9 VSS 0.12208f
C257 outp.t10 VSS 0.12208f
C258 outp.n62 VSS 0.25867f
C259 outp.n63 VSS 0.00959f
C260 outp.n64 VSS 0.02763f
C261 outp.n65 VSS 0.06978f
C262 outp.n66 VSS 0.30252f
C263 outp.n67 VSS 1.18925f
C264 outp.n68 VSS 3.04117f
C265 nb.t20 VSS 0.13504f
C266 nb.t21 VSS 0.11782f
C267 nb.n0 VSS 0.18174f
C268 nb.t22 VSS 0.13502f
C269 nb.n1 VSS 0.10581f
C270 nb.t23 VSS 0.11782f
C271 nb.n2 VSS 0.09306f
C272 nb.t24 VSS 0.13502f
C273 nb.n3 VSS 0.10581f
C274 nb.t25 VSS 0.11782f
C275 nb.n4 VSS 0.09306f
C276 nb.t26 VSS 0.13502f
C277 nb.n5 VSS 0.10581f
C278 nb.t27 VSS 0.11782f
C279 nb.n6 VSS 0.09306f
C280 nb.t28 VSS 0.13502f
C281 nb.n7 VSS 0.10581f
C282 nb.t29 VSS 0.11782f
C283 nb.n8 VSS 0.09306f
C284 nb.t30 VSS 0.13502f
C285 nb.n9 VSS 0.10581f
C286 nb.t31 VSS 0.11782f
C287 nb.n10 VSS 0.09306f
C288 nb.t32 VSS 0.13502f
C289 nb.n11 VSS 0.10581f
C290 nb.t33 VSS 0.11782f
C291 nb.n12 VSS 0.09306f
C292 nb.t34 VSS 0.13502f
C293 nb.n13 VSS 0.10581f
C294 nb.t35 VSS 0.11782f
C295 nb.n14 VSS 0.09306f
C296 nb.t36 VSS 0.13502f
C297 nb.n15 VSS 0.10581f
C298 nb.t37 VSS 0.11782f
C299 nb.n16 VSS 0.09306f
C300 nb.t38 VSS 0.13502f
C301 nb.n17 VSS 0.10581f
C302 nb.t39 VSS 0.11782f
C303 nb.n18 VSS 0.16793f
C304 nb.t0 VSS 0.13504f
C305 nb.t1 VSS 0.11782f
C306 nb.n19 VSS 0.18174f
C307 nb.t2 VSS 0.13502f
C308 nb.n20 VSS 0.10581f
C309 nb.t3 VSS 0.11782f
C310 nb.n21 VSS 0.09306f
C311 nb.t4 VSS 0.13502f
C312 nb.n22 VSS 0.10581f
C313 nb.t5 VSS 0.11782f
C314 nb.n23 VSS 0.09306f
C315 nb.t6 VSS 0.13502f
C316 nb.n24 VSS 0.10581f
C317 nb.t7 VSS 0.11782f
C318 nb.n25 VSS 0.09306f
C319 nb.t8 VSS 0.13502f
C320 nb.n26 VSS 0.10581f
C321 nb.t9 VSS 0.11782f
C322 nb.n27 VSS 0.09306f
C323 nb.t10 VSS 0.13502f
C324 nb.n28 VSS 0.10581f
C325 nb.t11 VSS 0.11782f
C326 nb.n29 VSS 0.09306f
C327 nb.t12 VSS 0.13502f
C328 nb.n30 VSS 0.10581f
C329 nb.t13 VSS 0.11782f
C330 nb.n31 VSS 0.09306f
C331 nb.t14 VSS 0.13502f
C332 nb.n32 VSS 0.10581f
C333 nb.t15 VSS 0.11782f
C334 nb.n33 VSS 0.09306f
C335 nb.t16 VSS 0.13502f
C336 nb.n34 VSS 0.10581f
C337 nb.t17 VSS 0.11782f
C338 nb.n35 VSS 0.09306f
C339 nb.t18 VSS 0.13502f
C340 nb.n36 VSS 0.10581f
C341 nb.t19 VSS 0.11782f
C342 nb.n37 VSS 0.16793f
C343 nb.n38 VSS 0.56261f
.ends
