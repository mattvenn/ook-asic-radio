* lpf_rc: magic R+C extraction of layout/lpf_rc.gds (layout/pex.sh)
.subckt lpf_rc in out VSS
X0 out.t1 VSS.t11 sky130_fd_pr__cap_mim_m3_1 l=30 w=30
X1 r13 r12 VSS.t9 sky130_fd_pr__res_xhigh_po_0p35 l=25
X2 r15 r14 VSS.t14 sky130_fd_pr__res_xhigh_po_0p35 l=25
X3 r7 r8 VSS.t8 sky130_fd_pr__res_xhigh_po_0p35 l=25
X4 r9 r10 VSS.t15 sky130_fd_pr__res_xhigh_po_0p35 l=25
X5 r11 r12 VSS.t13 sky130_fd_pr__res_xhigh_po_0p35 l=25
X6 r3 r2 VSS.t3 sky130_fd_pr__res_xhigh_po_0p35 l=25
X7 r5 r4 VSS.t1 sky130_fd_pr__res_xhigh_po_0p35 l=25
X8 r7 r6 VSS.t6 sky130_fd_pr__res_xhigh_po_0p35 l=25
X9 r1 r2 VSS.t0 sky130_fd_pr__res_xhigh_po_0p35 l=25
X10 out.t2 VSS.t10 sky130_fd_pr__cap_mim_m3_1 l=30 w=30
X11 r13 r14 VSS.t16 sky130_fd_pr__res_xhigh_po_0p35 l=25
X12 r15 out.t0 VSS.t17 sky130_fd_pr__res_xhigh_po_0p35 l=25
X13 r9 r8 VSS.t5 sky130_fd_pr__res_xhigh_po_0p35 l=25
X14 r11 r10 VSS.t12 sky130_fd_pr__res_xhigh_po_0p35 l=25
X15 r3 r4 VSS.t2 sky130_fd_pr__res_xhigh_po_0p35 l=25
X16 r5 r6 VSS.t4 sky130_fd_pr__res_xhigh_po_0p35 l=25
X17 r1 in.t0 VSS.t7 sky130_fd_pr__res_xhigh_po_0p35 l=25
R0 out.n8 out.n3 50.6672
R1 out.n15 out.n2 17.8167
R2 out.n16 out.n15 15.8839
R3 out.n6 out.n4 13.1884
R4 out.n7 out.n6 13.1662
R5 out.n9 out.n7 13.1662
R6 out.n10 out.n5 13.1662
R7 out.n14 out.n13 13.1662
R8 out out.n16 11.9742
R9 out.n14 out.n1 9.3005
R10 out.n13 out.n12 9.3005
R11 out.n13 out.n2 9.3005
R12 out.n11 out.n10 9.3005
R13 out.n10 out.n9 9.3005
R14 out.n7 out.n5 9.3005
R15 out.n6 out.t0 7.13193
R16 out.n8 out.n2 6.76621
R17 out.n13 out.n3 6.76621
R18 out.n9 out.n8 6.4005
R19 out.n10 out.n3 6.4005
R20 out.n5 out.n4 3.8419
R21 out.n11 out.n4 2.85946
R22 out.n15 out.n14 2.72607
R23 out.n0 out.t2 1.09506
R24 out out.n0 0.991648
R25 out.n12 out.n11 0.113
R26 out.n12 out.n1 0.113
R27 out.n16 out.n1 0.113
R28 out.n0 out.t1 0.0207703
R29 in.n7 in.n2 50.6672
R30 in.n14 in.n1 17.8167
R31 in.n15 in.n14 15.8839
R32 in.n5 in.n3 13.1884
R33 in.n6 in.n5 13.1662
R34 in.n8 in.n6 13.1662
R35 in.n9 in.n4 13.1662
R36 in.n13 in.n12 13.1662
R37 in in.n15 10.3271
R38 in.n13 in.n0 9.3005
R39 in.n12 in.n11 9.3005
R40 in.n12 in.n1 9.3005
R41 in.n10 in.n9 9.3005
R42 in.n9 in.n8 9.3005
R43 in.n6 in.n4 9.3005
R44 in.n5 in.t0 7.13193
R45 in.n7 in.n1 6.76621
R46 in.n12 in.n2 6.76621
R47 in.n8 in.n7 6.4005
R48 in.n9 in.n2 6.4005
R49 in.n4 in.n3 3.8419
R50 in.n10 in.n3 2.85946
R51 in.n14 in.n13 2.72607
R52 in.n11 in.n10 0.113
R53 in.n11 in.n0 0.113
R54 in.n15 in.n0 0.113
R55 VSS.n225 VSS.n224 585
R56 VSS.n226 VSS.n225 585
R57 VSS.n544 VSS.n543 585
R58 VSS.n543 VSS.n542 585
R59 VSS.n222 VSS.n221 585
R60 VSS.n541 VSS.n221 585
R61 VSS.n549 VSS.n548 585
R62 VSS.n550 VSS.n549 585
R63 VSS.n214 VSS.n213 585
R64 VSS.n215 VSS.n214 585
R65 VSS.n560 VSS.n559 585
R66 VSS.n559 VSS.n558 585
R67 VSS.n211 VSS.n210 585
R68 VSS.n210 VSS.n208 585
R69 VSS.n565 VSS.n564 585
R70 VSS.n566 VSS.n565 585
R71 VSS.n202 VSS.n201 585
R72 VSS.n209 VSS.n202 585
R73 VSS.n576 VSS.n575 585
R74 VSS.n575 VSS.n574 585
R75 VSS.n199 VSS.n198 585
R76 VSS.n198 VSS.n197 585
R77 VSS.n581 VSS.n580 585
R78 VSS.t9 VSS.n581 585
R79 VSS.n190 VSS.n189 585
R80 VSS.n191 VSS.n190 585
R81 VSS.n591 VSS.n590 585
R82 VSS.n590 VSS.n589 585
R83 VSS.n187 VSS.n186 585
R84 VSS.n186 VSS.n184 585
R85 VSS.n596 VSS.n595 585
R86 VSS.n597 VSS.n596 585
R87 VSS.n178 VSS.n177 585
R88 VSS.n185 VSS.n178 585
R89 VSS.n609 VSS.n608 585
R90 VSS.n608 VSS.n607 585
R91 VSS.n175 VSS.n174 585
R92 VSS.n174 VSS.n173 585
R93 VSS.n614 VSS.n613 585
R94 VSS.n615 VSS.n614 585
R95 VSS.n166 VSS.n165 585
R96 VSS.n167 VSS.n166 585
R97 VSS.n626 VSS.n625 585
R98 VSS.n625 VSS.n624 585
R99 VSS.n163 VSS.n162 585
R100 VSS.n623 VSS.n162 585
R101 VSS.n631 VSS.n630 585
R102 VSS.n632 VSS.n631 585
R103 VSS.n155 VSS.n154 585
R104 VSS.n161 VSS.n155 585
R105 VSS.n642 VSS.n641 585
R106 VSS.n641 VSS.n640 585
R107 VSS.n152 VSS.n151 585
R108 VSS.n151 VSS.n150 585
R109 VSS.n647 VSS.n646 585
R110 VSS.n648 VSS.n647 585
R111 VSS.n143 VSS.n142 585
R112 VSS.n144 VSS.n143 585
R113 VSS.n659 VSS.n658 585
R114 VSS.n658 VSS.n657 585
R115 VSS.n140 VSS.n139 585
R116 VSS.n656 VSS.n139 585
R117 VSS.n664 VSS.n663 585
R118 VSS.n665 VSS.n664 585
R119 VSS.n132 VSS.n131 585
R120 VSS.n133 VSS.n132 585
R121 VSS.n675 VSS.n674 585
R122 VSS.n674 VSS.n673 585
R123 VSS.n129 VSS.n128 585
R124 VSS.n128 VSS.n127 585
R125 VSS.n680 VSS.n679 585
R126 VSS.n681 VSS.n680 585
R127 VSS.n121 VSS.n120 585
R128 VSS.t2 VSS.n121 585
R129 VSS.n692 VSS.n691 585
R130 VSS.n691 VSS.n690 585
R131 VSS.n118 VSS.n117 585
R132 VSS.n689 VSS.n117 585
R133 VSS.n697 VSS.n696 585
R134 VSS.n698 VSS.n697 585
R135 VSS.n110 VSS.n109 585
R136 VSS.n111 VSS.n110 585
R137 VSS.n708 VSS.n707 585
R138 VSS.n707 VSS.n706 585
R139 VSS.n106 VSS.n104 585
R140 VSS.n104 VSS.n102 585
R141 VSS.n716 VSS.n715 585
R142 VSS.n717 VSS.n716 585
R143 VSS.n107 VSS.n105 585
R144 VSS.n105 VSS.n103 585
R145 VSS.n711 VSS.n95 585
R146 VSS.n96 VSS.n95 585
R147 VSS.n727 VSS.n94 585
R148 VSS.n727 VSS.n726 585
R149 VSS.n730 VSS.n729 585
R150 VSS.n729 VSS.n6 585
R151 VSS.n950 VSS.n949 585
R152 VSS.n5 VSS.n4 585
R153 VSS.n945 VSS.n944 585
R154 VSS.n50 VSS.n49 585
R155 VSS.n939 VSS.n938 585
R156 VSS.n937 VSS.n936 585
R157 VSS.n935 VSS.n934 585
R158 VSS.n928 VSS.n52 585
R159 VSS.n930 VSS.n929 585
R160 VSS.n927 VSS.n926 585
R161 VSS.n925 VSS.n924 585
R162 VSS.n918 VSS.n54 585
R163 VSS.n920 VSS.n919 585
R164 VSS.n917 VSS.n916 585
R165 VSS.n915 VSS.n914 585
R166 VSS.n908 VSS.n56 585
R167 VSS.n910 VSS.n909 585
R168 VSS.n907 VSS.n906 585
R169 VSS.n905 VSS.n904 585
R170 VSS.n898 VSS.n58 585
R171 VSS.n900 VSS.n899 585
R172 VSS.n897 VSS.n896 585
R173 VSS.n895 VSS.n894 585
R174 VSS.n888 VSS.n60 585
R175 VSS.n890 VSS.n889 585
R176 VSS.n887 VSS.n886 585
R177 VSS.n885 VSS.n884 585
R178 VSS.n878 VSS.n62 585
R179 VSS.n880 VSS.n879 585
R180 VSS.n877 VSS.n876 585
R181 VSS.n875 VSS.n874 585
R182 VSS.n868 VSS.n64 585
R183 VSS.n870 VSS.n869 585
R184 VSS.n867 VSS.n866 585
R185 VSS.n865 VSS.n864 585
R186 VSS.n858 VSS.n66 585
R187 VSS.n860 VSS.n859 585
R188 VSS.n857 VSS.n856 585
R189 VSS.n855 VSS.n854 585
R190 VSS.n848 VSS.n68 585
R191 VSS.n850 VSS.n849 585
R192 VSS.n847 VSS.n846 585
R193 VSS.n845 VSS.n844 585
R194 VSS.n838 VSS.n70 585
R195 VSS.n840 VSS.n839 585
R196 VSS.n837 VSS.n836 585
R197 VSS.n835 VSS.n834 585
R198 VSS.n828 VSS.n72 585
R199 VSS.n830 VSS.n829 585
R200 VSS.n827 VSS.n826 585
R201 VSS.n825 VSS.n824 585
R202 VSS.n818 VSS.n74 585
R203 VSS.n820 VSS.n819 585
R204 VSS.n817 VSS.n816 585
R205 VSS.n815 VSS.n814 585
R206 VSS.n808 VSS.n76 585
R207 VSS.n810 VSS.n809 585
R208 VSS.n807 VSS.n806 585
R209 VSS.n805 VSS.n804 585
R210 VSS.n798 VSS.n78 585
R211 VSS.n800 VSS.n799 585
R212 VSS.n797 VSS.n796 585
R213 VSS.n795 VSS.n794 585
R214 VSS.n788 VSS.n80 585
R215 VSS.n790 VSS.n789 585
R216 VSS.n787 VSS.n786 585
R217 VSS.n785 VSS.n784 585
R218 VSS.n778 VSS.n82 585
R219 VSS.n780 VSS.n779 585
R220 VSS.n777 VSS.n776 585
R221 VSS.n775 VSS.n774 585
R222 VSS.n768 VSS.n84 585
R223 VSS.n770 VSS.n769 585
R224 VSS.n767 VSS.n766 585
R225 VSS.n765 VSS.n764 585
R226 VSS.n758 VSS.n86 585
R227 VSS.n760 VSS.n759 585
R228 VSS.n757 VSS.n756 585
R229 VSS.n755 VSS.n754 585
R230 VSS.n748 VSS.n88 585
R231 VSS.n750 VSS.n749 585
R232 VSS.n747 VSS.n746 585
R233 VSS.n745 VSS.n744 585
R234 VSS.n738 VSS.n90 585
R235 VSS.n740 VSS.n739 585
R236 VSS.n737 VSS.n736 585
R237 VSS.n735 VSS.n734 585
R238 VSS.n728 VSS.n92 585
R239 VSS.n951 VSS.n3 585
R240 VSS.n6 VSS.n3 585
R241 VSS.n725 VSS.n2 585
R242 VSS.n726 VSS.n725 585
R243 VSS.n724 VSS.n723 585
R244 VSS.n724 VSS.n96 585
R245 VSS.n98 VSS.n97 585
R246 VSS.n103 VSS.n97 585
R247 VSS.n719 VSS.n718 585
R248 VSS.n718 VSS.n717 585
R249 VSS.n101 VSS.n100 585
R250 VSS.n102 VSS.n101 585
R251 VSS.n705 VSS.n704 585
R252 VSS.n706 VSS.n705 585
R253 VSS.n113 VSS.n112 585
R254 VSS.n112 VSS.n111 585
R255 VSS.n700 VSS.n699 585
R256 VSS.n699 VSS.n698 585
R257 VSS.n116 VSS.n115 585
R258 VSS.n689 VSS.n116 585
R259 VSS.n688 VSS.n687 585
R260 VSS.n690 VSS.n688 585
R261 VSS.n123 VSS.n122 585
R262 VSS.n122 VSS.t2 585
R263 VSS.n683 VSS.n682 585
R264 VSS.n682 VSS.n681 585
R265 VSS.n126 VSS.n125 585
R266 VSS.n127 VSS.n126 585
R267 VSS.n672 VSS.n671 585
R268 VSS.n673 VSS.n672 585
R269 VSS.n135 VSS.n134 585
R270 VSS.n134 VSS.n133 585
R271 VSS.n667 VSS.n666 585
R272 VSS.n666 VSS.n665 585
R273 VSS.n138 VSS.n137 585
R274 VSS.n656 VSS.n138 585
R275 VSS.n655 VSS.n654 585
R276 VSS.n657 VSS.n655 585
R277 VSS.n146 VSS.n145 585
R278 VSS.n145 VSS.n144 585
R279 VSS.n650 VSS.n649 585
R280 VSS.n649 VSS.n648 585
R281 VSS.n149 VSS.n148 585
R282 VSS.n150 VSS.n149 585
R283 VSS.n639 VSS.n638 585
R284 VSS.n640 VSS.n639 585
R285 VSS.n157 VSS.n156 585
R286 VSS.n161 VSS.n156 585
R287 VSS.n634 VSS.n633 585
R288 VSS.n633 VSS.n632 585
R289 VSS.n160 VSS.n159 585
R290 VSS.n623 VSS.n160 585
R291 VSS.n622 VSS.n621 585
R292 VSS.n624 VSS.n622 585
R293 VSS.n169 VSS.n168 585
R294 VSS.n168 VSS.n167 585
R295 VSS.n617 VSS.n616 585
R296 VSS.n616 VSS.n615 585
R297 VSS.n172 VSS.n171 585
R298 VSS.n173 VSS.n172 585
R299 VSS.n606 VSS.n605 585
R300 VSS.n607 VSS.n606 585
R301 VSS.n180 VSS.n179 585
R302 VSS.n185 VSS.n179 585
R303 VSS.n599 VSS.n598 585
R304 VSS.n598 VSS.n597 585
R305 VSS.n183 VSS.n182 585
R306 VSS.n184 VSS.n183 585
R307 VSS.n588 VSS.n587 585
R308 VSS.n589 VSS.n588 585
R309 VSS.n193 VSS.n192 585
R310 VSS.n192 VSS.n191 585
R311 VSS.n583 VSS.n582 585
R312 VSS.n582 VSS.t9 585
R313 VSS.n196 VSS.n195 585
R314 VSS.n197 VSS.n196 585
R315 VSS.n573 VSS.n572 585
R316 VSS.n574 VSS.n573 585
R317 VSS.n204 VSS.n203 585
R318 VSS.n209 VSS.n203 585
R319 VSS.n568 VSS.n567 585
R320 VSS.n567 VSS.n566 585
R321 VSS.n207 VSS.n206 585
R322 VSS.n208 VSS.n207 585
R323 VSS.n557 VSS.n556 585
R324 VSS.n558 VSS.n557 585
R325 VSS.n217 VSS.n216 585
R326 VSS.n216 VSS.n215 585
R327 VSS.n552 VSS.n551 585
R328 VSS.n551 VSS.n550 585
R329 VSS.n220 VSS.n219 585
R330 VSS.n541 VSS.n220 585
R331 VSS.n540 VSS.n539 585
R332 VSS.n542 VSS.n540 585
R333 VSS.n228 VSS.n227 585
R334 VSS.n227 VSS.n226 585
R335 VSS.n531 VSS.n530 585
R336 VSS.n276 VSS.n275 585
R337 VSS.n526 VSS.n274 585
R338 VSS.n533 VSS.n274 585
R339 VSS.n525 VSS.n278 585
R340 VSS.n524 VSS.n279 585
R341 VSS.n281 VSS.n280 585
R342 VSS.n520 VSS.n283 585
R343 VSS.n519 VSS.n284 585
R344 VSS.n518 VSS.n285 585
R345 VSS.n287 VSS.n286 585
R346 VSS.n514 VSS.n289 585
R347 VSS.n513 VSS.n290 585
R348 VSS.n512 VSS.n291 585
R349 VSS.n293 VSS.n292 585
R350 VSS.n508 VSS.n295 585
R351 VSS.n507 VSS.n296 585
R352 VSS.n506 VSS.n297 585
R353 VSS.n299 VSS.n298 585
R354 VSS.n502 VSS.n301 585
R355 VSS.n501 VSS.n302 585
R356 VSS.n500 VSS.n303 585
R357 VSS.n305 VSS.n304 585
R358 VSS.n496 VSS.n307 585
R359 VSS.n495 VSS.n308 585
R360 VSS.n494 VSS.n309 585
R361 VSS.n311 VSS.n310 585
R362 VSS.n490 VSS.n313 585
R363 VSS.n489 VSS.n314 585
R364 VSS.n488 VSS.n315 585
R365 VSS.n317 VSS.n316 585
R366 VSS.n484 VSS.n319 585
R367 VSS.n483 VSS.n320 585
R368 VSS.n482 VSS.n321 585
R369 VSS.n323 VSS.n322 585
R370 VSS.n478 VSS.n325 585
R371 VSS.n477 VSS.n326 585
R372 VSS.n476 VSS.n327 585
R373 VSS.n329 VSS.n328 585
R374 VSS.n472 VSS.n331 585
R375 VSS.n471 VSS.n332 585
R376 VSS.n470 VSS.n333 585
R377 VSS.n335 VSS.n334 585
R378 VSS.n466 VSS.n337 585
R379 VSS.n465 VSS.n338 585
R380 VSS.n464 VSS.n339 585
R381 VSS.n341 VSS.n340 585
R382 VSS.n460 VSS.n343 585
R383 VSS.n459 VSS.n344 585
R384 VSS.n458 VSS.n345 585
R385 VSS.n347 VSS.n346 585
R386 VSS.n454 VSS.n349 585
R387 VSS.n453 VSS.n350 585
R388 VSS.n452 VSS.n351 585
R389 VSS.n353 VSS.n352 585
R390 VSS.n448 VSS.n355 585
R391 VSS.n447 VSS.n356 585
R392 VSS.n446 VSS.n357 585
R393 VSS.n359 VSS.n358 585
R394 VSS.n442 VSS.n361 585
R395 VSS.n441 VSS.n362 585
R396 VSS.n440 VSS.n363 585
R397 VSS.n365 VSS.n364 585
R398 VSS.n436 VSS.n367 585
R399 VSS.n435 VSS.n368 585
R400 VSS.n434 VSS.n369 585
R401 VSS.n371 VSS.n370 585
R402 VSS.n430 VSS.n373 585
R403 VSS.n429 VSS.n374 585
R404 VSS.n428 VSS.n375 585
R405 VSS.n377 VSS.n376 585
R406 VSS.n424 VSS.n379 585
R407 VSS.n423 VSS.n380 585
R408 VSS.n422 VSS.n381 585
R409 VSS.n383 VSS.n382 585
R410 VSS.n418 VSS.n385 585
R411 VSS.n417 VSS.n386 585
R412 VSS.n416 VSS.n387 585
R413 VSS.n389 VSS.n388 585
R414 VSS.n412 VSS.n391 585
R415 VSS.n411 VSS.n392 585
R416 VSS.n410 VSS.n393 585
R417 VSS.n395 VSS.n394 585
R418 VSS.n406 VSS.n397 585
R419 VSS.n405 VSS.n398 585
R420 VSS.n404 VSS.n399 585
R421 VSS.n401 VSS.n400 585
R422 VSS.n231 VSS.n230 585
R423 VSS.n535 VSS.n534 585
R424 VSS.n534 VSS.n533 585
R425 VSS.n729 VSS.n728 426.014
R426 VSS.n949 VSS.n3 426.014
R427 VSS.n534 VSS.n227 426.014
R428 VSS.n531 VSS.n225 426.014
R429 VSS.n948 VSS.n947 254.01
R430 VSS.n947 VSS.n946 254.01
R431 VSS.n947 VSS.n48 254.01
R432 VSS.n947 VSS.n47 254.01
R433 VSS.n947 VSS.n46 254.01
R434 VSS.n947 VSS.n45 254.01
R435 VSS.n947 VSS.n44 254.01
R436 VSS.n947 VSS.n43 254.01
R437 VSS.n947 VSS.n42 254.01
R438 VSS.n947 VSS.n41 254.01
R439 VSS.n947 VSS.n40 254.01
R440 VSS.n947 VSS.n39 254.01
R441 VSS.n947 VSS.n38 254.01
R442 VSS.n947 VSS.n37 254.01
R443 VSS.n947 VSS.n36 254.01
R444 VSS.n947 VSS.n35 254.01
R445 VSS.n947 VSS.n34 254.01
R446 VSS.n947 VSS.n33 254.01
R447 VSS.n947 VSS.n32 254.01
R448 VSS.n947 VSS.n31 254.01
R449 VSS.n947 VSS.n30 254.01
R450 VSS.n947 VSS.n29 254.01
R451 VSS.n947 VSS.n28 254.01
R452 VSS.n947 VSS.n27 254.01
R453 VSS.n947 VSS.n26 254.01
R454 VSS.n947 VSS.n25 254.01
R455 VSS.n947 VSS.n24 254.01
R456 VSS.n947 VSS.n23 254.01
R457 VSS.n947 VSS.n22 254.01
R458 VSS.n947 VSS.n21 254.01
R459 VSS.n947 VSS.n20 254.01
R460 VSS.n947 VSS.n19 254.01
R461 VSS.n947 VSS.n18 254.01
R462 VSS.n947 VSS.n17 254.01
R463 VSS.n947 VSS.n16 254.01
R464 VSS.n947 VSS.n15 254.01
R465 VSS.n947 VSS.n14 254.01
R466 VSS.n947 VSS.n13 254.01
R467 VSS.n947 VSS.n12 254.01
R468 VSS.n947 VSS.n11 254.01
R469 VSS.n947 VSS.n10 254.01
R470 VSS.n947 VSS.n9 254.01
R471 VSS.n947 VSS.n8 254.01
R472 VSS.n947 VSS.n7 254.01
R473 VSS.n533 VSS.n532 254.01
R474 VSS.n533 VSS.n232 254.01
R475 VSS.n533 VSS.n233 254.01
R476 VSS.n533 VSS.n234 254.01
R477 VSS.n533 VSS.n235 254.01
R478 VSS.n533 VSS.n236 254.01
R479 VSS.n533 VSS.n237 254.01
R480 VSS.n533 VSS.n238 254.01
R481 VSS.n533 VSS.n239 254.01
R482 VSS.n533 VSS.n240 254.01
R483 VSS.n533 VSS.n241 254.01
R484 VSS.n533 VSS.n242 254.01
R485 VSS.n533 VSS.n243 254.01
R486 VSS.n533 VSS.n244 254.01
R487 VSS.n533 VSS.n245 254.01
R488 VSS.n533 VSS.n246 254.01
R489 VSS.n533 VSS.n247 254.01
R490 VSS.n533 VSS.n248 254.01
R491 VSS.n533 VSS.n249 254.01
R492 VSS.n533 VSS.n250 254.01
R493 VSS.n533 VSS.n251 254.01
R494 VSS.n533 VSS.n252 254.01
R495 VSS.n533 VSS.n253 254.01
R496 VSS.n533 VSS.n254 254.01
R497 VSS.n533 VSS.n255 254.01
R498 VSS.n533 VSS.n256 254.01
R499 VSS.n533 VSS.n257 254.01
R500 VSS.n533 VSS.n258 254.01
R501 VSS.n533 VSS.n259 254.01
R502 VSS.n533 VSS.n260 254.01
R503 VSS.n533 VSS.n261 254.01
R504 VSS.n533 VSS.n262 254.01
R505 VSS.n533 VSS.n263 254.01
R506 VSS.n533 VSS.n264 254.01
R507 VSS.n533 VSS.n265 254.01
R508 VSS.n533 VSS.n266 254.01
R509 VSS.n533 VSS.n267 254.01
R510 VSS.n533 VSS.n268 254.01
R511 VSS.n533 VSS.n269 254.01
R512 VSS.n533 VSS.n270 254.01
R513 VSS.n533 VSS.n271 254.01
R514 VSS.n533 VSS.n272 254.01
R515 VSS.n533 VSS.n273 254.01
R516 VSS.n736 VSS.n735 177.3
R517 VSS.n739 VSS.n738 177.3
R518 VSS.n746 VSS.n745 177.3
R519 VSS.n749 VSS.n748 177.3
R520 VSS.n756 VSS.n755 177.3
R521 VSS.n759 VSS.n758 177.3
R522 VSS.n766 VSS.n765 177.3
R523 VSS.n769 VSS.n768 177.3
R524 VSS.n776 VSS.n775 177.3
R525 VSS.n779 VSS.n778 177.3
R526 VSS.n786 VSS.n785 177.3
R527 VSS.n789 VSS.n788 177.3
R528 VSS.n796 VSS.n795 177.3
R529 VSS.n799 VSS.n798 177.3
R530 VSS.n806 VSS.n805 177.3
R531 VSS.n809 VSS.n808 177.3
R532 VSS.n816 VSS.n815 177.3
R533 VSS.n819 VSS.n818 177.3
R534 VSS.n826 VSS.n825 177.3
R535 VSS.n829 VSS.n828 177.3
R536 VSS.n836 VSS.n835 177.3
R537 VSS.n839 VSS.n838 177.3
R538 VSS.n846 VSS.n845 177.3
R539 VSS.n849 VSS.n848 177.3
R540 VSS.n856 VSS.n855 177.3
R541 VSS.n859 VSS.n858 177.3
R542 VSS.n866 VSS.n865 177.3
R543 VSS.n869 VSS.n868 177.3
R544 VSS.n876 VSS.n875 177.3
R545 VSS.n879 VSS.n878 177.3
R546 VSS.n886 VSS.n885 177.3
R547 VSS.n889 VSS.n888 177.3
R548 VSS.n896 VSS.n895 177.3
R549 VSS.n899 VSS.n898 177.3
R550 VSS.n906 VSS.n905 177.3
R551 VSS.n909 VSS.n908 177.3
R552 VSS.n916 VSS.n915 177.3
R553 VSS.n919 VSS.n918 177.3
R554 VSS.n926 VSS.n925 177.3
R555 VSS.n929 VSS.n928 177.3
R556 VSS.n936 VSS.n935 177.3
R557 VSS.n938 VSS.n49 177.3
R558 VSS.n945 VSS.n5 177.3
R559 VSS.n540 VSS.n227 177.3
R560 VSS.n540 VSS.n220 177.3
R561 VSS.n551 VSS.n220 177.3
R562 VSS.n551 VSS.n216 177.3
R563 VSS.n557 VSS.n216 177.3
R564 VSS.n557 VSS.n207 177.3
R565 VSS.n567 VSS.n207 177.3
R566 VSS.n567 VSS.n203 177.3
R567 VSS.n573 VSS.n203 177.3
R568 VSS.n573 VSS.n196 177.3
R569 VSS.n582 VSS.n196 177.3
R570 VSS.n582 VSS.n192 177.3
R571 VSS.n588 VSS.n192 177.3
R572 VSS.n588 VSS.n183 177.3
R573 VSS.n598 VSS.n183 177.3
R574 VSS.n598 VSS.n179 177.3
R575 VSS.n606 VSS.n179 177.3
R576 VSS.n606 VSS.n172 177.3
R577 VSS.n616 VSS.n172 177.3
R578 VSS.n616 VSS.n168 177.3
R579 VSS.n622 VSS.n168 177.3
R580 VSS.n622 VSS.n160 177.3
R581 VSS.n633 VSS.n160 177.3
R582 VSS.n633 VSS.n156 177.3
R583 VSS.n639 VSS.n156 177.3
R584 VSS.n639 VSS.n149 177.3
R585 VSS.n649 VSS.n149 177.3
R586 VSS.n649 VSS.n145 177.3
R587 VSS.n655 VSS.n145 177.3
R588 VSS.n655 VSS.n138 177.3
R589 VSS.n666 VSS.n138 177.3
R590 VSS.n666 VSS.n134 177.3
R591 VSS.n672 VSS.n134 177.3
R592 VSS.n672 VSS.n126 177.3
R593 VSS.n682 VSS.n126 177.3
R594 VSS.n682 VSS.n122 177.3
R595 VSS.n688 VSS.n122 177.3
R596 VSS.n688 VSS.n116 177.3
R597 VSS.n699 VSS.n116 177.3
R598 VSS.n699 VSS.n112 177.3
R599 VSS.n705 VSS.n112 177.3
R600 VSS.n705 VSS.n101 177.3
R601 VSS.n718 VSS.n101 177.3
R602 VSS.n718 VSS.n97 177.3
R603 VSS.n724 VSS.n97 177.3
R604 VSS.n725 VSS.n724 177.3
R605 VSS.n725 VSS.n3 177.3
R606 VSS.n275 VSS.n274 177.3
R607 VSS.n278 VSS.n274 177.3
R608 VSS.n280 VSS.n279 177.3
R609 VSS.n284 VSS.n283 177.3
R610 VSS.n286 VSS.n285 177.3
R611 VSS.n290 VSS.n289 177.3
R612 VSS.n292 VSS.n291 177.3
R613 VSS.n296 VSS.n295 177.3
R614 VSS.n298 VSS.n297 177.3
R615 VSS.n302 VSS.n301 177.3
R616 VSS.n304 VSS.n303 177.3
R617 VSS.n308 VSS.n307 177.3
R618 VSS.n310 VSS.n309 177.3
R619 VSS.n314 VSS.n313 177.3
R620 VSS.n316 VSS.n315 177.3
R621 VSS.n320 VSS.n319 177.3
R622 VSS.n322 VSS.n321 177.3
R623 VSS.n326 VSS.n325 177.3
R624 VSS.n328 VSS.n327 177.3
R625 VSS.n332 VSS.n331 177.3
R626 VSS.n334 VSS.n333 177.3
R627 VSS.n338 VSS.n337 177.3
R628 VSS.n340 VSS.n339 177.3
R629 VSS.n344 VSS.n343 177.3
R630 VSS.n346 VSS.n345 177.3
R631 VSS.n350 VSS.n349 177.3
R632 VSS.n352 VSS.n351 177.3
R633 VSS.n356 VSS.n355 177.3
R634 VSS.n358 VSS.n357 177.3
R635 VSS.n362 VSS.n361 177.3
R636 VSS.n364 VSS.n363 177.3
R637 VSS.n368 VSS.n367 177.3
R638 VSS.n370 VSS.n369 177.3
R639 VSS.n374 VSS.n373 177.3
R640 VSS.n376 VSS.n375 177.3
R641 VSS.n380 VSS.n379 177.3
R642 VSS.n382 VSS.n381 177.3
R643 VSS.n386 VSS.n385 177.3
R644 VSS.n388 VSS.n387 177.3
R645 VSS.n392 VSS.n391 177.3
R646 VSS.n394 VSS.n393 177.3
R647 VSS.n398 VSS.n397 177.3
R648 VSS.n400 VSS.n399 177.3
R649 VSS.n534 VSS.n231 177.3
R650 VSS.n543 VSS.n225 177.3
R651 VSS.n543 VSS.n221 177.3
R652 VSS.n549 VSS.n221 177.3
R653 VSS.n549 VSS.n214 177.3
R654 VSS.n559 VSS.n214 177.3
R655 VSS.n559 VSS.n210 177.3
R656 VSS.n565 VSS.n210 177.3
R657 VSS.n565 VSS.n202 177.3
R658 VSS.n575 VSS.n202 177.3
R659 VSS.n575 VSS.n198 177.3
R660 VSS.n581 VSS.n198 177.3
R661 VSS.n581 VSS.n190 177.3
R662 VSS.n590 VSS.n190 177.3
R663 VSS.n590 VSS.n186 177.3
R664 VSS.n596 VSS.n186 177.3
R665 VSS.n596 VSS.n178 177.3
R666 VSS.n608 VSS.n178 177.3
R667 VSS.n608 VSS.n174 177.3
R668 VSS.n614 VSS.n174 177.3
R669 VSS.n614 VSS.n166 177.3
R670 VSS.n625 VSS.n166 177.3
R671 VSS.n625 VSS.n162 177.3
R672 VSS.n631 VSS.n162 177.3
R673 VSS.n631 VSS.n155 177.3
R674 VSS.n641 VSS.n155 177.3
R675 VSS.n641 VSS.n151 177.3
R676 VSS.n647 VSS.n151 177.3
R677 VSS.n647 VSS.n143 177.3
R678 VSS.n658 VSS.n143 177.3
R679 VSS.n658 VSS.n139 177.3
R680 VSS.n664 VSS.n139 177.3
R681 VSS.n664 VSS.n132 177.3
R682 VSS.n674 VSS.n132 177.3
R683 VSS.n674 VSS.n128 177.3
R684 VSS.n680 VSS.n128 177.3
R685 VSS.n680 VSS.n121 177.3
R686 VSS.n691 VSS.n121 177.3
R687 VSS.n691 VSS.n117 177.3
R688 VSS.n697 VSS.n117 177.3
R689 VSS.n697 VSS.n110 177.3
R690 VSS.n707 VSS.n110 177.3
R691 VSS.n707 VSS.n104 177.3
R692 VSS.n716 VSS.n104 177.3
R693 VSS.n716 VSS.n105 177.3
R694 VSS.n105 VSS.n95 177.3
R695 VSS.n727 VSS.n95 177.3
R696 VSS.n729 VSS.n727 177.3
R697 VSS.n735 VSS.n7 76.985
R698 VSS.n739 VSS.n8 76.985
R699 VSS.n745 VSS.n9 76.985
R700 VSS.n749 VSS.n10 76.985
R701 VSS.n755 VSS.n11 76.985
R702 VSS.n759 VSS.n12 76.985
R703 VSS.n765 VSS.n13 76.985
R704 VSS.n769 VSS.n14 76.985
R705 VSS.n775 VSS.n15 76.985
R706 VSS.n779 VSS.n16 76.985
R707 VSS.n785 VSS.n17 76.985
R708 VSS.n789 VSS.n18 76.985
R709 VSS.n795 VSS.n19 76.985
R710 VSS.n799 VSS.n20 76.985
R711 VSS.n805 VSS.n21 76.985
R712 VSS.n809 VSS.n22 76.985
R713 VSS.n815 VSS.n23 76.985
R714 VSS.n819 VSS.n24 76.985
R715 VSS.n825 VSS.n25 76.985
R716 VSS.n829 VSS.n26 76.985
R717 VSS.n835 VSS.n27 76.985
R718 VSS.n839 VSS.n28 76.985
R719 VSS.n845 VSS.n29 76.985
R720 VSS.n849 VSS.n30 76.985
R721 VSS.n855 VSS.n31 76.985
R722 VSS.n859 VSS.n32 76.985
R723 VSS.n865 VSS.n33 76.985
R724 VSS.n869 VSS.n34 76.985
R725 VSS.n875 VSS.n35 76.985
R726 VSS.n879 VSS.n36 76.985
R727 VSS.n885 VSS.n37 76.985
R728 VSS.n889 VSS.n38 76.985
R729 VSS.n895 VSS.n39 76.985
R730 VSS.n899 VSS.n40 76.985
R731 VSS.n905 VSS.n41 76.985
R732 VSS.n909 VSS.n42 76.985
R733 VSS.n915 VSS.n43 76.985
R734 VSS.n919 VSS.n44 76.985
R735 VSS.n925 VSS.n45 76.985
R736 VSS.n929 VSS.n46 76.985
R737 VSS.n935 VSS.n47 76.985
R738 VSS.n938 VSS.n48 76.985
R739 VSS.n946 VSS.n945 76.985
R740 VSS.n949 VSS.n948 76.985
R741 VSS.n532 VSS.n531 76.985
R742 VSS.n278 VSS.n232 76.985
R743 VSS.n280 VSS.n233 76.985
R744 VSS.n284 VSS.n234 76.985
R745 VSS.n286 VSS.n235 76.985
R746 VSS.n290 VSS.n236 76.985
R747 VSS.n292 VSS.n237 76.985
R748 VSS.n296 VSS.n238 76.985
R749 VSS.n298 VSS.n239 76.985
R750 VSS.n302 VSS.n240 76.985
R751 VSS.n304 VSS.n241 76.985
R752 VSS.n308 VSS.n242 76.985
R753 VSS.n310 VSS.n243 76.985
R754 VSS.n314 VSS.n244 76.985
R755 VSS.n316 VSS.n245 76.985
R756 VSS.n320 VSS.n246 76.985
R757 VSS.n322 VSS.n247 76.985
R758 VSS.n326 VSS.n248 76.985
R759 VSS.n328 VSS.n249 76.985
R760 VSS.n332 VSS.n250 76.985
R761 VSS.n334 VSS.n251 76.985
R762 VSS.n338 VSS.n252 76.985
R763 VSS.n340 VSS.n253 76.985
R764 VSS.n344 VSS.n254 76.985
R765 VSS.n346 VSS.n255 76.985
R766 VSS.n350 VSS.n256 76.985
R767 VSS.n352 VSS.n257 76.985
R768 VSS.n356 VSS.n258 76.985
R769 VSS.n358 VSS.n259 76.985
R770 VSS.n362 VSS.n260 76.985
R771 VSS.n364 VSS.n261 76.985
R772 VSS.n368 VSS.n262 76.985
R773 VSS.n370 VSS.n263 76.985
R774 VSS.n374 VSS.n264 76.985
R775 VSS.n376 VSS.n265 76.985
R776 VSS.n380 VSS.n266 76.985
R777 VSS.n382 VSS.n267 76.985
R778 VSS.n386 VSS.n268 76.985
R779 VSS.n388 VSS.n269 76.985
R780 VSS.n392 VSS.n270 76.985
R781 VSS.n394 VSS.n271 76.985
R782 VSS.n398 VSS.n272 76.985
R783 VSS.n400 VSS.n273 76.985
R784 VSS.n948 VSS.n5 76.985
R785 VSS.n946 VSS.n49 76.985
R786 VSS.n936 VSS.n48 76.985
R787 VSS.n928 VSS.n47 76.985
R788 VSS.n926 VSS.n46 76.985
R789 VSS.n918 VSS.n45 76.985
R790 VSS.n916 VSS.n44 76.985
R791 VSS.n908 VSS.n43 76.985
R792 VSS.n906 VSS.n42 76.985
R793 VSS.n898 VSS.n41 76.985
R794 VSS.n896 VSS.n40 76.985
R795 VSS.n888 VSS.n39 76.985
R796 VSS.n886 VSS.n38 76.985
R797 VSS.n878 VSS.n37 76.985
R798 VSS.n876 VSS.n36 76.985
R799 VSS.n868 VSS.n35 76.985
R800 VSS.n866 VSS.n34 76.985
R801 VSS.n858 VSS.n33 76.985
R802 VSS.n856 VSS.n32 76.985
R803 VSS.n848 VSS.n31 76.985
R804 VSS.n846 VSS.n30 76.985
R805 VSS.n838 VSS.n29 76.985
R806 VSS.n836 VSS.n28 76.985
R807 VSS.n828 VSS.n27 76.985
R808 VSS.n826 VSS.n26 76.985
R809 VSS.n818 VSS.n25 76.985
R810 VSS.n816 VSS.n24 76.985
R811 VSS.n808 VSS.n23 76.985
R812 VSS.n806 VSS.n22 76.985
R813 VSS.n798 VSS.n21 76.985
R814 VSS.n796 VSS.n20 76.985
R815 VSS.n788 VSS.n19 76.985
R816 VSS.n786 VSS.n18 76.985
R817 VSS.n778 VSS.n17 76.985
R818 VSS.n776 VSS.n16 76.985
R819 VSS.n768 VSS.n15 76.985
R820 VSS.n766 VSS.n14 76.985
R821 VSS.n758 VSS.n13 76.985
R822 VSS.n756 VSS.n12 76.985
R823 VSS.n748 VSS.n11 76.985
R824 VSS.n746 VSS.n10 76.985
R825 VSS.n738 VSS.n9 76.985
R826 VSS.n736 VSS.n8 76.985
R827 VSS.n728 VSS.n7 76.985
R828 VSS.n532 VSS.n275 76.985
R829 VSS.n279 VSS.n232 76.985
R830 VSS.n283 VSS.n233 76.985
R831 VSS.n285 VSS.n234 76.985
R832 VSS.n289 VSS.n235 76.985
R833 VSS.n291 VSS.n236 76.985
R834 VSS.n295 VSS.n237 76.985
R835 VSS.n297 VSS.n238 76.985
R836 VSS.n301 VSS.n239 76.985
R837 VSS.n303 VSS.n240 76.985
R838 VSS.n307 VSS.n241 76.985
R839 VSS.n309 VSS.n242 76.985
R840 VSS.n313 VSS.n243 76.985
R841 VSS.n315 VSS.n244 76.985
R842 VSS.n319 VSS.n245 76.985
R843 VSS.n321 VSS.n246 76.985
R844 VSS.n325 VSS.n247 76.985
R845 VSS.n327 VSS.n248 76.985
R846 VSS.n331 VSS.n249 76.985
R847 VSS.n333 VSS.n250 76.985
R848 VSS.n337 VSS.n251 76.985
R849 VSS.n339 VSS.n252 76.985
R850 VSS.n343 VSS.n253 76.985
R851 VSS.n345 VSS.n254 76.985
R852 VSS.n349 VSS.n255 76.985
R853 VSS.n351 VSS.n256 76.985
R854 VSS.n355 VSS.n257 76.985
R855 VSS.n357 VSS.n258 76.985
R856 VSS.n361 VSS.n259 76.985
R857 VSS.n363 VSS.n260 76.985
R858 VSS.n367 VSS.n261 76.985
R859 VSS.n369 VSS.n262 76.985
R860 VSS.n373 VSS.n263 76.985
R861 VSS.n375 VSS.n264 76.985
R862 VSS.n379 VSS.n265 76.985
R863 VSS.n381 VSS.n266 76.985
R864 VSS.n385 VSS.n267 76.985
R865 VSS.n387 VSS.n268 76.985
R866 VSS.n391 VSS.n269 76.985
R867 VSS.n393 VSS.n270 76.985
R868 VSS.n397 VSS.n271 76.985
R869 VSS.n399 VSS.n272 76.985
R870 VSS.n273 VSS.n231 76.985
R871 VSS.n533 VSS.n226 59.6636
R872 VSS.n947 VSS.n6 59.6636
R873 VSS.n542 VSS.n226 45.2189
R874 VSS.n542 VSS.n541 45.2189
R875 VSS.n550 VSS.n215 45.2189
R876 VSS.n558 VSS.n215 45.2189
R877 VSS.n566 VSS.n208 45.2189
R878 VSS.n566 VSS.n209 45.2189
R879 VSS.n574 VSS.n197 45.2189
R880 VSS.t9 VSS.n197 45.2189
R881 VSS.t9 VSS.n191 45.2189
R882 VSS.n589 VSS.n191 45.2189
R883 VSS.n597 VSS.n184 45.2189
R884 VSS.n597 VSS.n185 45.2189
R885 VSS.n607 VSS.n173 45.2189
R886 VSS.n615 VSS.n173 45.2189
R887 VSS.n624 VSS.n167 45.2189
R888 VSS.n624 VSS.n623 45.2189
R889 VSS.n632 VSS.n161 45.2189
R890 VSS.n640 VSS.n150 45.2189
R891 VSS.n648 VSS.n150 45.2189
R892 VSS.n657 VSS.n144 45.2189
R893 VSS.n657 VSS.n656 45.2189
R894 VSS.n665 VSS.n133 45.2189
R895 VSS.n673 VSS.n133 45.2189
R896 VSS.n681 VSS.n127 45.2189
R897 VSS.n681 VSS.t2 45.2189
R898 VSS.n690 VSS.t2 45.2189
R899 VSS.n690 VSS.n689 45.2189
R900 VSS.n698 VSS.n111 45.2189
R901 VSS.n706 VSS.n111 45.2189
R902 VSS.n717 VSS.n102 45.2189
R903 VSS.n717 VSS.n103 45.2189
R904 VSS.n726 VSS.n96 45.2189
R905 VSS.n726 VSS.n6 45.2189
R906 VSS.n632 VSS.t5 40.1946
R907 VSS.n161 VSS.t8 40.1946
R908 VSS.n574 VSS.t16 35.1704
R909 VSS.n589 VSS.t13 35.1704
R910 VSS.t1 VSS.n127 35.1704
R911 VSS.n689 VSS.t3 35.1704
R912 VSS.n541 VSS.t17 30.1461
R913 VSS.t15 VSS.n167 30.1461
R914 VSS.n648 VSS.t6 30.1461
R915 VSS.t7 VSS.n96 30.1461
R916 VSS.n530 VSS.n224 27.6805
R917 VSS.n730 VSS.n92 27.6805
R918 VSS.n951 VSS.n950 27.6805
R919 VSS.n535 VSS.n228 27.6805
R920 VSS.t14 VSS.n208 25.1218
R921 VSS.n185 VSS.t12 25.1218
R922 VSS.n665 VSS.t4 25.1218
R923 VSS.n706 VSS.t0 25.1218
R924 VSS.n558 VSS.t14 20.0976
R925 VSS.n607 VSS.t12 20.0976
R926 VSS.n656 VSS.t4 20.0976
R927 VSS.t0 VSS.n102 20.0976
R928 VSS.n550 VSS.t17 15.0733
R929 VSS.n615 VSS.t15 15.0733
R930 VSS.t6 VSS.n144 15.0733
R931 VSS.n103 VSS.t7 15.0733
R932 VSS.n544 VSS.n224 11.5205
R933 VSS.n544 VSS.n222 11.5205
R934 VSS.n548 VSS.n222 11.5205
R935 VSS.n548 VSS.n213 11.5205
R936 VSS.n560 VSS.n213 11.5205
R937 VSS.n560 VSS.n211 11.5205
R938 VSS.n564 VSS.n211 11.5205
R939 VSS.n564 VSS.n201 11.5205
R940 VSS.n576 VSS.n201 11.5205
R941 VSS.n576 VSS.n199 11.5205
R942 VSS.n580 VSS.n199 11.5205
R943 VSS.n580 VSS.n189 11.5205
R944 VSS.n591 VSS.n189 11.5205
R945 VSS.n591 VSS.n187 11.5205
R946 VSS.n595 VSS.n187 11.5205
R947 VSS.n595 VSS.n177 11.5205
R948 VSS.n609 VSS.n177 11.5205
R949 VSS.n609 VSS.n175 11.5205
R950 VSS.n613 VSS.n175 11.5205
R951 VSS.n613 VSS.n165 11.5205
R952 VSS.n626 VSS.n165 11.5205
R953 VSS.n626 VSS.n163 11.5205
R954 VSS.n630 VSS.n163 11.5205
R955 VSS.n630 VSS.n154 11.5205
R956 VSS.n642 VSS.n154 11.5205
R957 VSS.n642 VSS.n152 11.5205
R958 VSS.n646 VSS.n152 11.5205
R959 VSS.n646 VSS.n142 11.5205
R960 VSS.n659 VSS.n142 11.5205
R961 VSS.n659 VSS.n140 11.5205
R962 VSS.n663 VSS.n140 11.5205
R963 VSS.n663 VSS.n131 11.5205
R964 VSS.n675 VSS.n131 11.5205
R965 VSS.n675 VSS.n129 11.5205
R966 VSS.n679 VSS.n129 11.5205
R967 VSS.n679 VSS.n120 11.5205
R968 VSS.n692 VSS.n120 11.5205
R969 VSS.n692 VSS.n118 11.5205
R970 VSS.n696 VSS.n118 11.5205
R971 VSS.n696 VSS.n109 11.5205
R972 VSS.n708 VSS.n109 11.5205
R973 VSS.n708 VSS.n106 11.5205
R974 VSS.n715 VSS.n106 11.5205
R975 VSS.n715 VSS.n107 11.5205
R976 VSS.n711 VSS.n107 11.5205
R977 VSS.n711 VSS.n94 11.5205
R978 VSS.n730 VSS.n94 11.5205
R979 VSS.n734 VSS.n92 11.5205
R980 VSS.n737 VSS.n734 11.5205
R981 VSS.n740 VSS.n737 11.5205
R982 VSS.n740 VSS.n90 11.5205
R983 VSS.n744 VSS.n90 11.5205
R984 VSS.n747 VSS.n744 11.5205
R985 VSS.n750 VSS.n747 11.5205
R986 VSS.n750 VSS.n88 11.5205
R987 VSS.n754 VSS.n88 11.5205
R988 VSS.n757 VSS.n754 11.5205
R989 VSS.n760 VSS.n757 11.5205
R990 VSS.n760 VSS.n86 11.5205
R991 VSS.n764 VSS.n86 11.5205
R992 VSS.n767 VSS.n764 11.5205
R993 VSS.n770 VSS.n767 11.5205
R994 VSS.n770 VSS.n84 11.5205
R995 VSS.n774 VSS.n84 11.5205
R996 VSS.n777 VSS.n774 11.5205
R997 VSS.n780 VSS.n777 11.5205
R998 VSS.n780 VSS.n82 11.5205
R999 VSS.n784 VSS.n82 11.5205
R1000 VSS.n787 VSS.n784 11.5205
R1001 VSS.n790 VSS.n787 11.5205
R1002 VSS.n790 VSS.n80 11.5205
R1003 VSS.n794 VSS.n80 11.5205
R1004 VSS.n797 VSS.n794 11.5205
R1005 VSS.n800 VSS.n797 11.5205
R1006 VSS.n800 VSS.n78 11.5205
R1007 VSS.n804 VSS.n78 11.5205
R1008 VSS.n807 VSS.n804 11.5205
R1009 VSS.n810 VSS.n807 11.5205
R1010 VSS.n810 VSS.n76 11.5205
R1011 VSS.n814 VSS.n76 11.5205
R1012 VSS.n817 VSS.n814 11.5205
R1013 VSS.n820 VSS.n817 11.5205
R1014 VSS.n820 VSS.n74 11.5205
R1015 VSS.n824 VSS.n74 11.5205
R1016 VSS.n827 VSS.n824 11.5205
R1017 VSS.n830 VSS.n827 11.5205
R1018 VSS.n830 VSS.n72 11.5205
R1019 VSS.n834 VSS.n72 11.5205
R1020 VSS.n837 VSS.n834 11.5205
R1021 VSS.n840 VSS.n837 11.5205
R1022 VSS.n840 VSS.n70 11.5205
R1023 VSS.n844 VSS.n70 11.5205
R1024 VSS.n847 VSS.n844 11.5205
R1025 VSS.n850 VSS.n847 11.5205
R1026 VSS.n850 VSS.n68 11.5205
R1027 VSS.n854 VSS.n68 11.5205
R1028 VSS.n857 VSS.n854 11.5205
R1029 VSS.n860 VSS.n857 11.5205
R1030 VSS.n860 VSS.n66 11.5205
R1031 VSS.n864 VSS.n66 11.5205
R1032 VSS.n867 VSS.n864 11.5205
R1033 VSS.n870 VSS.n867 11.5205
R1034 VSS.n870 VSS.n64 11.5205
R1035 VSS.n874 VSS.n64 11.5205
R1036 VSS.n877 VSS.n874 11.5205
R1037 VSS.n880 VSS.n877 11.5205
R1038 VSS.n880 VSS.n62 11.5205
R1039 VSS.n884 VSS.n62 11.5205
R1040 VSS.n887 VSS.n884 11.5205
R1041 VSS.n890 VSS.n887 11.5205
R1042 VSS.n890 VSS.n60 11.5205
R1043 VSS.n894 VSS.n60 11.5205
R1044 VSS.n897 VSS.n894 11.5205
R1045 VSS.n900 VSS.n897 11.5205
R1046 VSS.n900 VSS.n58 11.5205
R1047 VSS.n904 VSS.n58 11.5205
R1048 VSS.n907 VSS.n904 11.5205
R1049 VSS.n910 VSS.n907 11.5205
R1050 VSS.n910 VSS.n56 11.5205
R1051 VSS.n914 VSS.n56 11.5205
R1052 VSS.n917 VSS.n914 11.5205
R1053 VSS.n920 VSS.n917 11.5205
R1054 VSS.n920 VSS.n54 11.5205
R1055 VSS.n924 VSS.n54 11.5205
R1056 VSS.n927 VSS.n924 11.5205
R1057 VSS.n930 VSS.n927 11.5205
R1058 VSS.n930 VSS.n52 11.5205
R1059 VSS.n934 VSS.n52 11.5205
R1060 VSS.n937 VSS.n934 11.5205
R1061 VSS.n939 VSS.n937 11.5205
R1062 VSS.n939 VSS.n50 11.5205
R1063 VSS.n944 VSS.n50 11.5205
R1064 VSS.n944 VSS.n4 11.5205
R1065 VSS.n950 VSS.n4 11.5205
R1066 VSS.n539 VSS.n228 11.5205
R1067 VSS.n539 VSS.n219 11.5205
R1068 VSS.n552 VSS.n219 11.5205
R1069 VSS.n552 VSS.n217 11.5205
R1070 VSS.n556 VSS.n217 11.5205
R1071 VSS.n556 VSS.n206 11.5205
R1072 VSS.n568 VSS.n206 11.5205
R1073 VSS.n568 VSS.n204 11.5205
R1074 VSS.n572 VSS.n204 11.5205
R1075 VSS.n572 VSS.n195 11.5205
R1076 VSS.n583 VSS.n195 11.5205
R1077 VSS.n583 VSS.n193 11.5205
R1078 VSS.n587 VSS.n193 11.5205
R1079 VSS.n587 VSS.n182 11.5205
R1080 VSS.n599 VSS.n182 11.5205
R1081 VSS.n599 VSS.n180 11.5205
R1082 VSS.n605 VSS.n180 11.5205
R1083 VSS.n605 VSS.n171 11.5205
R1084 VSS.n617 VSS.n171 11.5205
R1085 VSS.n617 VSS.n169 11.5205
R1086 VSS.n621 VSS.n169 11.5205
R1087 VSS.n621 VSS.n159 11.5205
R1088 VSS.n634 VSS.n159 11.5205
R1089 VSS.n634 VSS.n157 11.5205
R1090 VSS.n638 VSS.n157 11.5205
R1091 VSS.n638 VSS.n148 11.5205
R1092 VSS.n650 VSS.n148 11.5205
R1093 VSS.n650 VSS.n146 11.5205
R1094 VSS.n654 VSS.n146 11.5205
R1095 VSS.n654 VSS.n137 11.5205
R1096 VSS.n667 VSS.n137 11.5205
R1097 VSS.n667 VSS.n135 11.5205
R1098 VSS.n671 VSS.n135 11.5205
R1099 VSS.n671 VSS.n125 11.5205
R1100 VSS.n683 VSS.n125 11.5205
R1101 VSS.n683 VSS.n123 11.5205
R1102 VSS.n687 VSS.n123 11.5205
R1103 VSS.n687 VSS.n115 11.5205
R1104 VSS.n700 VSS.n115 11.5205
R1105 VSS.n700 VSS.n113 11.5205
R1106 VSS.n704 VSS.n113 11.5205
R1107 VSS.n704 VSS.n100 11.5205
R1108 VSS.n719 VSS.n100 11.5205
R1109 VSS.n719 VSS.n98 11.5205
R1110 VSS.n723 VSS.n98 11.5205
R1111 VSS.n723 VSS.n2 11.5205
R1112 VSS.n951 VSS.n2 11.5205
R1113 VSS.n530 VSS.n276 11.5205
R1114 VSS.n526 VSS.n276 11.5205
R1115 VSS.n526 VSS.n525 11.5205
R1116 VSS.n525 VSS.n524 11.5205
R1117 VSS.n524 VSS.n281 11.5205
R1118 VSS.n520 VSS.n281 11.5205
R1119 VSS.n520 VSS.n519 11.5205
R1120 VSS.n519 VSS.n518 11.5205
R1121 VSS.n518 VSS.n287 11.5205
R1122 VSS.n514 VSS.n287 11.5205
R1123 VSS.n514 VSS.n513 11.5205
R1124 VSS.n513 VSS.n512 11.5205
R1125 VSS.n512 VSS.n293 11.5205
R1126 VSS.n508 VSS.n293 11.5205
R1127 VSS.n508 VSS.n507 11.5205
R1128 VSS.n507 VSS.n506 11.5205
R1129 VSS.n506 VSS.n299 11.5205
R1130 VSS.n502 VSS.n299 11.5205
R1131 VSS.n502 VSS.n501 11.5205
R1132 VSS.n501 VSS.n500 11.5205
R1133 VSS.n500 VSS.n305 11.5205
R1134 VSS.n496 VSS.n305 11.5205
R1135 VSS.n496 VSS.n495 11.5205
R1136 VSS.n495 VSS.n494 11.5205
R1137 VSS.n494 VSS.n311 11.5205
R1138 VSS.n490 VSS.n311 11.5205
R1139 VSS.n490 VSS.n489 11.5205
R1140 VSS.n489 VSS.n488 11.5205
R1141 VSS.n488 VSS.n317 11.5205
R1142 VSS.n484 VSS.n317 11.5205
R1143 VSS.n484 VSS.n483 11.5205
R1144 VSS.n483 VSS.n482 11.5205
R1145 VSS.n482 VSS.n323 11.5205
R1146 VSS.n478 VSS.n323 11.5205
R1147 VSS.n478 VSS.n477 11.5205
R1148 VSS.n477 VSS.n476 11.5205
R1149 VSS.n476 VSS.n329 11.5205
R1150 VSS.n472 VSS.n329 11.5205
R1151 VSS.n472 VSS.n471 11.5205
R1152 VSS.n471 VSS.n470 11.5205
R1153 VSS.n470 VSS.n335 11.5205
R1154 VSS.n466 VSS.n335 11.5205
R1155 VSS.n466 VSS.n465 11.5205
R1156 VSS.n465 VSS.n464 11.5205
R1157 VSS.n464 VSS.n341 11.5205
R1158 VSS.n460 VSS.n341 11.5205
R1159 VSS.n460 VSS.n459 11.5205
R1160 VSS.n459 VSS.n458 11.5205
R1161 VSS.n458 VSS.n347 11.5205
R1162 VSS.n454 VSS.n347 11.5205
R1163 VSS.n454 VSS.n453 11.5205
R1164 VSS.n453 VSS.n452 11.5205
R1165 VSS.n452 VSS.n353 11.5205
R1166 VSS.n448 VSS.n353 11.5205
R1167 VSS.n448 VSS.n447 11.5205
R1168 VSS.n447 VSS.n446 11.5205
R1169 VSS.n446 VSS.n359 11.5205
R1170 VSS.n442 VSS.n359 11.5205
R1171 VSS.n442 VSS.n441 11.5205
R1172 VSS.n441 VSS.n440 11.5205
R1173 VSS.n440 VSS.n365 11.5205
R1174 VSS.n436 VSS.n365 11.5205
R1175 VSS.n436 VSS.n435 11.5205
R1176 VSS.n435 VSS.n434 11.5205
R1177 VSS.n434 VSS.n371 11.5205
R1178 VSS.n430 VSS.n371 11.5205
R1179 VSS.n430 VSS.n429 11.5205
R1180 VSS.n429 VSS.n428 11.5205
R1181 VSS.n428 VSS.n377 11.5205
R1182 VSS.n424 VSS.n377 11.5205
R1183 VSS.n424 VSS.n423 11.5205
R1184 VSS.n423 VSS.n422 11.5205
R1185 VSS.n422 VSS.n383 11.5205
R1186 VSS.n418 VSS.n383 11.5205
R1187 VSS.n418 VSS.n417 11.5205
R1188 VSS.n417 VSS.n416 11.5205
R1189 VSS.n416 VSS.n389 11.5205
R1190 VSS.n412 VSS.n389 11.5205
R1191 VSS.n412 VSS.n411 11.5205
R1192 VSS.n411 VSS.n410 11.5205
R1193 VSS.n410 VSS.n395 11.5205
R1194 VSS.n406 VSS.n395 11.5205
R1195 VSS.n406 VSS.n405 11.5205
R1196 VSS.n405 VSS.n404 11.5205
R1197 VSS.n404 VSS.n401 11.5205
R1198 VSS.n401 VSS.n230 11.5205
R1199 VSS.n535 VSS.n230 11.5205
R1200 VSS.n209 VSS.t16 10.049
R1201 VSS.t13 VSS.n184 10.049
R1202 VSS.n673 VSS.t1 10.049
R1203 VSS.n698 VSS.t3 10.049
R1204 VSS.n530 VSS.n529 9.3005
R1205 VSS.n528 VSS.n276 9.3005
R1206 VSS.n527 VSS.n526 9.3005
R1207 VSS.n525 VSS.n277 9.3005
R1208 VSS.n524 VSS.n523 9.3005
R1209 VSS.n522 VSS.n281 9.3005
R1210 VSS.n521 VSS.n520 9.3005
R1211 VSS.n519 VSS.n282 9.3005
R1212 VSS.n518 VSS.n517 9.3005
R1213 VSS.n516 VSS.n287 9.3005
R1214 VSS.n515 VSS.n514 9.3005
R1215 VSS.n513 VSS.n288 9.3005
R1216 VSS.n512 VSS.n511 9.3005
R1217 VSS.n510 VSS.n293 9.3005
R1218 VSS.n509 VSS.n508 9.3005
R1219 VSS.n507 VSS.n294 9.3005
R1220 VSS.n506 VSS.n505 9.3005
R1221 VSS.n504 VSS.n299 9.3005
R1222 VSS.n503 VSS.n502 9.3005
R1223 VSS.n501 VSS.n300 9.3005
R1224 VSS.n500 VSS.n499 9.3005
R1225 VSS.n498 VSS.n305 9.3005
R1226 VSS.n497 VSS.n496 9.3005
R1227 VSS.n495 VSS.n306 9.3005
R1228 VSS.n494 VSS.n493 9.3005
R1229 VSS.n492 VSS.n311 9.3005
R1230 VSS.n491 VSS.n490 9.3005
R1231 VSS.n489 VSS.n312 9.3005
R1232 VSS.n488 VSS.n487 9.3005
R1233 VSS.n486 VSS.n317 9.3005
R1234 VSS.n485 VSS.n484 9.3005
R1235 VSS.n483 VSS.n318 9.3005
R1236 VSS.n482 VSS.n481 9.3005
R1237 VSS.n480 VSS.n323 9.3005
R1238 VSS.n479 VSS.n478 9.3005
R1239 VSS.n477 VSS.n324 9.3005
R1240 VSS.n476 VSS.n475 9.3005
R1241 VSS.n474 VSS.n329 9.3005
R1242 VSS.n473 VSS.n472 9.3005
R1243 VSS.n471 VSS.n330 9.3005
R1244 VSS.n470 VSS.n469 9.3005
R1245 VSS.n468 VSS.n335 9.3005
R1246 VSS.n467 VSS.n466 9.3005
R1247 VSS.n465 VSS.n336 9.3005
R1248 VSS.n464 VSS.n463 9.3005
R1249 VSS.n462 VSS.n341 9.3005
R1250 VSS.n461 VSS.n460 9.3005
R1251 VSS.n459 VSS.n342 9.3005
R1252 VSS.n458 VSS.n457 9.3005
R1253 VSS.n456 VSS.n347 9.3005
R1254 VSS.n455 VSS.n454 9.3005
R1255 VSS.n453 VSS.n348 9.3005
R1256 VSS.n452 VSS.n451 9.3005
R1257 VSS.n450 VSS.n353 9.3005
R1258 VSS.n449 VSS.n448 9.3005
R1259 VSS.n447 VSS.n354 9.3005
R1260 VSS.n446 VSS.n445 9.3005
R1261 VSS.n444 VSS.n359 9.3005
R1262 VSS.n443 VSS.n442 9.3005
R1263 VSS.n441 VSS.n360 9.3005
R1264 VSS.n440 VSS.n439 9.3005
R1265 VSS.n438 VSS.n365 9.3005
R1266 VSS.n437 VSS.n436 9.3005
R1267 VSS.n435 VSS.n366 9.3005
R1268 VSS.n434 VSS.n433 9.3005
R1269 VSS.n432 VSS.n371 9.3005
R1270 VSS.n431 VSS.n430 9.3005
R1271 VSS.n429 VSS.n372 9.3005
R1272 VSS.n428 VSS.n427 9.3005
R1273 VSS.n426 VSS.n377 9.3005
R1274 VSS.n425 VSS.n424 9.3005
R1275 VSS.n423 VSS.n378 9.3005
R1276 VSS.n422 VSS.n421 9.3005
R1277 VSS.n420 VSS.n383 9.3005
R1278 VSS.n419 VSS.n418 9.3005
R1279 VSS.n417 VSS.n384 9.3005
R1280 VSS.n416 VSS.n415 9.3005
R1281 VSS.n414 VSS.n389 9.3005
R1282 VSS.n413 VSS.n412 9.3005
R1283 VSS.n411 VSS.n390 9.3005
R1284 VSS.n410 VSS.n409 9.3005
R1285 VSS.n408 VSS.n395 9.3005
R1286 VSS.n407 VSS.n406 9.3005
R1287 VSS.n405 VSS.n396 9.3005
R1288 VSS.n404 VSS.n403 9.3005
R1289 VSS.n402 VSS.n401 9.3005
R1290 VSS.n230 VSS.n229 9.3005
R1291 VSS.n536 VSS.n535 9.3005
R1292 VSS.n224 VSS.n223 9.3005
R1293 VSS.n545 VSS.n544 9.3005
R1294 VSS.n546 VSS.n222 9.3005
R1295 VSS.n548 VSS.n547 9.3005
R1296 VSS.n213 VSS.n212 9.3005
R1297 VSS.n561 VSS.n560 9.3005
R1298 VSS.n562 VSS.n211 9.3005
R1299 VSS.n564 VSS.n563 9.3005
R1300 VSS.n201 VSS.n200 9.3005
R1301 VSS.n577 VSS.n576 9.3005
R1302 VSS.n578 VSS.n199 9.3005
R1303 VSS.n580 VSS.n579 9.3005
R1304 VSS.n189 VSS.n188 9.3005
R1305 VSS.n592 VSS.n591 9.3005
R1306 VSS.n593 VSS.n187 9.3005
R1307 VSS.n595 VSS.n594 9.3005
R1308 VSS.n177 VSS.n176 9.3005
R1309 VSS.n610 VSS.n609 9.3005
R1310 VSS.n611 VSS.n175 9.3005
R1311 VSS.n613 VSS.n612 9.3005
R1312 VSS.n165 VSS.n164 9.3005
R1313 VSS.n627 VSS.n626 9.3005
R1314 VSS.n628 VSS.n163 9.3005
R1315 VSS.n630 VSS.n629 9.3005
R1316 VSS.n154 VSS.n153 9.3005
R1317 VSS.n643 VSS.n642 9.3005
R1318 VSS.n644 VSS.n152 9.3005
R1319 VSS.n646 VSS.n645 9.3005
R1320 VSS.n142 VSS.n141 9.3005
R1321 VSS.n660 VSS.n659 9.3005
R1322 VSS.n661 VSS.n140 9.3005
R1323 VSS.n663 VSS.n662 9.3005
R1324 VSS.n131 VSS.n130 9.3005
R1325 VSS.n676 VSS.n675 9.3005
R1326 VSS.n677 VSS.n129 9.3005
R1327 VSS.n679 VSS.n678 9.3005
R1328 VSS.n120 VSS.n119 9.3005
R1329 VSS.n693 VSS.n692 9.3005
R1330 VSS.n694 VSS.n118 9.3005
R1331 VSS.n696 VSS.n695 9.3005
R1332 VSS.n109 VSS.n108 9.3005
R1333 VSS.n709 VSS.n708 9.3005
R1334 VSS.n710 VSS.n106 9.3005
R1335 VSS.n715 VSS.n714 9.3005
R1336 VSS.n713 VSS.n107 9.3005
R1337 VSS.n712 VSS.n711 9.3005
R1338 VSS.n94 VSS.n93 9.3005
R1339 VSS.n731 VSS.n730 9.3005
R1340 VSS.n950 VSS.n0 9.3005
R1341 VSS.n942 VSS.n4 9.3005
R1342 VSS.n944 VSS.n943 9.3005
R1343 VSS.n941 VSS.n50 9.3005
R1344 VSS.n940 VSS.n939 9.3005
R1345 VSS.n937 VSS.n51 9.3005
R1346 VSS.n934 VSS.n933 9.3005
R1347 VSS.n932 VSS.n52 9.3005
R1348 VSS.n931 VSS.n930 9.3005
R1349 VSS.n927 VSS.n53 9.3005
R1350 VSS.n924 VSS.n923 9.3005
R1351 VSS.n922 VSS.n54 9.3005
R1352 VSS.n921 VSS.n920 9.3005
R1353 VSS.n917 VSS.n55 9.3005
R1354 VSS.n914 VSS.n913 9.3005
R1355 VSS.n912 VSS.n56 9.3005
R1356 VSS.n911 VSS.n910 9.3005
R1357 VSS.n907 VSS.n57 9.3005
R1358 VSS.n904 VSS.n903 9.3005
R1359 VSS.n902 VSS.n58 9.3005
R1360 VSS.n901 VSS.n900 9.3005
R1361 VSS.n897 VSS.n59 9.3005
R1362 VSS.n894 VSS.n893 9.3005
R1363 VSS.n892 VSS.n60 9.3005
R1364 VSS.n891 VSS.n890 9.3005
R1365 VSS.n887 VSS.n61 9.3005
R1366 VSS.n884 VSS.n883 9.3005
R1367 VSS.n882 VSS.n62 9.3005
R1368 VSS.n881 VSS.n880 9.3005
R1369 VSS.n877 VSS.n63 9.3005
R1370 VSS.n874 VSS.n873 9.3005
R1371 VSS.n872 VSS.n64 9.3005
R1372 VSS.n871 VSS.n870 9.3005
R1373 VSS.n867 VSS.n65 9.3005
R1374 VSS.n864 VSS.n863 9.3005
R1375 VSS.n862 VSS.n66 9.3005
R1376 VSS.n861 VSS.n860 9.3005
R1377 VSS.n857 VSS.n67 9.3005
R1378 VSS.n854 VSS.n853 9.3005
R1379 VSS.n852 VSS.n68 9.3005
R1380 VSS.n851 VSS.n850 9.3005
R1381 VSS.n847 VSS.n69 9.3005
R1382 VSS.n844 VSS.n843 9.3005
R1383 VSS.n842 VSS.n70 9.3005
R1384 VSS.n841 VSS.n840 9.3005
R1385 VSS.n837 VSS.n71 9.3005
R1386 VSS.n834 VSS.n833 9.3005
R1387 VSS.n832 VSS.n72 9.3005
R1388 VSS.n831 VSS.n830 9.3005
R1389 VSS.n827 VSS.n73 9.3005
R1390 VSS.n824 VSS.n823 9.3005
R1391 VSS.n822 VSS.n74 9.3005
R1392 VSS.n821 VSS.n820 9.3005
R1393 VSS.n817 VSS.n75 9.3005
R1394 VSS.n814 VSS.n813 9.3005
R1395 VSS.n812 VSS.n76 9.3005
R1396 VSS.n811 VSS.n810 9.3005
R1397 VSS.n807 VSS.n77 9.3005
R1398 VSS.n804 VSS.n803 9.3005
R1399 VSS.n802 VSS.n78 9.3005
R1400 VSS.n801 VSS.n800 9.3005
R1401 VSS.n797 VSS.n79 9.3005
R1402 VSS.n794 VSS.n793 9.3005
R1403 VSS.n792 VSS.n80 9.3005
R1404 VSS.n791 VSS.n790 9.3005
R1405 VSS.n787 VSS.n81 9.3005
R1406 VSS.n784 VSS.n783 9.3005
R1407 VSS.n782 VSS.n82 9.3005
R1408 VSS.n781 VSS.n780 9.3005
R1409 VSS.n777 VSS.n83 9.3005
R1410 VSS.n774 VSS.n773 9.3005
R1411 VSS.n772 VSS.n84 9.3005
R1412 VSS.n771 VSS.n770 9.3005
R1413 VSS.n767 VSS.n85 9.3005
R1414 VSS.n764 VSS.n763 9.3005
R1415 VSS.n762 VSS.n86 9.3005
R1416 VSS.n761 VSS.n760 9.3005
R1417 VSS.n757 VSS.n87 9.3005
R1418 VSS.n754 VSS.n753 9.3005
R1419 VSS.n752 VSS.n88 9.3005
R1420 VSS.n751 VSS.n750 9.3005
R1421 VSS.n747 VSS.n89 9.3005
R1422 VSS.n744 VSS.n743 9.3005
R1423 VSS.n742 VSS.n90 9.3005
R1424 VSS.n741 VSS.n740 9.3005
R1425 VSS.n737 VSS.n91 9.3005
R1426 VSS.n734 VSS.n733 9.3005
R1427 VSS.n732 VSS.n92 9.3005
R1428 VSS.n952 VSS.n951 9.3005
R1429 VSS.n2 VSS.n1 9.3005
R1430 VSS.n723 VSS.n722 9.3005
R1431 VSS.n721 VSS.n98 9.3005
R1432 VSS.n720 VSS.n719 9.3005
R1433 VSS.n100 VSS.n99 9.3005
R1434 VSS.n704 VSS.n703 9.3005
R1435 VSS.n702 VSS.n113 9.3005
R1436 VSS.n701 VSS.n700 9.3005
R1437 VSS.n115 VSS.n114 9.3005
R1438 VSS.n687 VSS.n686 9.3005
R1439 VSS.n685 VSS.n123 9.3005
R1440 VSS.n684 VSS.n683 9.3005
R1441 VSS.n125 VSS.n124 9.3005
R1442 VSS.n671 VSS.n670 9.3005
R1443 VSS.n669 VSS.n135 9.3005
R1444 VSS.n668 VSS.n667 9.3005
R1445 VSS.n137 VSS.n136 9.3005
R1446 VSS.n654 VSS.n653 9.3005
R1447 VSS.n652 VSS.n146 9.3005
R1448 VSS.n651 VSS.n650 9.3005
R1449 VSS.n148 VSS.n147 9.3005
R1450 VSS.n638 VSS.n637 9.3005
R1451 VSS.n636 VSS.n157 9.3005
R1452 VSS.n635 VSS.n634 9.3005
R1453 VSS.n159 VSS.n158 9.3005
R1454 VSS.n621 VSS.n620 9.3005
R1455 VSS.n619 VSS.n169 9.3005
R1456 VSS.n618 VSS.n617 9.3005
R1457 VSS.n171 VSS.n170 9.3005
R1458 VSS.n605 VSS.n604 9.3005
R1459 VSS.n601 VSS.n180 9.3005
R1460 VSS.n600 VSS.n599 9.3005
R1461 VSS.n182 VSS.n181 9.3005
R1462 VSS.n587 VSS.n586 9.3005
R1463 VSS.n585 VSS.n193 9.3005
R1464 VSS.n584 VSS.n583 9.3005
R1465 VSS.n195 VSS.n194 9.3005
R1466 VSS.n572 VSS.n571 9.3005
R1467 VSS.n570 VSS.n204 9.3005
R1468 VSS.n569 VSS.n568 9.3005
R1469 VSS.n206 VSS.n205 9.3005
R1470 VSS.n556 VSS.n555 9.3005
R1471 VSS.n554 VSS.n217 9.3005
R1472 VSS.n553 VSS.n552 9.3005
R1473 VSS.n219 VSS.n218 9.3005
R1474 VSS.n539 VSS.n538 9.3005
R1475 VSS.n537 VSS.n228 9.3005
R1476 VSS.n623 VSS.t5 5.02477
R1477 VSS.n640 VSS.t8 5.02477
R1478 VSS VSS.n953 1.38998
R1479 VSS.n529 VSS.n223 0.270812
R1480 VSS.n732 VSS.n731 0.270812
R1481 VSS.n537 VSS.n536 0.147115
R1482 VSS.n953 VSS.n0 0.122375
R1483 VSS.n529 VSS.n528 0.113
R1484 VSS.n528 VSS.n527 0.113
R1485 VSS.n527 VSS.n277 0.113
R1486 VSS.n523 VSS.n277 0.113
R1487 VSS.n523 VSS.n522 0.113
R1488 VSS.n522 VSS.n521 0.113
R1489 VSS.n521 VSS.n282 0.113
R1490 VSS.n517 VSS.n282 0.113
R1491 VSS.n517 VSS.n516 0.113
R1492 VSS.n516 VSS.n515 0.113
R1493 VSS.n515 VSS.n288 0.113
R1494 VSS.n511 VSS.n288 0.113
R1495 VSS.n511 VSS.n510 0.113
R1496 VSS.n510 VSS.n509 0.113
R1497 VSS.n509 VSS.n294 0.113
R1498 VSS.n505 VSS.n294 0.113
R1499 VSS.n505 VSS.n504 0.113
R1500 VSS.n504 VSS.n503 0.113
R1501 VSS.n503 VSS.n300 0.113
R1502 VSS.n499 VSS.n300 0.113
R1503 VSS.n499 VSS.n498 0.113
R1504 VSS.n498 VSS.n497 0.113
R1505 VSS.n497 VSS.n306 0.113
R1506 VSS.n493 VSS.n306 0.113
R1507 VSS.n493 VSS.n492 0.113
R1508 VSS.n492 VSS.n491 0.113
R1509 VSS.n491 VSS.n312 0.113
R1510 VSS.n487 VSS.n312 0.113
R1511 VSS.n487 VSS.n486 0.113
R1512 VSS.n486 VSS.n485 0.113
R1513 VSS.n485 VSS.n318 0.113
R1514 VSS.n481 VSS.n318 0.113
R1515 VSS.n481 VSS.n480 0.113
R1516 VSS.n480 VSS.n479 0.113
R1517 VSS.n479 VSS.n324 0.113
R1518 VSS.n475 VSS.n324 0.113
R1519 VSS.n475 VSS.n474 0.113
R1520 VSS.n474 VSS.n473 0.113
R1521 VSS.n473 VSS.n330 0.113
R1522 VSS.n469 VSS.n330 0.113
R1523 VSS.n469 VSS.n468 0.113
R1524 VSS.n468 VSS.n467 0.113
R1525 VSS.n467 VSS.n336 0.113
R1526 VSS.n463 VSS.n336 0.113
R1527 VSS.n463 VSS.n462 0.113
R1528 VSS.n462 VSS.n461 0.113
R1529 VSS.n461 VSS.n342 0.113
R1530 VSS.n457 VSS.n342 0.113
R1531 VSS.n457 VSS.n456 0.113
R1532 VSS.n456 VSS.n455 0.113
R1533 VSS.n455 VSS.n348 0.113
R1534 VSS.n451 VSS.n348 0.113
R1535 VSS.n451 VSS.n450 0.113
R1536 VSS.n450 VSS.n449 0.113
R1537 VSS.n449 VSS.n354 0.113
R1538 VSS.n445 VSS.n354 0.113
R1539 VSS.n445 VSS.n444 0.113
R1540 VSS.n444 VSS.n443 0.113
R1541 VSS.n443 VSS.n360 0.113
R1542 VSS.n439 VSS.n360 0.113
R1543 VSS.n439 VSS.n438 0.113
R1544 VSS.n438 VSS.n437 0.113
R1545 VSS.n437 VSS.n366 0.113
R1546 VSS.n433 VSS.n366 0.113
R1547 VSS.n433 VSS.n432 0.113
R1548 VSS.n432 VSS.n431 0.113
R1549 VSS.n431 VSS.n372 0.113
R1550 VSS.n427 VSS.n372 0.113
R1551 VSS.n427 VSS.n426 0.113
R1552 VSS.n426 VSS.n425 0.113
R1553 VSS.n425 VSS.n378 0.113
R1554 VSS.n421 VSS.n378 0.113
R1555 VSS.n421 VSS.n420 0.113
R1556 VSS.n420 VSS.n419 0.113
R1557 VSS.n419 VSS.n384 0.113
R1558 VSS.n415 VSS.n384 0.113
R1559 VSS.n415 VSS.n414 0.113
R1560 VSS.n414 VSS.n413 0.113
R1561 VSS.n413 VSS.n390 0.113
R1562 VSS.n409 VSS.n390 0.113
R1563 VSS.n409 VSS.n408 0.113
R1564 VSS.n408 VSS.n407 0.113
R1565 VSS.n407 VSS.n396 0.113
R1566 VSS.n403 VSS.n396 0.113
R1567 VSS.n403 VSS.n402 0.113
R1568 VSS.n402 VSS.n229 0.113
R1569 VSS.n536 VSS.n229 0.113
R1570 VSS.n545 VSS.n223 0.113
R1571 VSS.n546 VSS.n545 0.113
R1572 VSS.n547 VSS.n546 0.113
R1573 VSS.n547 VSS.n212 0.113
R1574 VSS.n561 VSS.n212 0.113
R1575 VSS.n562 VSS.n561 0.113
R1576 VSS.n563 VSS.n562 0.113
R1577 VSS.n563 VSS.n200 0.113
R1578 VSS.n577 VSS.n200 0.113
R1579 VSS.n578 VSS.n577 0.113
R1580 VSS.n579 VSS.n578 0.113
R1581 VSS.n579 VSS.n188 0.113
R1582 VSS.n592 VSS.n188 0.113
R1583 VSS.n593 VSS.n592 0.113
R1584 VSS.n594 VSS.n593 0.113
R1585 VSS.n594 VSS.n176 0.113
R1586 VSS.n610 VSS.n176 0.113
R1587 VSS.n611 VSS.n610 0.113
R1588 VSS.n612 VSS.n611 0.113
R1589 VSS.n612 VSS.n164 0.113
R1590 VSS.n627 VSS.n164 0.113
R1591 VSS.n628 VSS.n627 0.113
R1592 VSS.n629 VSS.n628 0.113
R1593 VSS.n629 VSS.n153 0.113
R1594 VSS.n643 VSS.n153 0.113
R1595 VSS.n644 VSS.n643 0.113
R1596 VSS.n645 VSS.n644 0.113
R1597 VSS.n645 VSS.n141 0.113
R1598 VSS.n660 VSS.n141 0.113
R1599 VSS.n661 VSS.n660 0.113
R1600 VSS.n662 VSS.n661 0.113
R1601 VSS.n662 VSS.n130 0.113
R1602 VSS.n676 VSS.n130 0.113
R1603 VSS.n677 VSS.n676 0.113
R1604 VSS.n678 VSS.n677 0.113
R1605 VSS.n678 VSS.n119 0.113
R1606 VSS.n693 VSS.n119 0.113
R1607 VSS.n694 VSS.n693 0.113
R1608 VSS.n695 VSS.n694 0.113
R1609 VSS.n695 VSS.n108 0.113
R1610 VSS.n709 VSS.n108 0.113
R1611 VSS.n710 VSS.n709 0.113
R1612 VSS.n714 VSS.n710 0.113
R1613 VSS.n714 VSS.n713 0.113
R1614 VSS.n713 VSS.n712 0.113
R1615 VSS.n712 VSS.n93 0.113
R1616 VSS.n731 VSS.n93 0.113
R1617 VSS.n733 VSS.n732 0.113
R1618 VSS.n733 VSS.n91 0.113
R1619 VSS.n741 VSS.n91 0.113
R1620 VSS.n742 VSS.n741 0.113
R1621 VSS.n743 VSS.n742 0.113
R1622 VSS.n743 VSS.n89 0.113
R1623 VSS.n751 VSS.n89 0.113
R1624 VSS.n752 VSS.n751 0.113
R1625 VSS.n753 VSS.n752 0.113
R1626 VSS.n753 VSS.n87 0.113
R1627 VSS.n761 VSS.n87 0.113
R1628 VSS.n762 VSS.n761 0.113
R1629 VSS.n763 VSS.n762 0.113
R1630 VSS.n763 VSS.n85 0.113
R1631 VSS.n771 VSS.n85 0.113
R1632 VSS.n772 VSS.n771 0.113
R1633 VSS.n773 VSS.n772 0.113
R1634 VSS.n773 VSS.n83 0.113
R1635 VSS.n781 VSS.n83 0.113
R1636 VSS.n782 VSS.n781 0.113
R1637 VSS.n783 VSS.n782 0.113
R1638 VSS.n783 VSS.n81 0.113
R1639 VSS.n791 VSS.n81 0.113
R1640 VSS.n792 VSS.n791 0.113
R1641 VSS.n793 VSS.n792 0.113
R1642 VSS.n793 VSS.n79 0.113
R1643 VSS.n801 VSS.n79 0.113
R1644 VSS.n802 VSS.n801 0.113
R1645 VSS.n803 VSS.n802 0.113
R1646 VSS.n803 VSS.n77 0.113
R1647 VSS.n811 VSS.n77 0.113
R1648 VSS.n812 VSS.n811 0.113
R1649 VSS.n813 VSS.n812 0.113
R1650 VSS.n813 VSS.n75 0.113
R1651 VSS.n821 VSS.n75 0.113
R1652 VSS.n822 VSS.n821 0.113
R1653 VSS.n823 VSS.n822 0.113
R1654 VSS.n823 VSS.n73 0.113
R1655 VSS.n831 VSS.n73 0.113
R1656 VSS.n832 VSS.n831 0.113
R1657 VSS.n833 VSS.n832 0.113
R1658 VSS.n833 VSS.n71 0.113
R1659 VSS.n841 VSS.n71 0.113
R1660 VSS.n842 VSS.n841 0.113
R1661 VSS.n843 VSS.n842 0.113
R1662 VSS.n843 VSS.n69 0.113
R1663 VSS.n851 VSS.n69 0.113
R1664 VSS.n852 VSS.n851 0.113
R1665 VSS.n853 VSS.n852 0.113
R1666 VSS.n853 VSS.n67 0.113
R1667 VSS.n861 VSS.n67 0.113
R1668 VSS.n862 VSS.n861 0.113
R1669 VSS.n863 VSS.n862 0.113
R1670 VSS.n863 VSS.n65 0.113
R1671 VSS.n871 VSS.n65 0.113
R1672 VSS.n872 VSS.n871 0.113
R1673 VSS.n873 VSS.n872 0.113
R1674 VSS.n873 VSS.n63 0.113
R1675 VSS.n881 VSS.n63 0.113
R1676 VSS.n882 VSS.n881 0.113
R1677 VSS.n883 VSS.n882 0.113
R1678 VSS.n883 VSS.n61 0.113
R1679 VSS.n891 VSS.n61 0.113
R1680 VSS.n892 VSS.n891 0.113
R1681 VSS.n893 VSS.n892 0.113
R1682 VSS.n893 VSS.n59 0.113
R1683 VSS.n901 VSS.n59 0.113
R1684 VSS.n902 VSS.n901 0.113
R1685 VSS.n903 VSS.n902 0.113
R1686 VSS.n903 VSS.n57 0.113
R1687 VSS.n911 VSS.n57 0.113
R1688 VSS.n912 VSS.n911 0.113
R1689 VSS.n913 VSS.n912 0.113
R1690 VSS.n913 VSS.n55 0.113
R1691 VSS.n921 VSS.n55 0.113
R1692 VSS.n922 VSS.n921 0.113
R1693 VSS.n923 VSS.n922 0.113
R1694 VSS.n923 VSS.n53 0.113
R1695 VSS.n931 VSS.n53 0.113
R1696 VSS.n932 VSS.n931 0.113
R1697 VSS.n933 VSS.n932 0.113
R1698 VSS.n933 VSS.n51 0.113
R1699 VSS.n940 VSS.n51 0.113
R1700 VSS.n941 VSS.n940 0.113
R1701 VSS.n943 VSS.n941 0.113
R1702 VSS.n943 VSS.n942 0.113
R1703 VSS.n942 VSS.n0 0.113
R1704 VSS.n602 VSS.t10 0.063146
R1705 VSS.n602 VSS.t11 0.0255461
R1706 VSS.n953 VSS.n952 0.0252396
R1707 VSS.n538 VSS.n537 0.01925
R1708 VSS.n538 VSS.n218 0.01925
R1709 VSS.n553 VSS.n218 0.01925
R1710 VSS.n554 VSS.n553 0.01925
R1711 VSS.n555 VSS.n554 0.01925
R1712 VSS.n555 VSS.n205 0.01925
R1713 VSS.n569 VSS.n205 0.01925
R1714 VSS.n570 VSS.n569 0.01925
R1715 VSS.n571 VSS.n570 0.01925
R1716 VSS.n571 VSS.n194 0.01925
R1717 VSS.n584 VSS.n194 0.01925
R1718 VSS.n585 VSS.n584 0.01925
R1719 VSS.n586 VSS.n585 0.01925
R1720 VSS.n586 VSS.n181 0.01925
R1721 VSS.n600 VSS.n181 0.01925
R1722 VSS.n601 VSS.n600 0.01925
R1723 VSS.n604 VSS.n170 0.01925
R1724 VSS.n618 VSS.n170 0.01925
R1725 VSS.n619 VSS.n618 0.01925
R1726 VSS.n620 VSS.n619 0.01925
R1727 VSS.n620 VSS.n158 0.01925
R1728 VSS.n635 VSS.n158 0.01925
R1729 VSS.n636 VSS.n635 0.01925
R1730 VSS.n637 VSS.n636 0.01925
R1731 VSS.n637 VSS.n147 0.01925
R1732 VSS.n651 VSS.n147 0.01925
R1733 VSS.n652 VSS.n651 0.01925
R1734 VSS.n653 VSS.n652 0.01925
R1735 VSS.n653 VSS.n136 0.01925
R1736 VSS.n668 VSS.n136 0.01925
R1737 VSS.n669 VSS.n668 0.01925
R1738 VSS.n670 VSS.n669 0.01925
R1739 VSS.n670 VSS.n124 0.01925
R1740 VSS.n684 VSS.n124 0.01925
R1741 VSS.n685 VSS.n684 0.01925
R1742 VSS.n686 VSS.n685 0.01925
R1743 VSS.n686 VSS.n114 0.01925
R1744 VSS.n701 VSS.n114 0.01925
R1745 VSS.n702 VSS.n701 0.01925
R1746 VSS.n703 VSS.n702 0.01925
R1747 VSS.n703 VSS.n99 0.01925
R1748 VSS.n720 VSS.n99 0.01925
R1749 VSS.n721 VSS.n720 0.01925
R1750 VSS.n722 VSS.n721 0.01925
R1751 VSS.n722 VSS.n1 0.01925
R1752 VSS.n952 VSS.n1 0.01925
R1753 VSS.n603 VSS.n601 0.0148229
R1754 VSS.n603 VSS.n602 0.00865106
R1755 VSS.n604 VSS.n603 0.00492708
C0 out r7 0.0234f
C1 out r1 0.01632f
C2 out r5 0.01604f
C3 r4 r6 0.2514f
C4 in r2 0.25168f
C5 r15 out 0.01632f
C6 r11 out 0.01604f
C7 r8 out 0
C8 r12 r10 0.2514f
C9 out r10 0
C10 r9 r7 0.2514f
C11 out r3 0.01604f
C12 r15 r13 0.2514f
C13 r13 r11 0.2514f
C14 r11 r9 0.2514f
C15 r4 r2 0.2514f
C16 r5 r7 0.2514f
C17 r8 in 0
C18 r12 out 0
C19 r4 in 0
C20 r13 out 0.01604f
C21 r1 r3 0.2514f
C22 r6 in 0
C23 r9 out 0.0234f
C24 r5 r3 0.2514f
C25 r8 r10 0.2514f
C26 r8 r6 0.2514f
C27 r14 r12 0.2514f
C28 r14 out 0.25168f
C29 out VSS 26.69348f
C30 in VSS 7.20964f
C31 r15 VSS 0.84889f
C32 r14 VSS 0.7099f
C33 r13 VSS 0.63958f
C34 r12 VSS 0.70971f
C35 r11 VSS 0.6398f
C36 r10 VSS 0.70679f
C37 r9 VSS 0.60303f
C38 r8 VSS 0.63878f
C39 r7 VSS 0.60303f
C40 r6 VSS 0.70679f
C41 r5 VSS 0.6398f
C42 r4 VSS 0.70971f
C43 r3 VSS 0.63958f
C44 r2 VSS 0.7099f
C45 r1 VSS 0.84623f
C46 in.n0 VSS 0.00201f
C47 in.n1 VSS 0.00198f
C48 in.n2 VSS 0
C49 in.n3 VSS 0.00146f
C50 in.n4 VSS 0.00176f
C51 in.t0 VSS 0
C52 in.n5 VSS 0.0019f
C53 in.n6 VSS 0.00176f
C54 in.n7 VSS 0
C55 in.n8 VSS 0.00131f
C56 in.n9 VSS 0.00131f
C57 in.n10 VSS 0.00569f
C58 in.n11 VSS 0.00201f
C59 in.n12 VSS 0.00133f
C60 in.n13 VSS 0.00176f
C61 in.n14 VSS 0.0035f
C62 in.n15 VSS 0.06832f
C63 out.t2 VSS 0.19044f
C64 out.t1 VSS 0.18183f
C65 out.n0 VSS 0.00822f
C66 out.n1 VSS 0
C67 out.n2 VSS 0
C68 out.n3 VSS 0
C69 out.n4 VSS 0
C70 out.n5 VSS 0
C71 out.t0 VSS 0
C72 out.n6 VSS 0
C73 out.n7 VSS 0
C74 out.n8 VSS 0
C75 out.n9 VSS 0
C76 out.n10 VSS 0
C77 out.n11 VSS 0
C78 out.n12 VSS 0
C79 out.n13 VSS 0
C80 out.n14 VSS 0
C81 out.n15 VSS 0
C82 out.n16 VSS 0.00162f
.ends
