* lpf_rc: magic R+C extraction of layout/lpf_rc.gds (layout/pex.sh)
.subckt lpf_rc in out VSS
X0 out VSS.t10 sky130_fd_pr__cap_mim_m3_1 l=30 w=30
X1 r13 r12 VSS.t9 sky130_fd_pr__res_xhigh_po_0p35 l=25
X2 r15 r14 VSS.t15 sky130_fd_pr__res_xhigh_po_0p35 l=25
X3 r7 r8 VSS.t8 sky130_fd_pr__res_xhigh_po_0p35 l=25
X4 r9 r10 VSS.t16 sky130_fd_pr__res_xhigh_po_0p35 l=25
X5 r11 r12 VSS.t14 sky130_fd_pr__res_xhigh_po_0p35 l=25
X6 r3 r2 VSS.t3 sky130_fd_pr__res_xhigh_po_0p35 l=25
X7 r5 r4 VSS.t1 sky130_fd_pr__res_xhigh_po_0p35 l=25
X8 r7 r6 VSS.t6 sky130_fd_pr__res_xhigh_po_0p35 l=25
X9 r1 r2 VSS.t0 sky130_fd_pr__res_xhigh_po_0p35 l=25
X10 out VSS.t10 sky130_fd_pr__cap_mim_m3_1 l=30 w=30
X11 r13 r14 VSS.t17 sky130_fd_pr__res_xhigh_po_0p35 l=25
X12 r15 out VSS.t18 sky130_fd_pr__res_xhigh_po_0p35 l=25
X13 r9 r8 VSS.t5 sky130_fd_pr__res_xhigh_po_0p35 l=25
X14 r11 r10 VSS.t13 sky130_fd_pr__res_xhigh_po_0p35 l=25
X15 r3 r4 VSS.t2 sky130_fd_pr__res_xhigh_po_0p35 l=25
X16 r5 r6 VSS.t4 sky130_fd_pr__res_xhigh_po_0p35 l=25
X17 r1 in VSS.t7 sky130_fd_pr__res_xhigh_po_0p35 l=25
R0 VSS.n548 VSS.n547 585
R1 VSS.n333 VSS.n332 585
R2 VSS.n478 VSS.n477 585
R3 VSS.n479 VSS.n476 585
R4 VSS.n480 VSS.n475 585
R5 VSS.n481 VSS.n474 585
R6 VSS.n473 VSS.n472 585
R7 VSS.n482 VSS.n471 585
R8 VSS.n483 VSS.n470 585
R9 VSS.n484 VSS.n469 585
R10 VSS.n468 VSS.n467 585
R11 VSS.n485 VSS.n466 585
R12 VSS.n545 VSS.n351 585
R13 VSS.n486 VSS.n351 585
R14 VSS.n487 VSS.n465 585
R15 VSS.n464 VSS.n463 585
R16 VSS.n488 VSS.n462 585
R17 VSS.n489 VSS.n461 585
R18 VSS.n490 VSS.n460 585
R19 VSS.n459 VSS.n458 585
R20 VSS.n545 VSS.n359 585
R21 VSS.n491 VSS.n359 585
R22 VSS.n492 VSS.n457 585
R23 VSS.n493 VSS.n456 585
R24 VSS.n455 VSS.n454 585
R25 VSS.n494 VSS.n453 585
R26 VSS.n495 VSS.n452 585
R27 VSS.n496 VSS.n451 585
R28 VSS.n450 VSS.n449 585
R29 VSS.n497 VSS.n448 585
R30 VSS.n498 VSS.n447 585
R31 VSS.n499 VSS.n446 585
R32 VSS.n445 VSS.n444 585
R33 VSS.n500 VSS.n443 585
R34 VSS.n501 VSS.n442 585
R35 VSS.n502 VSS.n441 585
R36 VSS.n440 VSS.n439 585
R37 VSS.n503 VSS.n438 585
R38 VSS.n504 VSS.n437 585
R39 VSS.n505 VSS.n436 585
R40 VSS.n435 VSS.n434 585
R41 VSS.n506 VSS.n433 585
R42 VSS.n507 VSS.n432 585
R43 VSS.n508 VSS.n431 585
R44 VSS.n430 VSS.n429 585
R45 VSS.n509 VSS.n428 585
R46 VSS.n510 VSS.n427 585
R47 VSS.n511 VSS.n426 585
R48 VSS.n545 VSS.n341 585
R49 VSS.n425 VSS.n341 585
R50 VSS.n512 VSS.n424 585
R51 VSS.n513 VSS.n423 585
R52 VSS.n545 VSS.n366 585
R53 VSS.n514 VSS.n366 585
R54 VSS.n422 VSS.n421 585
R55 VSS.n515 VSS.n420 585
R56 VSS.n516 VSS.n419 585
R57 VSS.n517 VSS.n418 585
R58 VSS.n417 VSS.n416 585
R59 VSS.n518 VSS.n415 585
R60 VSS.n545 VSS.n339 585
R61 VSS.n519 VSS.n339 585
R62 VSS.n520 VSS.n414 585
R63 VSS.n413 VSS.n412 585
R64 VSS.n521 VSS.n411 585
R65 VSS.n522 VSS.n410 585
R66 VSS.n523 VSS.n409 585
R67 VSS.n408 VSS.n407 585
R68 VSS.n524 VSS.n406 585
R69 VSS.n525 VSS.n405 585
R70 VSS.n526 VSS.n404 585
R71 VSS.n403 VSS.n402 585
R72 VSS.n527 VSS.n401 585
R73 VSS.n528 VSS.n400 585
R74 VSS.n529 VSS.n399 585
R75 VSS.n398 VSS.n397 585
R76 VSS.n530 VSS.n396 585
R77 VSS.n531 VSS.n395 585
R78 VSS.n532 VSS.n394 585
R79 VSS.n393 VSS.n392 585
R80 VSS.n545 VSS.n376 585
R81 VSS.n533 VSS.n376 585
R82 VSS.n534 VSS.n391 585
R83 VSS.n535 VSS.n390 585
R84 VSS.n545 VSS.n335 585
R85 VSS.n389 VSS.n335 585
R86 VSS.n536 VSS.n388 585
R87 VSS.n537 VSS.n387 585
R88 VSS.n538 VSS.n386 585
R89 VSS.n385 VSS.n384 585
R90 VSS.n545 VSS.n379 585
R91 VSS.n539 VSS.n379 585
R92 VSS.n540 VSS.n383 585
R93 VSS.n541 VSS.n382 585
R94 VSS.n381 VSS.n380 585
R95 VSS.n543 VSS.n542 585
R96 VSS.n330 VSS.n329 585
R97 VSS.n331 VSS.n330 585
R98 VSS.n552 VSS.n550 585
R99 VSS.n550 VSS.n549 585
R100 VSS.n551 VSS.n324 585
R101 VSS.n324 VSS.n323 585
R102 VSS.n558 VSS.n557 585
R103 VSS.n559 VSS.n558 585
R104 VSS.n321 VSS.n320 585
R105 VSS.n322 VSS.n321 585
R106 VSS.n562 VSS.n561 585
R107 VSS.n561 VSS.n560 585
R108 VSS.n314 VSS.n313 585
R109 VSS.n313 VSS.n312 585
R110 VSS.n568 VSS.n567 585
R111 VSS.n569 VSS.n568 585
R112 VSS.n315 VSS.n310 585
R113 VSS.n311 VSS.n310 585
R114 VSS.n572 VSS.n571 585
R115 VSS.n571 VSS.n570 585
R116 VSS.n305 VSS.n304 585
R117 VSS.n304 VSS.n303 585
R118 VSS.n577 VSS.t9 585
R119 VSS.n578 VSS.n577 585
R120 VSS.n301 VSS.n300 585
R121 VSS.n302 VSS.n301 585
R122 VSS.n581 VSS.n580 585
R123 VSS.n580 VSS.n579 585
R124 VSS.n294 VSS.n293 585
R125 VSS.n293 VSS.n292 585
R126 VSS.n587 VSS.n586 585
R127 VSS.n588 VSS.n587 585
R128 VSS.n295 VSS.n290 585
R129 VSS.n291 VSS.n290 585
R130 VSS.n591 VSS.n590 585
R131 VSS.n590 VSS.n589 585
R132 VSS.n285 VSS.n284 585
R133 VSS.n284 VSS.n283 585
R134 VSS.n597 VSS.n596 585
R135 VSS.n598 VSS.n597 585
R136 VSS.n281 VSS.n280 585
R137 VSS.n282 VSS.n281 585
R138 VSS.n602 VSS.n600 585
R139 VSS.n600 VSS.n599 585
R140 VSS.n601 VSS.n274 585
R141 VSS.n274 VSS.n273 585
R142 VSS.n608 VSS.n607 585
R143 VSS.n609 VSS.n608 585
R144 VSS.n275 VSS.n271 585
R145 VSS.n272 VSS.n271 585
R146 VSS.n612 VSS.n611 585
R147 VSS.n611 VSS.n610 585
R148 VSS.n266 VSS.n265 585
R149 VSS.n265 VSS.n264 585
R150 VSS.n618 VSS.n617 585
R151 VSS.n619 VSS.n618 585
R152 VSS.n262 VSS.n261 585
R153 VSS.n263 VSS.n262 585
R154 VSS.n623 VSS.n621 585
R155 VSS.n621 VSS.n620 585
R156 VSS.n622 VSS.n256 585
R157 VSS.n256 VSS.n255 585
R158 VSS.n629 VSS.n628 585
R159 VSS.n630 VSS.n629 585
R160 VSS.n253 VSS.n252 585
R161 VSS.n254 VSS.n253 585
R162 VSS.n633 VSS.n632 585
R163 VSS.n632 VSS.n631 585
R164 VSS.n247 VSS.n246 585
R165 VSS.n246 VSS.n245 585
R166 VSS.n639 VSS.n638 585
R167 VSS.n640 VSS.n639 585
R168 VSS.n243 VSS.t2 585
R169 VSS.n244 VSS.n243 585
R170 VSS.n644 VSS.n642 585
R171 VSS.n642 VSS.n641 585
R172 VSS.n643 VSS.n238 585
R173 VSS.n238 VSS.n237 585
R174 VSS.n650 VSS.n649 585
R175 VSS.n651 VSS.n650 585
R176 VSS.n235 VSS.n234 585
R177 VSS.n236 VSS.n235 585
R178 VSS.n654 VSS.n653 585
R179 VSS.n653 VSS.n652 585
R180 VSS.n227 VSS.n226 585
R181 VSS.n226 VSS.n225 585
R182 VSS.n661 VSS.n660 585
R183 VSS.n662 VSS.n661 585
R184 VSS.n228 VSS.n223 585
R185 VSS.n224 VSS.n223 585
R186 VSS.n664 VSS.n222 585
R187 VSS.n664 VSS.n663 585
R188 VSS.n666 VSS.n665 585
R189 VSS.n665 VSS.n150 585
R190 VSS.n154 VSS.n151 585
R191 VSS.n824 VSS.n151 585
R192 VSS.n668 VSS.n219 585
R193 VSS.n672 VSS.n671 585
R194 VSS.n674 VSS.n673 585
R195 VSS.n677 VSS.n676 585
R196 VSS.n675 VSS.n218 585
R197 VSS.n679 VSS.n678 585
R198 VSS.n681 VSS.n680 585
R199 VSS.n684 VSS.n683 585
R200 VSS.n682 VSS.n217 585
R201 VSS.n686 VSS.n685 585
R202 VSS.n688 VSS.n687 585
R203 VSS.n691 VSS.n690 585
R204 VSS.n689 VSS.n216 585
R205 VSS.n693 VSS.n692 585
R206 VSS.n695 VSS.n694 585
R207 VSS.n698 VSS.n697 585
R208 VSS.n696 VSS.n215 585
R209 VSS.n700 VSS.n699 585
R210 VSS.n702 VSS.n701 585
R211 VSS.n705 VSS.n704 585
R212 VSS.n703 VSS.n214 585
R213 VSS.n707 VSS.n706 585
R214 VSS.n709 VSS.n708 585
R215 VSS.n712 VSS.n711 585
R216 VSS.n710 VSS.n213 585
R217 VSS.n714 VSS.n713 585
R218 VSS.n716 VSS.n715 585
R219 VSS.n719 VSS.n718 585
R220 VSS.n717 VSS.n212 585
R221 VSS.n721 VSS.n720 585
R222 VSS.n723 VSS.n722 585
R223 VSS.n726 VSS.n725 585
R224 VSS.n724 VSS.n211 585
R225 VSS.n728 VSS.n727 585
R226 VSS.n730 VSS.n729 585
R227 VSS.n733 VSS.n732 585
R228 VSS.n731 VSS.n210 585
R229 VSS.n735 VSS.n734 585
R230 VSS.n737 VSS.n736 585
R231 VSS.n740 VSS.n739 585
R232 VSS.n738 VSS.n209 585
R233 VSS.n742 VSS.n741 585
R234 VSS.n744 VSS.n743 585
R235 VSS.n747 VSS.n746 585
R236 VSS.n745 VSS.n208 585
R237 VSS.n749 VSS.n748 585
R238 VSS.n751 VSS.n750 585
R239 VSS.n754 VSS.n753 585
R240 VSS.n752 VSS.n207 585
R241 VSS.n756 VSS.n755 585
R242 VSS.n758 VSS.n757 585
R243 VSS.n761 VSS.n760 585
R244 VSS.n759 VSS.n206 585
R245 VSS.n763 VSS.n762 585
R246 VSS.n765 VSS.n764 585
R247 VSS.n768 VSS.n767 585
R248 VSS.n766 VSS.n205 585
R249 VSS.n770 VSS.n769 585
R250 VSS.n772 VSS.n771 585
R251 VSS.n775 VSS.n774 585
R252 VSS.n773 VSS.n204 585
R253 VSS.n777 VSS.n776 585
R254 VSS.n779 VSS.n778 585
R255 VSS.n782 VSS.n781 585
R256 VSS.n780 VSS.n203 585
R257 VSS.n784 VSS.n783 585
R258 VSS.n786 VSS.n785 585
R259 VSS.n789 VSS.n788 585
R260 VSS.n787 VSS.n202 585
R261 VSS.n791 VSS.n790 585
R262 VSS.n793 VSS.n792 585
R263 VSS.n796 VSS.n795 585
R264 VSS.n794 VSS.n201 585
R265 VSS.n798 VSS.n797 585
R266 VSS.n800 VSS.n799 585
R267 VSS.n803 VSS.n802 585
R268 VSS.n801 VSS.n200 585
R269 VSS.n805 VSS.n804 585
R270 VSS.n807 VSS.n806 585
R271 VSS.n810 VSS.n809 585
R272 VSS.n808 VSS.n199 585
R273 VSS.n812 VSS.n811 585
R274 VSS.n814 VSS.n813 585
R275 VSS.n816 VSS.n815 585
R276 VSS.n198 VSS.n197 585
R277 VSS.n818 VSS.n817 585
R278 VSS.n153 VSS.n152 585
R279 VSS.n823 VSS.n822 585
R280 VSS.n669 VSS.n154 585
R281 VSS.n670 VSS.n669 585
R282 VSS.n667 VSS.n666 585
R283 VSS.n667 VSS.n220 585
R284 VSS.n222 VSS.n221 585
R285 VSS.n657 VSS.n221 585
R286 VSS.n230 VSS.n228 585
R287 VSS.n59 VSS.n230 585
R288 VSS.n660 VSS.n659 585
R289 VSS.n659 VSS.n658 585
R290 VSS.n229 VSS.n227 585
R291 VSS.n231 VSS.n229 585
R292 VSS.n655 VSS.n654 585
R293 VSS.n656 VSS.n655 585
R294 VSS.n234 VSS.n233 585
R295 VSS.n233 VSS.n232 585
R296 VSS.n649 VSS.n648 585
R297 VSS.n648 VSS.n647 585
R298 VSS.n643 VSS.n239 585
R299 VSS.n240 VSS.n239 585
R300 VSS.n645 VSS.n644 585
R301 VSS.n646 VSS.n645 585
R302 VSS.t2 VSS.n242 585
R303 VSS.n242 VSS.n241 585
R304 VSS.n638 VSS.n637 585
R305 VSS.n637 VSS.n636 585
R306 VSS.n248 VSS.n247 585
R307 VSS.n249 VSS.n248 585
R308 VSS.n634 VSS.n633 585
R309 VSS.n635 VSS.n634 585
R310 VSS.n252 VSS.n251 585
R311 VSS.n251 VSS.n250 585
R312 VSS.n628 VSS.n627 585
R313 VSS.n627 VSS.n626 585
R314 VSS.n622 VSS.n257 585
R315 VSS.n258 VSS.n257 585
R316 VSS.n624 VSS.n623 585
R317 VSS.n625 VSS.n624 585
R318 VSS.n261 VSS.n260 585
R319 VSS.n260 VSS.n259 585
R320 VSS.n617 VSS.n616 585
R321 VSS.n616 VSS.n615 585
R322 VSS.n267 VSS.n266 585
R323 VSS.n268 VSS.n267 585
R324 VSS.n613 VSS.n612 585
R325 VSS.n614 VSS.n613 585
R326 VSS.n275 VSS.n270 585
R327 VSS.n270 VSS.n269 585
R328 VSS.n607 VSS.n606 585
R329 VSS.n606 VSS.n605 585
R330 VSS.n601 VSS.n276 585
R331 VSS.n277 VSS.n276 585
R332 VSS.n603 VSS.n602 585
R333 VSS.n604 VSS.n603 585
R334 VSS.n280 VSS.n279 585
R335 VSS.n279 VSS.n278 585
R336 VSS.n596 VSS.n595 585
R337 VSS.n595 VSS.n594 585
R338 VSS.n286 VSS.n285 585
R339 VSS.n287 VSS.n286 585
R340 VSS.n592 VSS.n591 585
R341 VSS.n593 VSS.n592 585
R342 VSS.n295 VSS.n289 585
R343 VSS.n289 VSS.n288 585
R344 VSS.n586 VSS.n585 585
R345 VSS.n585 VSS.n584 585
R346 VSS.n296 VSS.n294 585
R347 VSS.n297 VSS.n296 585
R348 VSS.n582 VSS.n581 585
R349 VSS.n583 VSS.n582 585
R350 VSS.n300 VSS.n299 585
R351 VSS.n299 VSS.n298 585
R352 VSS.t9 VSS.n576 585
R353 VSS.n576 VSS.n575 585
R354 VSS.n306 VSS.n305 585
R355 VSS.n307 VSS.n306 585
R356 VSS.n573 VSS.n572 585
R357 VSS.n574 VSS.n573 585
R358 VSS.n315 VSS.n309 585
R359 VSS.n309 VSS.n308 585
R360 VSS.n567 VSS.n566 585
R361 VSS.n566 VSS.n565 585
R362 VSS.n316 VSS.n314 585
R363 VSS.n317 VSS.n316 585
R364 VSS.n563 VSS.n562 585
R365 VSS.n564 VSS.n563 585
R366 VSS.n320 VSS.n319 585
R367 VSS.n319 VSS.n318 585
R368 VSS.n557 VSS.n556 585
R369 VSS.n556 VSS.n555 585
R370 VSS.n551 VSS.n325 585
R371 VSS.n326 VSS.n325 585
R372 VSS.n553 VSS.n552 585
R373 VSS.n554 VSS.n553 585
R374 VSS.n329 VSS.n328 585
R375 VSS.n328 VSS.n327 585
R376 VSS.n543 VSS.n328 426.014
R377 VSS.n547 VSS.n330 426.014
R378 VSS.n822 VSS.n151 426.014
R379 VSS.n669 VSS.n668 426.014
R380 VSS.n546 VSS.n545 254.01
R381 VSS.n545 VSS.n356 254.01
R382 VSS.n545 VSS.n355 254.01
R383 VSS.n545 VSS.n354 254.01
R384 VSS.n545 VSS.n353 254.01
R385 VSS.n545 VSS.n352 254.01
R386 VSS.n545 VSS.n357 254.01
R387 VSS.n545 VSS.n350 254.01
R388 VSS.n545 VSS.n358 254.01
R389 VSS.n545 VSS.n349 254.01
R390 VSS.n545 VSS.n360 254.01
R391 VSS.n545 VSS.n361 254.01
R392 VSS.n545 VSS.n348 254.01
R393 VSS.n545 VSS.n362 254.01
R394 VSS.n545 VSS.n347 254.01
R395 VSS.n545 VSS.n346 254.01
R396 VSS.n545 VSS.n363 254.01
R397 VSS.n545 VSS.n345 254.01
R398 VSS.n545 VSS.n344 254.01
R399 VSS.n545 VSS.n343 254.01
R400 VSS.n545 VSS.n364 254.01
R401 VSS.n545 VSS.n342 254.01
R402 VSS.n545 VSS.n365 254.01
R403 VSS.n545 VSS.n367 254.01
R404 VSS.n545 VSS.n368 254.01
R405 VSS.n545 VSS.n340 254.01
R406 VSS.n545 VSS.n338 254.01
R407 VSS.n545 VSS.n369 254.01
R408 VSS.n545 VSS.n337 254.01
R409 VSS.n545 VSS.n370 254.01
R410 VSS.n545 VSS.n371 254.01
R411 VSS.n545 VSS.n372 254.01
R412 VSS.n545 VSS.n373 254.01
R413 VSS.n545 VSS.n374 254.01
R414 VSS.n545 VSS.n375 254.01
R415 VSS.n545 VSS.n336 254.01
R416 VSS.n545 VSS.n377 254.01
R417 VSS.n545 VSS.n378 254.01
R418 VSS.n545 VSS.n334 254.01
R419 VSS.n545 VSS.n544 254.01
R420 VSS.n820 VSS.n155 254.01
R421 VSS.n820 VSS.n156 254.01
R422 VSS.n820 VSS.n157 254.01
R423 VSS.n820 VSS.n158 254.01
R424 VSS.n820 VSS.n159 254.01
R425 VSS.n820 VSS.n160 254.01
R426 VSS.n820 VSS.n161 254.01
R427 VSS.n820 VSS.n162 254.01
R428 VSS.n820 VSS.n163 254.01
R429 VSS.n820 VSS.n164 254.01
R430 VSS.n820 VSS.n165 254.01
R431 VSS.n820 VSS.n166 254.01
R432 VSS.n820 VSS.n167 254.01
R433 VSS.n820 VSS.n168 254.01
R434 VSS.n820 VSS.n169 254.01
R435 VSS.n820 VSS.n170 254.01
R436 VSS.n820 VSS.n171 254.01
R437 VSS.n820 VSS.n172 254.01
R438 VSS.n820 VSS.n173 254.01
R439 VSS.n820 VSS.n174 254.01
R440 VSS.n820 VSS.n175 254.01
R441 VSS.n820 VSS.n176 254.01
R442 VSS.n820 VSS.n177 254.01
R443 VSS.n820 VSS.n178 254.01
R444 VSS.n820 VSS.n179 254.01
R445 VSS.n820 VSS.n180 254.01
R446 VSS.n820 VSS.n181 254.01
R447 VSS.n820 VSS.n182 254.01
R448 VSS.n820 VSS.n183 254.01
R449 VSS.n820 VSS.n184 254.01
R450 VSS.n820 VSS.n185 254.01
R451 VSS.n820 VSS.n186 254.01
R452 VSS.n820 VSS.n187 254.01
R453 VSS.n820 VSS.n188 254.01
R454 VSS.n820 VSS.n189 254.01
R455 VSS.n820 VSS.n190 254.01
R456 VSS.n820 VSS.n191 254.01
R457 VSS.n820 VSS.n192 254.01
R458 VSS.n820 VSS.n193 254.01
R459 VSS.n820 VSS.n194 254.01
R460 VSS.n820 VSS.n195 254.01
R461 VSS.n820 VSS.n196 254.01
R462 VSS.n820 VSS.n819 254.01
R463 VSS.n821 VSS.n820 254.01
R464 VSS.n669 VSS.n667 177.3
R465 VSS.n667 VSS.n221 177.3
R466 VSS.n230 VSS.n221 177.3
R467 VSS.n659 VSS.n230 177.3
R468 VSS.n659 VSS.n229 177.3
R469 VSS.n655 VSS.n229 177.3
R470 VSS.n655 VSS.n233 177.3
R471 VSS.n648 VSS.n233 177.3
R472 VSS.n648 VSS.n239 177.3
R473 VSS.n645 VSS.n239 177.3
R474 VSS.n645 VSS.n242 177.3
R475 VSS.n637 VSS.n242 177.3
R476 VSS.n637 VSS.n248 177.3
R477 VSS.n634 VSS.n248 177.3
R478 VSS.n634 VSS.n251 177.3
R479 VSS.n627 VSS.n251 177.3
R480 VSS.n627 VSS.n257 177.3
R481 VSS.n624 VSS.n257 177.3
R482 VSS.n624 VSS.n260 177.3
R483 VSS.n616 VSS.n260 177.3
R484 VSS.n616 VSS.n267 177.3
R485 VSS.n613 VSS.n267 177.3
R486 VSS.n613 VSS.n270 177.3
R487 VSS.n606 VSS.n270 177.3
R488 VSS.n606 VSS.n276 177.3
R489 VSS.n603 VSS.n276 177.3
R490 VSS.n603 VSS.n279 177.3
R491 VSS.n595 VSS.n279 177.3
R492 VSS.n595 VSS.n286 177.3
R493 VSS.n592 VSS.n286 177.3
R494 VSS.n592 VSS.n289 177.3
R495 VSS.n585 VSS.n289 177.3
R496 VSS.n585 VSS.n296 177.3
R497 VSS.n582 VSS.n296 177.3
R498 VSS.n582 VSS.n299 177.3
R499 VSS.n576 VSS.n299 177.3
R500 VSS.n576 VSS.n306 177.3
R501 VSS.n573 VSS.n306 177.3
R502 VSS.n573 VSS.n309 177.3
R503 VSS.n566 VSS.n309 177.3
R504 VSS.n566 VSS.n316 177.3
R505 VSS.n563 VSS.n316 177.3
R506 VSS.n563 VSS.n319 177.3
R507 VSS.n556 VSS.n319 177.3
R508 VSS.n556 VSS.n325 177.3
R509 VSS.n553 VSS.n325 177.3
R510 VSS.n553 VSS.n328 177.3
R511 VSS.n477 VSS.n333 177.3
R512 VSS.n476 VSS.n475 177.3
R513 VSS.n474 VSS.n473 177.3
R514 VSS.n471 VSS.n470 177.3
R515 VSS.n469 VSS.n468 177.3
R516 VSS.n466 VSS.n351 177.3
R517 VSS.n465 VSS.n351 177.3
R518 VSS.n463 VSS.n462 177.3
R519 VSS.n461 VSS.n460 177.3
R520 VSS.n458 VSS.n359 177.3
R521 VSS.n457 VSS.n359 177.3
R522 VSS.n456 VSS.n455 177.3
R523 VSS.n453 VSS.n452 177.3
R524 VSS.n451 VSS.n450 177.3
R525 VSS.n448 VSS.n447 177.3
R526 VSS.n446 VSS.n445 177.3
R527 VSS.n443 VSS.n442 177.3
R528 VSS.n441 VSS.n440 177.3
R529 VSS.n438 VSS.n437 177.3
R530 VSS.n436 VSS.n435 177.3
R531 VSS.n433 VSS.n432 177.3
R532 VSS.n431 VSS.n430 177.3
R533 VSS.n428 VSS.n427 177.3
R534 VSS.n426 VSS.n341 177.3
R535 VSS.n424 VSS.n341 177.3
R536 VSS.n423 VSS.n366 177.3
R537 VSS.n421 VSS.n366 177.3
R538 VSS.n420 VSS.n419 177.3
R539 VSS.n418 VSS.n417 177.3
R540 VSS.n415 VSS.n339 177.3
R541 VSS.n414 VSS.n339 177.3
R542 VSS.n412 VSS.n411 177.3
R543 VSS.n410 VSS.n409 177.3
R544 VSS.n407 VSS.n406 177.3
R545 VSS.n405 VSS.n404 177.3
R546 VSS.n402 VSS.n401 177.3
R547 VSS.n400 VSS.n399 177.3
R548 VSS.n397 VSS.n396 177.3
R549 VSS.n395 VSS.n394 177.3
R550 VSS.n392 VSS.n376 177.3
R551 VSS.n391 VSS.n376 177.3
R552 VSS.n390 VSS.n335 177.3
R553 VSS.n388 VSS.n335 177.3
R554 VSS.n387 VSS.n386 177.3
R555 VSS.n384 VSS.n379 177.3
R556 VSS.n383 VSS.n379 177.3
R557 VSS.n382 VSS.n380 177.3
R558 VSS.n665 VSS.n151 177.3
R559 VSS.n665 VSS.n664 177.3
R560 VSS.n664 VSS.n223 177.3
R561 VSS.n661 VSS.n223 177.3
R562 VSS.n661 VSS.n226 177.3
R563 VSS.n653 VSS.n226 177.3
R564 VSS.n653 VSS.n235 177.3
R565 VSS.n650 VSS.n235 177.3
R566 VSS.n650 VSS.n238 177.3
R567 VSS.n642 VSS.n238 177.3
R568 VSS.n642 VSS.n243 177.3
R569 VSS.n639 VSS.n243 177.3
R570 VSS.n639 VSS.n246 177.3
R571 VSS.n632 VSS.n246 177.3
R572 VSS.n632 VSS.n253 177.3
R573 VSS.n629 VSS.n253 177.3
R574 VSS.n629 VSS.n256 177.3
R575 VSS.n621 VSS.n256 177.3
R576 VSS.n621 VSS.n262 177.3
R577 VSS.n618 VSS.n262 177.3
R578 VSS.n618 VSS.n265 177.3
R579 VSS.n611 VSS.n265 177.3
R580 VSS.n611 VSS.n271 177.3
R581 VSS.n608 VSS.n271 177.3
R582 VSS.n608 VSS.n274 177.3
R583 VSS.n600 VSS.n274 177.3
R584 VSS.n600 VSS.n281 177.3
R585 VSS.n597 VSS.n281 177.3
R586 VSS.n597 VSS.n284 177.3
R587 VSS.n590 VSS.n284 177.3
R588 VSS.n590 VSS.n290 177.3
R589 VSS.n587 VSS.n290 177.3
R590 VSS.n587 VSS.n293 177.3
R591 VSS.n580 VSS.n293 177.3
R592 VSS.n580 VSS.n301 177.3
R593 VSS.n577 VSS.n301 177.3
R594 VSS.n577 VSS.n304 177.3
R595 VSS.n571 VSS.n304 177.3
R596 VSS.n571 VSS.n310 177.3
R597 VSS.n568 VSS.n310 177.3
R598 VSS.n568 VSS.n313 177.3
R599 VSS.n561 VSS.n313 177.3
R600 VSS.n561 VSS.n321 177.3
R601 VSS.n558 VSS.n321 177.3
R602 VSS.n558 VSS.n324 177.3
R603 VSS.n550 VSS.n324 177.3
R604 VSS.n550 VSS.n330 177.3
R605 VSS.n818 VSS.n153 177.3
R606 VSS.n815 VSS.n197 177.3
R607 VSS.n813 VSS.n812 177.3
R608 VSS.n809 VSS.n808 177.3
R609 VSS.n806 VSS.n805 177.3
R610 VSS.n802 VSS.n801 177.3
R611 VSS.n799 VSS.n798 177.3
R612 VSS.n795 VSS.n794 177.3
R613 VSS.n792 VSS.n791 177.3
R614 VSS.n788 VSS.n787 177.3
R615 VSS.n785 VSS.n784 177.3
R616 VSS.n781 VSS.n780 177.3
R617 VSS.n778 VSS.n777 177.3
R618 VSS.n774 VSS.n773 177.3
R619 VSS.n771 VSS.n770 177.3
R620 VSS.n767 VSS.n766 177.3
R621 VSS.n764 VSS.n763 177.3
R622 VSS.n760 VSS.n759 177.3
R623 VSS.n757 VSS.n756 177.3
R624 VSS.n753 VSS.n752 177.3
R625 VSS.n750 VSS.n749 177.3
R626 VSS.n746 VSS.n745 177.3
R627 VSS.n743 VSS.n742 177.3
R628 VSS.n739 VSS.n738 177.3
R629 VSS.n736 VSS.n735 177.3
R630 VSS.n732 VSS.n731 177.3
R631 VSS.n729 VSS.n728 177.3
R632 VSS.n725 VSS.n724 177.3
R633 VSS.n722 VSS.n721 177.3
R634 VSS.n718 VSS.n717 177.3
R635 VSS.n715 VSS.n714 177.3
R636 VSS.n711 VSS.n710 177.3
R637 VSS.n708 VSS.n707 177.3
R638 VSS.n704 VSS.n703 177.3
R639 VSS.n701 VSS.n700 177.3
R640 VSS.n697 VSS.n696 177.3
R641 VSS.n694 VSS.n693 177.3
R642 VSS.n690 VSS.n689 177.3
R643 VSS.n687 VSS.n686 177.3
R644 VSS.n683 VSS.n682 177.3
R645 VSS.n680 VSS.n679 177.3
R646 VSS.n676 VSS.n675 177.3
R647 VSS.n673 VSS.n672 177.3
R648 VSS.n547 VSS.n546 76.985
R649 VSS.n476 VSS.n356 76.985
R650 VSS.n474 VSS.n355 76.985
R651 VSS.n471 VSS.n354 76.985
R652 VSS.n469 VSS.n353 76.985
R653 VSS.n466 VSS.n352 76.985
R654 VSS.n463 VSS.n357 76.985
R655 VSS.n462 VSS.n350 76.985
R656 VSS.n458 VSS.n358 76.985
R657 VSS.n456 VSS.n349 76.985
R658 VSS.n455 VSS.n360 76.985
R659 VSS.n452 VSS.n361 76.985
R660 VSS.n448 VSS.n348 76.985
R661 VSS.n447 VSS.n362 76.985
R662 VSS.n443 VSS.n347 76.985
R663 VSS.n441 VSS.n346 76.985
R664 VSS.n440 VSS.n363 76.985
R665 VSS.n436 VSS.n345 76.985
R666 VSS.n433 VSS.n344 76.985
R667 VSS.n431 VSS.n343 76.985
R668 VSS.n430 VSS.n364 76.985
R669 VSS.n426 VSS.n342 76.985
R670 VSS.n423 VSS.n365 76.985
R671 VSS.n421 VSS.n367 76.985
R672 VSS.n419 VSS.n368 76.985
R673 VSS.n415 VSS.n340 76.985
R674 VSS.n414 VSS.n338 76.985
R675 VSS.n410 VSS.n369 76.985
R676 VSS.n409 VSS.n337 76.985
R677 VSS.n405 VSS.n370 76.985
R678 VSS.n402 VSS.n371 76.985
R679 VSS.n400 VSS.n372 76.985
R680 VSS.n397 VSS.n373 76.985
R681 VSS.n395 VSS.n374 76.985
R682 VSS.n392 VSS.n375 76.985
R683 VSS.n390 VSS.n336 76.985
R684 VSS.n387 VSS.n377 76.985
R685 VSS.n384 VSS.n378 76.985
R686 VSS.n382 VSS.n334 76.985
R687 VSS.n544 VSS.n380 76.985
R688 VSS.n668 VSS.n155 76.985
R689 VSS.n673 VSS.n156 76.985
R690 VSS.n675 VSS.n157 76.985
R691 VSS.n680 VSS.n158 76.985
R692 VSS.n682 VSS.n159 76.985
R693 VSS.n687 VSS.n160 76.985
R694 VSS.n689 VSS.n161 76.985
R695 VSS.n694 VSS.n162 76.985
R696 VSS.n696 VSS.n163 76.985
R697 VSS.n701 VSS.n164 76.985
R698 VSS.n703 VSS.n165 76.985
R699 VSS.n708 VSS.n166 76.985
R700 VSS.n710 VSS.n167 76.985
R701 VSS.n715 VSS.n168 76.985
R702 VSS.n717 VSS.n169 76.985
R703 VSS.n722 VSS.n170 76.985
R704 VSS.n724 VSS.n171 76.985
R705 VSS.n729 VSS.n172 76.985
R706 VSS.n731 VSS.n173 76.985
R707 VSS.n736 VSS.n174 76.985
R708 VSS.n738 VSS.n175 76.985
R709 VSS.n743 VSS.n176 76.985
R710 VSS.n745 VSS.n177 76.985
R711 VSS.n750 VSS.n178 76.985
R712 VSS.n752 VSS.n179 76.985
R713 VSS.n757 VSS.n180 76.985
R714 VSS.n759 VSS.n181 76.985
R715 VSS.n764 VSS.n182 76.985
R716 VSS.n766 VSS.n183 76.985
R717 VSS.n771 VSS.n184 76.985
R718 VSS.n773 VSS.n185 76.985
R719 VSS.n778 VSS.n186 76.985
R720 VSS.n780 VSS.n187 76.985
R721 VSS.n785 VSS.n188 76.985
R722 VSS.n787 VSS.n189 76.985
R723 VSS.n792 VSS.n190 76.985
R724 VSS.n794 VSS.n191 76.985
R725 VSS.n799 VSS.n192 76.985
R726 VSS.n801 VSS.n193 76.985
R727 VSS.n806 VSS.n194 76.985
R728 VSS.n808 VSS.n195 76.985
R729 VSS.n813 VSS.n196 76.985
R730 VSS.n819 VSS.n197 76.985
R731 VSS.n821 VSS.n153 76.985
R732 VSS.n546 VSS.n333 76.985
R733 VSS.n477 VSS.n356 76.985
R734 VSS.n475 VSS.n355 76.985
R735 VSS.n473 VSS.n354 76.985
R736 VSS.n470 VSS.n353 76.985
R737 VSS.n468 VSS.n352 76.985
R738 VSS.n465 VSS.n357 76.985
R739 VSS.n461 VSS.n350 76.985
R740 VSS.n460 VSS.n358 76.985
R741 VSS.n457 VSS.n349 76.985
R742 VSS.n453 VSS.n360 76.985
R743 VSS.n451 VSS.n361 76.985
R744 VSS.n450 VSS.n348 76.985
R745 VSS.n446 VSS.n362 76.985
R746 VSS.n445 VSS.n347 76.985
R747 VSS.n442 VSS.n346 76.985
R748 VSS.n438 VSS.n363 76.985
R749 VSS.n437 VSS.n345 76.985
R750 VSS.n435 VSS.n344 76.985
R751 VSS.n432 VSS.n343 76.985
R752 VSS.n428 VSS.n364 76.985
R753 VSS.n427 VSS.n342 76.985
R754 VSS.n424 VSS.n365 76.985
R755 VSS.n420 VSS.n367 76.985
R756 VSS.n418 VSS.n368 76.985
R757 VSS.n417 VSS.n340 76.985
R758 VSS.n412 VSS.n338 76.985
R759 VSS.n411 VSS.n369 76.985
R760 VSS.n407 VSS.n337 76.985
R761 VSS.n406 VSS.n370 76.985
R762 VSS.n404 VSS.n371 76.985
R763 VSS.n401 VSS.n372 76.985
R764 VSS.n399 VSS.n373 76.985
R765 VSS.n396 VSS.n374 76.985
R766 VSS.n394 VSS.n375 76.985
R767 VSS.n391 VSS.n336 76.985
R768 VSS.n388 VSS.n377 76.985
R769 VSS.n386 VSS.n378 76.985
R770 VSS.n383 VSS.n334 76.985
R771 VSS.n544 VSS.n543 76.985
R772 VSS.n822 VSS.n821 76.985
R773 VSS.n819 VSS.n818 76.985
R774 VSS.n815 VSS.n196 76.985
R775 VSS.n812 VSS.n195 76.985
R776 VSS.n809 VSS.n194 76.985
R777 VSS.n805 VSS.n193 76.985
R778 VSS.n802 VSS.n192 76.985
R779 VSS.n798 VSS.n191 76.985
R780 VSS.n795 VSS.n190 76.985
R781 VSS.n791 VSS.n189 76.985
R782 VSS.n788 VSS.n188 76.985
R783 VSS.n784 VSS.n187 76.985
R784 VSS.n781 VSS.n186 76.985
R785 VSS.n777 VSS.n185 76.985
R786 VSS.n774 VSS.n184 76.985
R787 VSS.n770 VSS.n183 76.985
R788 VSS.n767 VSS.n182 76.985
R789 VSS.n763 VSS.n181 76.985
R790 VSS.n760 VSS.n180 76.985
R791 VSS.n756 VSS.n179 76.985
R792 VSS.n753 VSS.n178 76.985
R793 VSS.n749 VSS.n177 76.985
R794 VSS.n746 VSS.n176 76.985
R795 VSS.n742 VSS.n175 76.985
R796 VSS.n739 VSS.n174 76.985
R797 VSS.n735 VSS.n173 76.985
R798 VSS.n732 VSS.n172 76.985
R799 VSS.n728 VSS.n171 76.985
R800 VSS.n725 VSS.n170 76.985
R801 VSS.n721 VSS.n169 76.985
R802 VSS.n718 VSS.n168 76.985
R803 VSS.n714 VSS.n167 76.985
R804 VSS.n711 VSS.n166 76.985
R805 VSS.n707 VSS.n165 76.985
R806 VSS.n704 VSS.n164 76.985
R807 VSS.n700 VSS.n163 76.985
R808 VSS.n697 VSS.n162 76.985
R809 VSS.n693 VSS.n161 76.985
R810 VSS.n690 VSS.n160 76.985
R811 VSS.n686 VSS.n159 76.985
R812 VSS.n683 VSS.n158 76.985
R813 VSS.n679 VSS.n157 76.985
R814 VSS.n676 VSS.n156 76.985
R815 VSS.n672 VSS.n155 76.985
R816 VSS.n820 VSS.n154 59.6636
R817 VSS.n545 VSS.n329 59.6636
R818 VSS.n666 VSS.n154 45.2189
R819 VSS.n666 VSS.n222 45.2189
R820 VSS.n660 VSS.n228 45.2189
R821 VSS.n660 VSS.n227 45.2189
R822 VSS.n654 VSS.n234 45.2189
R823 VSS.n649 VSS.n234 45.2189
R824 VSS.n644 VSS.n643 45.2189
R825 VSS.n644 VSS.t2 45.2189
R826 VSS.n638 VSS.t2 45.2189
R827 VSS.n638 VSS.n247 45.2189
R828 VSS.n633 VSS.n252 45.2189
R829 VSS.n628 VSS.n252 45.2189
R830 VSS.n623 VSS.n622 45.2189
R831 VSS.n623 VSS.n261 45.2189
R832 VSS.n617 VSS.n266 45.2189
R833 VSS.n612 VSS.n266 45.2189
R834 VSS.n607 VSS.n275 45.2189
R835 VSS.n602 VSS.n601 45.2189
R836 VSS.n602 VSS.n280 45.2189
R837 VSS.n596 VSS.n285 45.2189
R838 VSS.n591 VSS.n285 45.2189
R839 VSS.n586 VSS.n295 45.2189
R840 VSS.n586 VSS.n294 45.2189
R841 VSS.n581 VSS.n300 45.2189
R842 VSS.t9 VSS.n300 45.2189
R843 VSS.t9 VSS.n305 45.2189
R844 VSS.n572 VSS.n305 45.2189
R845 VSS.n567 VSS.n315 45.2189
R846 VSS.n567 VSS.n314 45.2189
R847 VSS.n562 VSS.n320 45.2189
R848 VSS.n557 VSS.n320 45.2189
R849 VSS.n552 VSS.n551 45.2189
R850 VSS.n552 VSS.n329 45.2189
R851 VSS.n275 VSS.t8 40.1946
R852 VSS.n607 VSS.t5 40.1946
R853 VSS.n643 VSS.t3 35.1704
R854 VSS.t1 VSS.n247 35.1704
R855 VSS.n581 VSS.t14 35.1704
R856 VSS.n572 VSS.t17 35.1704
R857 VSS.t7 VSS.n222 30.1461
R858 VSS.n617 VSS.t6 30.1461
R859 VSS.t16 VSS.n280 30.1461
R860 VSS.n551 VSS.t18 30.1461
R861 VSS.n548 VSS.n331 27.6805
R862 VSS.n824 VSS.n823 27.6805
R863 VSS.n670 VSS.n219 27.6805
R864 VSS.n542 VSS.n327 27.6805
R865 VSS.n654 VSS.t0 25.1218
R866 VSS.n628 VSS.t4 25.1218
R867 VSS.n295 VSS.t13 25.1218
R868 VSS.t15 VSS.n314 25.1218
R869 VSS.t0 VSS.n227 20.0976
R870 VSS.n622 VSS.t4 20.0976
R871 VSS.n591 VSS.t13 20.0976
R872 VSS.n562 VSS.t15 20.0976
R873 VSS.n228 VSS.t7 15.0733
R874 VSS.t6 VSS.n261 15.0733
R875 VSS.n596 VSS.t16 15.0733
R876 VSS.n557 VSS.t18 15.0733
R877 VSS.n548 VSS.n83 3.55797
R878 VSS.n478 VSS.n332 11.5205
R879 VSS.n479 VSS.n84 3.55797
R880 VSS.n480 VSS.n479 11.5205
R881 VSS.n481 VSS.n85 3.55797
R882 VSS.n481 VSS.n472 11.5205
R883 VSS.n482 VSS.n86 3.55797
R884 VSS.n483 VSS.n482 11.5205
R885 VSS.n484 VSS.n87 3.55797
R886 VSS.n484 VSS.n467 11.5205
R887 VSS.n485 VSS.n88 3.55797
R888 VSS.n486 VSS.n485 11.5205
R889 VSS.n487 VSS.n89 3.55797
R890 VSS.n487 VSS.n464 11.5205
R891 VSS.n488 VSS.n90 3.55797
R892 VSS.n489 VSS.n488 11.5205
R893 VSS.n490 VSS.n91 3.55797
R894 VSS.n490 VSS.n459 11.5205
R895 VSS.n491 VSS.n92 3.55797
R896 VSS.n492 VSS.n491 11.5205
R897 VSS.n493 VSS.n93 3.55797
R898 VSS.n493 VSS.n454 11.5205
R899 VSS.n494 VSS.n94 3.55797
R900 VSS.n495 VSS.n494 11.5205
R901 VSS.n496 VSS.n95 3.55797
R902 VSS.n496 VSS.n449 11.5205
R903 VSS.n497 VSS.n96 3.55797
R904 VSS.n498 VSS.n497 11.5205
R905 VSS.n499 VSS.n97 3.55797
R906 VSS.n499 VSS.n444 11.5205
R907 VSS.n500 VSS.n98 3.55797
R908 VSS.n501 VSS.n500 11.5205
R909 VSS.n502 VSS.n99 3.55797
R910 VSS.n502 VSS.n439 11.5205
R911 VSS.n503 VSS.n100 3.55797
R912 VSS.n504 VSS.n503 11.5205
R913 VSS.n505 VSS.n101 3.55797
R914 VSS.n505 VSS.n434 11.5205
R915 VSS.n506 VSS.n102 3.55797
R916 VSS.n507 VSS.n506 11.5205
R917 VSS.n508 VSS.n103 3.55797
R918 VSS.n508 VSS.n429 11.5205
R919 VSS.n509 VSS.n104 3.55797
R920 VSS.n510 VSS.n509 11.5205
R921 VSS.n511 VSS.n105 3.55797
R922 VSS.n511 VSS.n425 11.5205
R923 VSS.n512 VSS.n106 3.55797
R924 VSS.n513 VSS.n512 11.5205
R925 VSS.n514 VSS.n107 3.55797
R926 VSS.n514 VSS.n422 11.5205
R927 VSS.n515 VSS.n108 3.55797
R928 VSS.n516 VSS.n515 11.5205
R929 VSS.n517 VSS.n109 3.55797
R930 VSS.n517 VSS.n416 11.5205
R931 VSS.n518 VSS.n110 3.55797
R932 VSS.n519 VSS.n518 11.5205
R933 VSS.n520 VSS.n111 3.55797
R934 VSS.n520 VSS.n413 11.5205
R935 VSS.n521 VSS.n112 3.55797
R936 VSS.n522 VSS.n521 11.5205
R937 VSS.n523 VSS.n113 3.55797
R938 VSS.n523 VSS.n408 11.5205
R939 VSS.n524 VSS.n114 3.55797
R940 VSS.n525 VSS.n524 11.5205
R941 VSS.n526 VSS.n115 3.55797
R942 VSS.n526 VSS.n403 11.5205
R943 VSS.n527 VSS.n116 3.55797
R944 VSS.n528 VSS.n527 11.5205
R945 VSS.n529 VSS.n117 3.55797
R946 VSS.n529 VSS.n398 11.5205
R947 VSS.n530 VSS.n118 3.55797
R948 VSS.n531 VSS.n530 11.5205
R949 VSS.n532 VSS.n119 3.55797
R950 VSS.n532 VSS.n393 11.5205
R951 VSS.n533 VSS.n120 3.55797
R952 VSS.n534 VSS.n533 11.5205
R953 VSS.n535 VSS.n121 3.55797
R954 VSS.n535 VSS.n389 11.5205
R955 VSS.n536 VSS.n122 3.55797
R956 VSS.n537 VSS.n536 11.5205
R957 VSS.n538 VSS.n123 3.55797
R958 VSS.n538 VSS.n385 11.5205
R959 VSS.n539 VSS.n124 3.55797
R960 VSS.n540 VSS.n539 11.5205
R961 VSS.n541 VSS.n125 3.55797
R962 VSS.n541 VSS.n381 11.5205
R963 VSS.n542 VSS.n126 3.55797
R964 VSS.n824 VSS.n150 11.5205
R965 VSS.n663 VSS.n127 3.55797
R966 VSS.n663 VSS.n224 11.5205
R967 VSS.n662 VSS.n128 3.55797
R968 VSS.n662 VSS.n225 11.5205
R969 VSS.n652 VSS.n129 3.55797
R970 VSS.n652 VSS.n236 11.5205
R971 VSS.n651 VSS.n130 3.55797
R972 VSS.n651 VSS.n237 11.5205
R973 VSS.n641 VSS.n131 3.55797
R974 VSS.n641 VSS.n244 11.5205
R975 VSS.n640 VSS.n132 3.55797
R976 VSS.n640 VSS.n245 11.5205
R977 VSS.n631 VSS.n133 3.55797
R978 VSS.n631 VSS.n254 11.5205
R979 VSS.n630 VSS.n134 3.55797
R980 VSS.n630 VSS.n255 11.5205
R981 VSS.n620 VSS.n135 3.55797
R982 VSS.n620 VSS.n263 11.5205
R983 VSS.n619 VSS.n136 3.55797
R984 VSS.n619 VSS.n264 11.5205
R985 VSS.n610 VSS.n137 3.55797
R986 VSS.n610 VSS.n272 11.5205
R987 VSS.n609 VSS.n138 3.55797
R988 VSS.n609 VSS.n273 11.5205
R989 VSS.n599 VSS.n139 3.55797
R990 VSS.n599 VSS.n282 11.5205
R991 VSS.n598 VSS.n149 3.55797
R992 VSS.n598 VSS.n283 11.5205
R993 VSS.n589 VSS.n283 11.5205
R994 VSS.n140 VSS.n291 3.55797
R995 VSS.n588 VSS.n291 11.5205
R996 VSS.n141 VSS.n292 3.55797
R997 VSS.n579 VSS.n292 11.5205
R998 VSS.n142 VSS.n302 3.55797
R999 VSS.n578 VSS.n302 11.5205
R1000 VSS.n143 VSS.n303 3.55797
R1001 VSS.n570 VSS.n303 11.5205
R1002 VSS.n144 VSS.n311 3.55797
R1003 VSS.n569 VSS.n311 11.5205
R1004 VSS.n145 VSS.n312 3.55797
R1005 VSS.n560 VSS.n312 11.5205
R1006 VSS.n146 VSS.n322 3.55797
R1007 VSS.n559 VSS.n322 11.5205
R1008 VSS.n147 VSS.n323 3.55797
R1009 VSS.n549 VSS.n323 11.5205
R1010 VSS.n148 VSS.n331 3.55797
R1011 VSS.n14 VSS.n152 3.55797
R1012 VSS.n817 VSS.n152 11.5205
R1013 VSS.n15 VSS.n198 3.55797
R1014 VSS.n816 VSS.n198 11.5205
R1015 VSS.n16 VSS.n814 3.55797
R1016 VSS.n814 VSS.n811 11.5205
R1017 VSS.n17 VSS.n199 3.55797
R1018 VSS.n810 VSS.n199 11.5205
R1019 VSS.n18 VSS.n807 3.55797
R1020 VSS.n807 VSS.n804 11.5205
R1021 VSS.n19 VSS.n200 3.55797
R1022 VSS.n803 VSS.n200 11.5205
R1023 VSS.n20 VSS.n800 3.55797
R1024 VSS.n800 VSS.n797 11.5205
R1025 VSS.n21 VSS.n201 3.55797
R1026 VSS.n796 VSS.n201 11.5205
R1027 VSS.n22 VSS.n793 3.55797
R1028 VSS.n793 VSS.n790 11.5205
R1029 VSS.n23 VSS.n202 3.55797
R1030 VSS.n789 VSS.n202 11.5205
R1031 VSS.n24 VSS.n786 3.55797
R1032 VSS.n786 VSS.n783 11.5205
R1033 VSS.n25 VSS.n203 3.55797
R1034 VSS.n782 VSS.n203 11.5205
R1035 VSS.n26 VSS.n779 3.55797
R1036 VSS.n779 VSS.n776 11.5205
R1037 VSS.n27 VSS.n204 3.55797
R1038 VSS.n775 VSS.n204 11.5205
R1039 VSS.n28 VSS.n772 3.55797
R1040 VSS.n772 VSS.n769 11.5205
R1041 VSS.n29 VSS.n205 3.55797
R1042 VSS.n768 VSS.n205 11.5205
R1043 VSS.n30 VSS.n765 3.55797
R1044 VSS.n765 VSS.n762 11.5205
R1045 VSS.n31 VSS.n206 3.55797
R1046 VSS.n761 VSS.n206 11.5205
R1047 VSS.n32 VSS.n758 3.55797
R1048 VSS.n758 VSS.n755 11.5205
R1049 VSS.n33 VSS.n207 3.55797
R1050 VSS.n754 VSS.n207 11.5205
R1051 VSS.n34 VSS.n751 3.55797
R1052 VSS.n751 VSS.n748 11.5205
R1053 VSS.n35 VSS.n208 3.55797
R1054 VSS.n747 VSS.n208 11.5205
R1055 VSS.n36 VSS.n744 3.55797
R1056 VSS.n744 VSS.n741 11.5205
R1057 VSS.n37 VSS.n209 3.55797
R1058 VSS.n740 VSS.n209 11.5205
R1059 VSS.n38 VSS.n737 3.55797
R1060 VSS.n737 VSS.n734 11.5205
R1061 VSS.n39 VSS.n210 3.55797
R1062 VSS.n733 VSS.n210 11.5205
R1063 VSS.n40 VSS.n730 3.55797
R1064 VSS.n730 VSS.n727 11.5205
R1065 VSS.n41 VSS.n211 3.55797
R1066 VSS.n726 VSS.n211 11.5205
R1067 VSS.n42 VSS.n723 3.55797
R1068 VSS.n723 VSS.n720 11.5205
R1069 VSS.n43 VSS.n212 3.55797
R1070 VSS.n719 VSS.n212 11.5205
R1071 VSS.n44 VSS.n716 3.55797
R1072 VSS.n716 VSS.n713 11.5205
R1073 VSS.n45 VSS.n213 3.55797
R1074 VSS.n712 VSS.n213 11.5205
R1075 VSS.n46 VSS.n709 3.55797
R1076 VSS.n709 VSS.n706 11.5205
R1077 VSS.n47 VSS.n214 3.55797
R1078 VSS.n705 VSS.n214 11.5205
R1079 VSS.n48 VSS.n702 3.55797
R1080 VSS.n702 VSS.n699 11.5205
R1081 VSS.n49 VSS.n215 3.55797
R1082 VSS.n698 VSS.n215 11.5205
R1083 VSS.n50 VSS.n695 3.55797
R1084 VSS.n695 VSS.n692 11.5205
R1085 VSS.n51 VSS.n216 3.55797
R1086 VSS.n691 VSS.n216 11.5205
R1087 VSS.n52 VSS.n688 3.55797
R1088 VSS.n688 VSS.n685 11.5205
R1089 VSS.n53 VSS.n217 3.55797
R1090 VSS.n684 VSS.n217 11.5205
R1091 VSS.n54 VSS.n681 3.55797
R1092 VSS.n681 VSS.n678 11.5205
R1093 VSS.n55 VSS.n218 3.55797
R1094 VSS.n677 VSS.n218 11.5205
R1095 VSS.n56 VSS.n674 3.55797
R1096 VSS.n674 VSS.n671 11.5205
R1097 VSS.n57 VSS.n219 3.55797
R1098 VSS.n670 VSS.n58 3.55797
R1099 VSS.n657 VSS.n220 11.5205
R1100 VSS.n60 VSS.n59 3.55797
R1101 VSS.n658 VSS.n59 11.5205
R1102 VSS.n61 VSS.n231 3.55797
R1103 VSS.n656 VSS.n231 11.5205
R1104 VSS.n62 VSS.n232 3.55797
R1105 VSS.n647 VSS.n232 11.5205
R1106 VSS.n63 VSS.n240 3.55797
R1107 VSS.n646 VSS.n240 11.5205
R1108 VSS.n64 VSS.n241 3.55797
R1109 VSS.n636 VSS.n241 11.5205
R1110 VSS.n65 VSS.n249 3.55797
R1111 VSS.n635 VSS.n249 11.5205
R1112 VSS.n66 VSS.n250 3.55797
R1113 VSS.n626 VSS.n250 11.5205
R1114 VSS.n67 VSS.n258 3.55797
R1115 VSS.n625 VSS.n258 11.5205
R1116 VSS.n68 VSS.n259 3.55797
R1117 VSS.n615 VSS.n259 11.5205
R1118 VSS.n69 VSS.n268 3.55797
R1119 VSS.n614 VSS.n268 11.5205
R1120 VSS.n70 VSS.n269 3.55797
R1121 VSS.n605 VSS.n269 11.5205
R1122 VSS.n71 VSS.n277 3.55797
R1123 VSS.n604 VSS.n277 11.5205
R1124 VSS.n72 VSS.n278 3.55797
R1125 VSS.n594 VSS.n278 11.5205
R1126 VSS.n73 VSS.n287 3.55797
R1127 VSS.n593 VSS.n287 11.5205
R1128 VSS.n74 VSS.n288 3.55797
R1129 VSS.n584 VSS.n288 11.5205
R1130 VSS.n75 VSS.n297 3.55797
R1131 VSS.n583 VSS.n297 11.5205
R1132 VSS.n76 VSS.n298 3.55797
R1133 VSS.n575 VSS.n298 11.5205
R1134 VSS.n77 VSS.n307 3.55797
R1135 VSS.n574 VSS.n307 11.5205
R1136 VSS.n78 VSS.n308 3.55797
R1137 VSS.n565 VSS.n308 11.5205
R1138 VSS.n79 VSS.n317 3.55797
R1139 VSS.n564 VSS.n317 11.5205
R1140 VSS.n80 VSS.n318 3.55797
R1141 VSS.n555 VSS.n318 11.5205
R1142 VSS.n81 VSS.n326 3.55797
R1143 VSS.n554 VSS.n326 11.5205
R1144 VSS.n82 VSS.n327 3.55797
R1145 VSS.n649 VSS.t3 10.049
R1146 VSS.n633 VSS.t1 10.049
R1147 VSS.t14 VSS.n294 10.049
R1148 VSS.n315 VSS.t17 10.049
R1149 VSS.t10 VSS.n148 2.87251
R1150 VSS.n549 VSS.n148 3.55797
R1151 VSS.n147 VSS.t10 2.87251
R1152 VSS.n147 VSS.n559 3.55797
R1153 VSS.t10 VSS.n146 2.87251
R1154 VSS.n560 VSS.n146 3.55797
R1155 VSS.n145 VSS.t10 2.87251
R1156 VSS.n145 VSS.n569 3.55797
R1157 VSS.t10 VSS.n144 2.87251
R1158 VSS.n570 VSS.n144 3.55797
R1159 VSS.n143 VSS.t10 2.87251
R1160 VSS.n143 VSS.n578 3.55797
R1161 VSS.t10 VSS.n142 2.87251
R1162 VSS.n579 VSS.n142 3.55797
R1163 VSS.n141 VSS.t10 2.87251
R1164 VSS.n141 VSS.n588 3.55797
R1165 VSS.t10 VSS.n140 2.87251
R1166 VSS.n589 VSS.n140 3.55797
R1167 VSS.n283 VSS.t10 9.3005
R1168 VSS.t10 VSS.n149 2.87251
R1169 VSS.n149 VSS.n282 3.55797
R1170 VSS.n139 VSS.t10 2.87251
R1171 VSS.n273 VSS.n139 3.55797
R1172 VSS.t10 VSS.n138 2.87251
R1173 VSS.n138 VSS.n272 3.55797
R1174 VSS.n137 VSS.t10 2.87251
R1175 VSS.n264 VSS.n137 3.55797
R1176 VSS.t10 VSS.n136 2.87251
R1177 VSS.n136 VSS.n263 3.55797
R1178 VSS.n135 VSS.t10 2.87251
R1179 VSS.n255 VSS.n135 3.55797
R1180 VSS.t10 VSS.n134 2.87251
R1181 VSS.n134 VSS.n254 3.55797
R1182 VSS.n133 VSS.t10 2.87251
R1183 VSS.n245 VSS.n133 3.55797
R1184 VSS.t10 VSS.n132 2.87251
R1185 VSS.n132 VSS.n244 3.55797
R1186 VSS.n131 VSS.t10 2.87251
R1187 VSS.n237 VSS.n131 3.55797
R1188 VSS.n13 VSS.n130 2.87251
R1189 VSS.n130 VSS.n236 3.55797
R1190 VSS.n129 VSS.n13 2.87251
R1191 VSS.n225 VSS.n129 3.55797
R1192 VSS.n13 VSS.n128 2.87251
R1193 VSS.n128 VSS.n224 3.55797
R1194 VSS.n127 VSS.n13 2.87251
R1195 VSS.n150 VSS.n127 3.55797
R1196 VSS.n13 VSS.n824 9.3005
R1197 VSS.n8 VSS.n57 2.87251
R1198 VSS.n671 VSS.n57 3.55797
R1199 VSS.n56 VSS.n8 2.87251
R1200 VSS.n56 VSS.n677 3.55797
R1201 VSS.n8 VSS.n55 2.87251
R1202 VSS.n678 VSS.n55 3.55797
R1203 VSS.n54 VSS.n8 2.87251
R1204 VSS.n54 VSS.n684 3.55797
R1205 VSS.n9 VSS.n53 2.87251
R1206 VSS.n685 VSS.n53 3.55797
R1207 VSS.n52 VSS.n9 2.87251
R1208 VSS.n52 VSS.n691 3.55797
R1209 VSS.n9 VSS.n51 2.87251
R1210 VSS.n692 VSS.n51 3.55797
R1211 VSS.n50 VSS.n9 2.87251
R1212 VSS.n50 VSS.n698 3.55797
R1213 VSS.n9 VSS.n49 2.87251
R1214 VSS.n699 VSS.n49 3.55797
R1215 VSS.n48 VSS.n9 2.87251
R1216 VSS.n48 VSS.n705 3.55797
R1217 VSS.n9 VSS.n47 2.87251
R1218 VSS.n706 VSS.n47 3.55797
R1219 VSS.n46 VSS.n9 2.87251
R1220 VSS.n46 VSS.n712 3.55797
R1221 VSS.n10 VSS.n45 2.87251
R1222 VSS.n713 VSS.n45 3.55797
R1223 VSS.n44 VSS.n10 2.87251
R1224 VSS.n44 VSS.n719 3.55797
R1225 VSS.n10 VSS.n43 2.87251
R1226 VSS.n720 VSS.n43 3.55797
R1227 VSS.n42 VSS.n10 2.87251
R1228 VSS.n42 VSS.n726 3.55797
R1229 VSS.n10 VSS.n41 2.87251
R1230 VSS.n727 VSS.n41 3.55797
R1231 VSS.n40 VSS.n10 2.87251
R1232 VSS.n40 VSS.n733 3.55797
R1233 VSS.n10 VSS.n39 2.87251
R1234 VSS.n734 VSS.n39 3.55797
R1235 VSS.n38 VSS.n10 2.87251
R1236 VSS.n38 VSS.n740 3.55797
R1237 VSS.n11 VSS.n37 2.87251
R1238 VSS.n741 VSS.n37 3.55797
R1239 VSS.n36 VSS.n11 2.87251
R1240 VSS.n36 VSS.n747 3.55797
R1241 VSS.n11 VSS.n35 2.87251
R1242 VSS.n748 VSS.n35 3.55797
R1243 VSS.n34 VSS.n11 2.87251
R1244 VSS.n34 VSS.n754 3.55797
R1245 VSS.n11 VSS.n33 2.87251
R1246 VSS.n755 VSS.n33 3.55797
R1247 VSS.n32 VSS.n11 2.87251
R1248 VSS.n32 VSS.n761 3.55797
R1249 VSS.n11 VSS.n31 2.87251
R1250 VSS.n762 VSS.n31 3.55797
R1251 VSS.n30 VSS.n11 2.87251
R1252 VSS.n30 VSS.n768 3.55797
R1253 VSS.n12 VSS.n29 2.87251
R1254 VSS.n769 VSS.n29 3.55797
R1255 VSS.n28 VSS.n12 2.87251
R1256 VSS.n28 VSS.n775 3.55797
R1257 VSS.n12 VSS.n27 2.87251
R1258 VSS.n776 VSS.n27 3.55797
R1259 VSS.n26 VSS.n12 2.87251
R1260 VSS.n26 VSS.n782 3.55797
R1261 VSS.n12 VSS.n25 2.87251
R1262 VSS.n783 VSS.n25 3.55797
R1263 VSS.n24 VSS.n12 2.87251
R1264 VSS.n24 VSS.n789 3.55797
R1265 VSS.n12 VSS.n23 2.87251
R1266 VSS.n790 VSS.n23 3.55797
R1267 VSS.n22 VSS.n12 2.87251
R1268 VSS.n22 VSS.n796 3.55797
R1269 VSS.n13 VSS.n21 2.87251
R1270 VSS.n797 VSS.n21 3.55797
R1271 VSS.n20 VSS.n13 2.87251
R1272 VSS.n20 VSS.n803 3.55797
R1273 VSS.n13 VSS.n19 2.87251
R1274 VSS.n804 VSS.n19 3.55797
R1275 VSS.n18 VSS.n13 2.87251
R1276 VSS.n18 VSS.n810 3.55797
R1277 VSS.n13 VSS.n17 2.87251
R1278 VSS.n811 VSS.n17 3.55797
R1279 VSS.n16 VSS.n13 2.87251
R1280 VSS.n16 VSS.n816 3.55797
R1281 VSS.n13 VSS.n15 2.87251
R1282 VSS.n817 VSS.n15 3.55797
R1283 VSS.n13 VSS.n14 2.87251
R1284 VSS.n823 VSS.n14 3.55797
R1285 VSS.n8 VSS.n58 2.87251
R1286 VSS.n220 VSS.n58 3.55797
R1287 VSS.n60 VSS.n657 3.55797
R1288 VSS.n8 VSS.n60 2.87251
R1289 VSS.n658 VSS.n61 3.55797
R1290 VSS.n8 VSS.n61 2.87251
R1291 VSS.n62 VSS.n656 3.55797
R1292 VSS.n62 VSS.n7 2.87251
R1293 VSS.n647 VSS.n63 3.55797
R1294 VSS.n7 VSS.n63 2.87251
R1295 VSS.n64 VSS.n646 3.55797
R1296 VSS.n64 VSS.n7 2.87251
R1297 VSS.n636 VSS.n65 3.55797
R1298 VSS.n7 VSS.n65 2.87251
R1299 VSS.n66 VSS.n635 3.55797
R1300 VSS.n66 VSS.n7 2.87251
R1301 VSS.n626 VSS.n67 3.55797
R1302 VSS.n7 VSS.n67 2.87251
R1303 VSS.n68 VSS.n625 3.55797
R1304 VSS.n68 VSS.n6 2.87251
R1305 VSS.n615 VSS.n69 3.55797
R1306 VSS.n6 VSS.n69 2.87251
R1307 VSS.n70 VSS.n614 3.55797
R1308 VSS.n70 VSS.n6 2.87251
R1309 VSS.n605 VSS.n71 3.55797
R1310 VSS.n6 VSS.n71 2.87251
R1311 VSS.n72 VSS.n604 3.55797
R1312 VSS.n72 VSS.n6 2.87251
R1313 VSS.n594 VSS.n73 3.55797
R1314 VSS.n6 VSS.n73 2.87251
R1315 VSS.n74 VSS.n593 3.55797
R1316 VSS.n74 VSS.n6 2.87251
R1317 VSS.n584 VSS.n75 3.55797
R1318 VSS.n6 VSS.n75 2.87251
R1319 VSS.n76 VSS.n583 3.55797
R1320 VSS.n76 VSS.n5 2.87251
R1321 VSS.n575 VSS.n77 3.55797
R1322 VSS.n5 VSS.n77 2.87251
R1323 VSS.n78 VSS.n574 3.55797
R1324 VSS.n78 VSS.n5 2.87251
R1325 VSS.n565 VSS.n79 3.55797
R1326 VSS.n5 VSS.n79 2.87251
R1327 VSS.n80 VSS.n564 3.55797
R1328 VSS.n80 VSS.n1 2.87251
R1329 VSS.n555 VSS.n81 3.55797
R1330 VSS.n1 VSS.n81 2.87251
R1331 VSS.n82 VSS.n554 3.55797
R1332 VSS.n82 VSS.n1 2.87251
R1333 VSS.t10 VSS.n83 2.87251
R1334 VSS.n332 VSS.n83 3.55797
R1335 VSS.n84 VSS.n478 3.55797
R1336 VSS.n84 VSS.t10 2.87251
R1337 VSS.n480 VSS.n85 3.55797
R1338 VSS.t10 VSS.n85 2.87251
R1339 VSS.n86 VSS.n472 3.55797
R1340 VSS.n86 VSS.n4 2.87251
R1341 VSS.n483 VSS.n87 3.55797
R1342 VSS.n4 VSS.n87 2.87251
R1343 VSS.n88 VSS.n467 3.55797
R1344 VSS.n88 VSS.n4 2.87251
R1345 VSS.n486 VSS.n89 3.55797
R1346 VSS.n4 VSS.n89 2.87251
R1347 VSS.n90 VSS.n464 3.55797
R1348 VSS.n90 VSS.n4 2.87251
R1349 VSS.n489 VSS.n91 3.55797
R1350 VSS.n4 VSS.n91 2.87251
R1351 VSS.n92 VSS.n459 3.55797
R1352 VSS.n92 VSS.n4 2.87251
R1353 VSS.n492 VSS.n93 3.55797
R1354 VSS.n4 VSS.n93 2.87251
R1355 VSS.n94 VSS.n454 3.55797
R1356 VSS.n94 VSS.n3 2.87251
R1357 VSS.n495 VSS.n95 3.55797
R1358 VSS.n3 VSS.n95 2.87251
R1359 VSS.n96 VSS.n449 3.55797
R1360 VSS.n96 VSS.n3 2.87251
R1361 VSS.n498 VSS.n97 3.55797
R1362 VSS.n3 VSS.n97 2.87251
R1363 VSS.n98 VSS.n444 3.55797
R1364 VSS.n98 VSS.n3 2.87251
R1365 VSS.n501 VSS.n99 3.55797
R1366 VSS.n3 VSS.n99 2.87251
R1367 VSS.n100 VSS.n439 3.55797
R1368 VSS.n100 VSS.n3 2.87251
R1369 VSS.n504 VSS.n101 3.55797
R1370 VSS.n3 VSS.n101 2.87251
R1371 VSS.n102 VSS.n434 3.55797
R1372 VSS.n102 VSS.n2 2.87251
R1373 VSS.n507 VSS.n103 3.55797
R1374 VSS.n2 VSS.n103 2.87251
R1375 VSS.n104 VSS.n429 3.55797
R1376 VSS.n104 VSS.n2 2.87251
R1377 VSS.n510 VSS.n105 3.55797
R1378 VSS.n2 VSS.n105 2.87251
R1379 VSS.n106 VSS.n425 3.55797
R1380 VSS.n106 VSS.n2 2.87251
R1381 VSS.n513 VSS.n107 3.55797
R1382 VSS.n2 VSS.n107 2.87251
R1383 VSS.n108 VSS.n422 3.55797
R1384 VSS.n108 VSS.n2 2.87251
R1385 VSS.n516 VSS.n109 3.55797
R1386 VSS.n2 VSS.n109 2.87251
R1387 VSS.n110 VSS.n416 3.55797
R1388 VSS.n110 VSS.n0 2.87251
R1389 VSS.n519 VSS.n111 3.55797
R1390 VSS.n0 VSS.n111 2.87251
R1391 VSS.n112 VSS.n413 3.55797
R1392 VSS.n112 VSS.n0 2.87251
R1393 VSS.n522 VSS.n113 3.55797
R1394 VSS.n0 VSS.n113 2.87251
R1395 VSS.n114 VSS.n408 3.55797
R1396 VSS.n114 VSS.n0 2.87251
R1397 VSS.n525 VSS.n115 3.55797
R1398 VSS.n0 VSS.n115 2.87251
R1399 VSS.n116 VSS.n403 3.55797
R1400 VSS.n116 VSS.n0 2.87251
R1401 VSS.n528 VSS.n117 3.55797
R1402 VSS.n0 VSS.n117 2.87251
R1403 VSS.n118 VSS.n398 3.55797
R1404 VSS.n118 VSS.n1 2.87251
R1405 VSS.n531 VSS.n119 3.55797
R1406 VSS.n1 VSS.n119 2.87251
R1407 VSS.n120 VSS.n393 3.55797
R1408 VSS.n120 VSS.n1 2.87251
R1409 VSS.n534 VSS.n121 3.55797
R1410 VSS.n1 VSS.n121 2.87251
R1411 VSS.n122 VSS.n389 3.55797
R1412 VSS.n122 VSS.n1 2.87251
R1413 VSS.n537 VSS.n123 3.55797
R1414 VSS.n1 VSS.n123 2.87251
R1415 VSS.n124 VSS.n385 3.55797
R1416 VSS.n124 VSS.n1 2.87251
R1417 VSS.n540 VSS.n125 3.55797
R1418 VSS.n1 VSS.n125 2.87251
R1419 VSS.n126 VSS.n381 3.55797
R1420 VSS.n126 VSS.n1 2.87251
R1421 VSS.n612 VSS.t8 5.02477
R1422 VSS.n601 VSS.t5 5.02477
R1423 VSS.n5 VSS.n1 2.52081
R1424 VSS.n13 VSS.n12 1.8005
R1425 VSS.n12 VSS.n11 1.8005
R1426 VSS.n11 VSS.n10 1.8005
R1427 VSS.n10 VSS.n9 1.8005
R1428 VSS.n9 VSS.n8 1.8005
R1429 VSS.n7 VSS.n6 1.8005
R1430 VSS.n6 VSS.n5 1.8005
R1431 VSS.n3 VSS.n4 1.8005
R1432 VSS.n2 VSS.n3 1.8005
R1433 VSS.n0 VSS.n2 1.8005
R1434 VSS.n1 VSS.n0 1.8005
R1435 VSS.n4 VSS.t10 1.64711
R1436 VSS VSS.n13 1.38998
R1437 VSS.n13 VSS.t10 1.32836
R1438 VSS.n8 VSS.n7 1.28331
C0 r1 out 0.01632f
C1 r12 out 0
C2 r4 in 0
C3 r5 out 0.01604f
C4 r6 in 0
C5 r10 r8 0.12655f
C6 r2 r4 0.12655f
C7 r13 r11 0.12655f
C8 r9 r11 0.12655f
C9 r7 r5 0.12655f
C10 r6 r4 0.12655f
C11 r8 in 0
C12 r7 out 0.0234f
C13 r13 out 0.01604f
C14 r15 out 0.01632f
C15 r12 r10 0.12655f
C16 r9 out 0.0234f
C17 r3 r1 0.12655f
C18 r12 r14 0.12655f
C19 r8 out 0
C20 r3 r5 0.12655f
C21 r10 out 0
C22 r9 r7 0.12655f
C23 r13 r15 0.12655f
C24 r6 r8 0.12655f
C25 r14 out 0.12683f
C26 r3 out 0.01604f
C27 r2 in 0.12683f
C28 r11 out 0.01604f
C29 in VSS 5.78104f
C30 r15 VSS 0.75167f
C31 r14 VSS 0.69297f
C32 r13 VSS 0.60157f
C33 r12 VSS 0.69278f
C34 r11 VSS 0.60178f
C35 r10 VSS 0.68987f
C36 r9 VSS 0.56502f
C37 r8 VSS 0.62185f
C38 r7 VSS 0.56502f
C39 r6 VSS 0.68987f
C40 r5 VSS 0.60178f
C41 r4 VSS 0.69278f
C42 r3 VSS 0.60157f
C43 r2 VSS 0.69297f
C44 r1 VSS 0.74901f
C45 VSS.t10 VSS 25.1733f
.ends
