* amp_dpc_ts: magic R+C extraction of layout/amp_dpc_ts.gds (layout/pex.sh)
.subckt amp_dpc_ts inp inn nb outp outn VDD VSS lna_lo_n
X0 outn.t4 inp.t1 sp VSS.t24 sky130_fd_pr__nfet_01v8 ad=0.75 pd=5.3 as=0.75 ps=5.3 w=5 l=0.15
X1 VDD.t0 outn.t1 VSS.t21 sky130_fd_pr__res_high_po_0p69 l=7.38
X2 sp inp.t0 outn.t5 VSS.t25 sky130_fd_pr__nfet_01v8 ad=1.5 pd=10.6 as=0.75 ps=5.3 w=5 l=0.15
X3 outp.t0 sa VSS.t0 sky130_fd_pr__res_high_po_1p41 l=0.62
X4 sp sn sky130_fd_pr__cap_mim_m3_1 l=21.33 w=6.8
X5 VDD.t9 gi VDD.t8 VDD.t7 sky130_fd_pr__pfet_01v8 ad=1.5 pd=10.6 as=0 ps=0 w=5 l=5
X6 VSS.t10 nb.t8 sp VSS.t9 sky130_fd_pr__nfet_01v8 ad=0.45 pd=3.3 as=0.45 ps=3.3 w=3 l=0.5
X7 outp.t5 VDD.t10 VSS.t21 sky130_fd_pr__res_high_po_0p69 l=7.38
X8 gi lna_lo_n.t0 VSS.t2 sky130_fd_pr__res_xhigh_po_0p35 l=2.71
X9 sp nb.t9 VSS.t8 VSS.t7 sky130_fd_pr__nfet_01v8 ad=0.45 pd=3.3 as=0.45 ps=3.3 w=3 l=0.5
X10 sn nb.t5 VSS.t15 VSS.t3 sky130_fd_pr__nfet_01v8 ad=0.45 pd=3.3 as=0.9 ps=6.6 w=3 l=0.5
X11 VSS.t20 nb.t0 sn VSS.t13 sky130_fd_pr__nfet_01v8 ad=0.9 pd=6.6 as=0.45 ps=3.3 w=3 l=0.5
X12 sn nb.t1 VSS.t19 VSS.t11 sky130_fd_pr__nfet_01v8 ad=0.45 pd=3.3 as=0.45 ps=3.3 w=3 l=0.5
X13 a_1156_10545# gi sa VDD.t1 sky130_fd_pr__pfet_01v8 ad=0.45 pd=3.3 as=0.9 ps=6.6 w=3 l=0.15
X14 outn.t0 a_1156_10545# VSS.t1 sky130_fd_pr__res_high_po_1p41 l=0.62
X15 VSS.t6 nb.t10 sp VSS.t5 sky130_fd_pr__nfet_01v8 ad=0.45 pd=3.3 as=0.45 ps=3.3 w=3 l=0.5
X16 sa gi a_1156_10545# VDD.t4 sky130_fd_pr__pfet_01v8 ad=0.45 pd=3.3 as=0.45 ps=3.3 w=3 l=0.15
X17 sa gi a_1156_10545# VDD.t2 sky130_fd_pr__pfet_01v8 ad=0.45 pd=3.3 as=0.45 ps=3.3 w=3 l=0.15
X18 VSS.t18 nb.t2 sn VSS.t9 sky130_fd_pr__nfet_01v8 ad=0.45 pd=3.3 as=0.45 ps=3.3 w=3 l=0.5
X19 sn nb.t3 VSS.t17 VSS.t7 sky130_fd_pr__nfet_01v8 ad=0.45 pd=3.3 as=0.45 ps=3.3 w=3 l=0.5
X20 outp.t1 inn.t3 sn VSS.t22 sky130_fd_pr__nfet_01v8 ad=0.75 pd=5.3 as=1.5 ps=10.6 w=5 l=0.15
X21 a_1156_10545# gi sa VDD.t5 sky130_fd_pr__pfet_01v8 ad=0.45 pd=3.3 as=0.45 ps=3.3 w=3 l=0.15
X22 a_1156_10545# gi sa VDD.t3 sky130_fd_pr__pfet_01v8 ad=0.45 pd=3.3 as=0.45 ps=3.3 w=3 l=0.15
X23 sn inn.t2 outp.t2 VSS.t23 sky130_fd_pr__nfet_01v8 ad=0.75 pd=5.3 as=0.75 ps=5.3 w=5 l=0.15
X24 sn sp sky130_fd_pr__cap_mim_m3_1 l=21.33 w=6.8
X25 sp nb.t11 VSS.t4 VSS.t3 sky130_fd_pr__nfet_01v8 ad=0.45 pd=3.3 as=0.9 ps=6.6 w=3 l=0.5
X26 outp.t3 inn.t1 sn VSS.t24 sky130_fd_pr__nfet_01v8 ad=0.75 pd=5.3 as=0.75 ps=5.3 w=5 l=0.15
X27 VSS.t14 nb.t6 sp VSS.t13 sky130_fd_pr__nfet_01v8 ad=0.9 pd=6.6 as=0.45 ps=3.3 w=3 l=0.5
X28 sa gi a_1156_10545# VDD.t6 sky130_fd_pr__pfet_01v8 ad=0.9 pd=6.6 as=0.45 ps=3.3 w=3 l=0.15
X29 sn inn.t0 outp.t4 VSS.t25 sky130_fd_pr__nfet_01v8 ad=1.5 pd=10.6 as=0.75 ps=5.3 w=5 l=0.15
X30 outn.t2 inp.t3 sp VSS.t22 sky130_fd_pr__nfet_01v8 ad=0.75 pd=5.3 as=1.5 ps=10.6 w=5 l=0.15
X31 sp nb.t7 VSS.t12 VSS.t11 sky130_fd_pr__nfet_01v8 ad=0.45 pd=3.3 as=0.45 ps=3.3 w=3 l=0.5
X32 VSS.t16 nb.t4 sn VSS.t5 sky130_fd_pr__nfet_01v8 ad=0.45 pd=3.3 as=0.45 ps=3.3 w=3 l=0.5
X33 sp inp.t2 outn.t3 VSS.t23 sky130_fd_pr__nfet_01v8 ad=0.75 pd=5.3 as=0.75 ps=5.3 w=5 l=0.15
R0 lna_lo_n.n8 lna_lo_n.n3 50.6672
R1 lna_lo_n.n15 lna_lo_n.n2 17.8167
R2 lna_lo_n.n16 lna_lo_n.n15 15.9135
R3 lna_lo_n.n6 lna_lo_n.n4 13.1884
R4 lna_lo_n.n7 lna_lo_n.n6 13.1662
R5 lna_lo_n.n9 lna_lo_n.n7 13.1662
R6 lna_lo_n.n10 lna_lo_n.n5 13.1662
R7 lna_lo_n.n14 lna_lo_n.n13 13.1662
R8 lna_lo_n.n14 lna_lo_n.n1 9.3005
R9 lna_lo_n.n13 lna_lo_n.n12 9.3005
R10 lna_lo_n.n13 lna_lo_n.n2 9.3005
R11 lna_lo_n.n11 lna_lo_n.n10 9.3005
R12 lna_lo_n.n10 lna_lo_n.n9 9.3005
R13 lna_lo_n.n7 lna_lo_n.n5 9.3005
R14 lna_lo_n.n6 lna_lo_n.t0 7.13193
R15 lna_lo_n.n8 lna_lo_n.n2 6.76621
R16 lna_lo_n.n13 lna_lo_n.n3 6.76621
R17 lna_lo_n.n9 lna_lo_n.n8 6.4005
R18 lna_lo_n.n10 lna_lo_n.n3 6.4005
R19 lna_lo_n.n17 lna_lo_n.n0 4.55819
R20 lna_lo_n.n17 lna_lo_n.n16 4.5005
R21 lna_lo_n.n5 lna_lo_n.n4 3.8419
R22 lna_lo_n lna_lo_n.n17 3.8077
R23 lna_lo_n.n11 lna_lo_n.n4 2.85946
R24 lna_lo_n.n15 lna_lo_n.n14 2.72607
R25 lna_lo_n.n12 lna_lo_n.n11 0.113
R26 lna_lo_n.n12 lna_lo_n.n0 0.0958125
R27 lna_lo_n.n16 lna_lo_n.n1 0.0833125
R28 lna_lo_n.n1 lna_lo_n.n0 0.0176875
R29 inn.n0 inn.t0 1283.35
R30 inn.n1 inn.t2 1283.29
R31 inn.n2 inn.t3 1058.39
R32 inn.n0 inn.t1 1058.36
R33 inn inn.n2 2.76478
R34 inn.n1 inn.n0 0.0609839
R35 inn.n2 inn.n1 0.0314035
R36 nb.n5 nb.t0 408.675
R37 nb.n0 nb.t6 408.675
R38 nb.n8 nb.t4 408.567
R39 nb.n6 nb.t2 408.567
R40 nb.n3 nb.t10 408.567
R41 nb.n1 nb.t8 408.567
R42 nb.n9 nb.t5 341.087
R43 nb.n7 nb.t3 341.087
R44 nb.n5 nb.t1 341.087
R45 nb.n4 nb.t11 341.087
R46 nb.n2 nb.t9 341.087
R47 nb.n0 nb.t7 341.087
R48 nb.n10 nb.n9 4.55552
R49 nb.n10 nb.n4 4.55452
R50 nb.n10 nb 3.40675
R51 nb nb.n10 0.313
R52 nb.n6 nb.n5 0.108027
R53 nb.n7 nb.n6 0.108027
R54 nb.n8 nb.n7 0.108027
R55 nb.n9 nb.n8 0.108027
R56 nb.n1 nb.n0 0.108027
R57 nb.n2 nb.n1 0.108027
R58 nb.n3 nb.n2 0.108027
R59 nb.n4 nb.n3 0.108027
R60 inp.n0 inp.t0 1283.35
R61 inp.n1 inp.t2 1283.29
R62 inp.n2 inp.t3 1058.39
R63 inp.n0 inp.t1 1058.36
R64 inp inp.n2 2.76478
R65 inp.n1 inp.n0 0.0609839
R66 inp.n2 inp.n1 0.0314035
R67 outn.n3 outn.n2 185
R68 outn.n10 outn.n9 185
R69 outn.n5 outn.n2 27.1064
R70 outn.n12 outn.n9 27.1064
R71 outn.n5 outn.n4 26.125
R72 outn.n12 outn.n11 26.125
R73 outn.n4 outn.n3 13.6337
R74 outn.n11 outn.n10 13.6337
R75 outn.n7 outn.n2 9.32967
R76 outn.n14 outn.n9 9.32967
R77 outn.n6 outn.n5 9.3005
R78 outn.n13 outn.n12 9.3005
R79 outn.n18 outn.n17 6.8205
R80 outn.n19 outn.t0 6.71098
R81 outn.n18 outn 5.18401
R82 outn.n8 outn.n1 4.55338
R83 outn.n15 outn.n0 4.55338
R84 outn.n15 outn.n14 4.5005
R85 outn.n8 outn.n7 4.5005
R86 outn.n3 outn.t3 3.6005
R87 outn.n3 outn.t2 3.6005
R88 outn.n10 outn.t5 3.6005
R89 outn.n10 outn.t4 3.6005
R90 outn.n4 outn.n1 3.54039
R91 outn.n11 outn.n0 3.54039
R92 outn.n16 outn.t1 3.31245
R93 outn.n17 outn.n16 2.42342
R94 outn.n19 outn.n18 1.57813
R95 outn outn.n19 0.642536
R96 outn.n17 outn 0.391125
R97 outn.n16 outn.n15 0.357643
R98 outn.n15 outn.n8 0.268357
R99 outn.n7 outn.n6 0.126462
R100 outn.n14 outn.n13 0.126462
R101 outn.n6 outn.n1 0.0149231
R102 outn.n13 outn.n0 0.0149231
R103 outp.n6 outp.n5 86.1871
R104 outp.n13 outp.n12 86.1871
R105 outp.n4 outp.n3 33.2743
R106 outp.n11 outp.n10 33.2743
R107 outp.n7 outp.n6 21.958
R108 outp.n14 outp.n13 21.958
R109 outp.n5 outp.n4 17.3653
R110 outp.n12 outp.n11 17.3653
R111 outp.n6 outp.n3 12.6288
R112 outp.n13 outp.n10 12.6288
R113 outp.n18 outp.t0 9.88691
R114 outp.n3 outp.n2 9.3005
R115 outp.n10 outp.n9 9.3005
R116 outp.n17 outp 6.86738
R117 outp.n18 outp.n17 4.55455
R118 outp.n8 outp.n1 4.55338
R119 outp.n15 outp.n0 4.55338
R120 outp.n15 outp.n14 4.5005
R121 outp.n8 outp.n7 4.5005
R122 outp.n5 outp.t2 3.6005
R123 outp.n5 outp.t1 3.6005
R124 outp.n12 outp.t4 3.6005
R125 outp.n12 outp.t3 3.6005
R126 outp.n16 outp.t5 3.31268
R127 outp outp.n16 2.81404
R128 outp.n17 outp 2.27824
R129 outp.n4 outp.n1 1.08791
R130 outp.n11 outp.n0 1.08791
R131 outp outp.n18 0.571892
R132 outp.n16 outp.n15 0.357643
R133 outp.n15 outp.n8 0.268357
R134 outp.n7 outp.n2 0.126462
R135 outp.n14 outp.n9 0.126462
R136 outp.n2 outp.n1 0.0149231
R137 outp.n9 outp.n0 0.0149231
R138 VDD.n55 VDD.n42 649.413
R139 VDD.n103 VDD.n12 649.413
R140 VDD.n77 VDD.n45 649.413
R141 VDD.n101 VDD.n22 649.413
R142 VDD.n213 VDD.n174 628.236
R143 VDD.n283 VDD.n143 628.236
R144 VDD.n286 VDD.n131 628.236
R145 VDD.n215 VDD.n172 628.236
R146 VDD.n83 VDD.n42 254.119
R147 VDD.n84 VDD.n83 254.119
R148 VDD.n84 VDD.n4 254.119
R149 VDD.n114 VDD.n4 254.119
R150 VDD.n114 VDD.n5 254.119
R151 VDD.n110 VDD.n5 254.119
R152 VDD.n110 VDD.n9 254.119
R153 VDD.n95 VDD.n9 254.119
R154 VDD.n95 VDD.n12 254.119
R155 VDD.n59 VDD.n58 254.119
R156 VDD.n63 VDD.n62 254.119
R157 VDD.n67 VDD.n66 254.119
R158 VDD.n69 VDD.n52 254.119
R159 VDD.n73 VDD.n47 254.119
R160 VDD.n81 VDD.n45 254.119
R161 VDD.n81 VDD.n41 254.119
R162 VDD.n87 VDD.n41 254.119
R163 VDD.n87 VDD.n6 254.119
R164 VDD.n7 VDD.n6 254.119
R165 VDD.n8 VDD.n7 254.119
R166 VDD.n93 VDD.n8 254.119
R167 VDD.n97 VDD.n93 254.119
R168 VDD.n97 VDD.n22 254.119
R169 VDD.n103 VDD.n14 254.119
R170 VDD.n25 VDD.n24 254.119
R171 VDD.n29 VDD.n28 254.119
R172 VDD.n33 VDD.n32 254.119
R173 VDD.n37 VDD.n36 254.119
R174 VDD.n101 VDD.n21 254.119
R175 VDD.n213 VDD.n167 254.119
R176 VDD.n223 VDD.n167 254.119
R177 VDD.n223 VDD.n164 254.119
R178 VDD.n228 VDD.n164 254.119
R179 VDD.n228 VDD.n165 254.119
R180 VDD.n165 VDD.n153 254.119
R181 VDD.n239 VDD.n153 254.119
R182 VDD.n239 VDD.n151 254.119
R183 VDD.n243 VDD.n151 254.119
R184 VDD.n243 VDD.n150 254.119
R185 VDD.n247 VDD.n150 254.119
R186 VDD.n247 VDD.n148 254.119
R187 VDD.n251 VDD.n148 254.119
R188 VDD.n251 VDD.n145 254.119
R189 VDD.n255 VDD.n145 254.119
R190 VDD.n255 VDD.n143 254.119
R191 VDD.n142 VDD.n141 254.119
R192 VDD.n278 VDD.n141 254.119
R193 VDD.n276 VDD.n275 254.119
R194 VDD.n272 VDD.n271 254.119
R195 VDD.n268 VDD.n267 254.119
R196 VDD.n264 VDD.n263 254.119
R197 VDD.n260 VDD.n259 254.119
R198 VDD.n286 VDD.n133 254.119
R199 VDD.n215 VDD.n169 254.119
R200 VDD.n221 VDD.n169 254.119
R201 VDD.n221 VDD.n160 254.119
R202 VDD.n230 VDD.n160 254.119
R203 VDD.n230 VDD.n161 254.119
R204 VDD.n161 VDD.n155 254.119
R205 VDD.n237 VDD.n155 254.119
R206 VDD.n237 VDD.n156 254.119
R207 VDD.n156 VDD.n123 254.119
R208 VDD.n124 VDD.n123 254.119
R209 VDD.n125 VDD.n124 254.119
R210 VDD.n146 VDD.n125 254.119
R211 VDD.n146 VDD.n128 254.119
R212 VDD.n129 VDD.n128 254.119
R213 VDD.n130 VDD.n129 254.119
R214 VDD.n131 VDD.n130 254.119
R215 VDD.n209 VDD.n207 254.119
R216 VDD.n205 VDD.n176 254.119
R217 VDD.n201 VDD.n199 254.119
R218 VDD.n197 VDD.n178 254.119
R219 VDD.n193 VDD.n191 254.119
R220 VDD.n189 VDD.n180 254.119
R221 VDD.n185 VDD.n183 254.119
R222 VDD.n104 VDD.n103 185
R223 VDD.n103 VDD.n102 185
R224 VDD.n14 VDD.n13 185
R225 VDD.n24 VDD.n23 185
R226 VDD.n26 VDD.n25 185
R227 VDD.n28 VDD.n27 185
R228 VDD.n30 VDD.n29 185
R229 VDD.n32 VDD.n31 185
R230 VDD.n34 VDD.n33 185
R231 VDD.n36 VDD.n35 185
R232 VDD.n38 VDD.n37 185
R233 VDD.n39 VDD.n21 185
R234 VDD.n101 VDD.n100 185
R235 VDD.n102 VDD.n101 185
R236 VDD.n99 VDD.n22 185
R237 VDD.n22 VDD.n15 185
R238 VDD.n98 VDD.n97 185
R239 VDD.n97 VDD.n96 185
R240 VDD.n93 VDD.n92 185
R241 VDD.n94 VDD.n93 185
R242 VDD.n91 VDD.n8 185
R243 VDD.n111 VDD.n8 185
R244 VDD.n90 VDD.n7 185
R245 VDD.n112 VDD.n7 185
R246 VDD.n89 VDD.n6 185
R247 VDD.n113 VDD.n6 185
R248 VDD.n88 VDD.n87 185
R249 VDD.n87 VDD.n86 185
R250 VDD.n41 VDD.n40 185
R251 VDD.n85 VDD.n41 185
R252 VDD.n81 VDD.n80 185
R253 VDD.n82 VDD.n81 185
R254 VDD.n79 VDD.n45 185
R255 VDD.n45 VDD.n44 185
R256 VDD.n78 VDD.n77 185
R257 VDD.n47 VDD.n46 185
R258 VDD.n73 VDD.n72 185
R259 VDD.n71 VDD.n52 185
R260 VDD.n70 VDD.n69 185
R261 VDD.n68 VDD.n67 185
R262 VDD.n66 VDD.n65 185
R263 VDD.n64 VDD.n63 185
R264 VDD.n62 VDD.n61 185
R265 VDD.n60 VDD.n59 185
R266 VDD.n58 VDD.n57 185
R267 VDD.n56 VDD.n55 185
R268 VDD.n54 VDD.n42 185
R269 VDD.n44 VDD.n42 185
R270 VDD.n83 VDD.n43 185
R271 VDD.n83 VDD.n82 185
R272 VDD.n84 VDD.n3 185
R273 VDD.n85 VDD.n84 185
R274 VDD.n116 VDD.n4 185
R275 VDD.n86 VDD.n4 185
R276 VDD.n115 VDD.n114 185
R277 VDD.n114 VDD.n113 185
R278 VDD.n10 VDD.n5 185
R279 VDD.n112 VDD.n5 185
R280 VDD.n110 VDD.n109 185
R281 VDD.n111 VDD.n110 185
R282 VDD.n108 VDD.n9 185
R283 VDD.n94 VDD.n9 185
R284 VDD.n95 VDD.n11 185
R285 VDD.n96 VDD.n95 185
R286 VDD.n105 VDD.n12 185
R287 VDD.n15 VDD.n12 185
R288 VDD.n172 VDD.n171 185
R289 VDD.n183 VDD.n181 185
R290 VDD.n186 VDD.n185 185
R291 VDD.n187 VDD.n180 185
R292 VDD.n189 VDD.n188 185
R293 VDD.n191 VDD.n179 185
R294 VDD.n194 VDD.n193 185
R295 VDD.n195 VDD.n178 185
R296 VDD.n197 VDD.n196 185
R297 VDD.n199 VDD.n177 185
R298 VDD.n202 VDD.n201 185
R299 VDD.n203 VDD.n176 185
R300 VDD.n205 VDD.n204 185
R301 VDD.n207 VDD.n175 185
R302 VDD.n210 VDD.n209 185
R303 VDD.n211 VDD.n174 185
R304 VDD.n213 VDD.n212 185
R305 VDD.n214 VDD.n213 185
R306 VDD.n167 VDD.n166 185
R307 VDD.n168 VDD.n167 185
R308 VDD.n224 VDD.n223 185
R309 VDD.n223 VDD.n222 185
R310 VDD.n225 VDD.n164 185
R311 VDD.n164 VDD.n162 185
R312 VDD.n228 VDD.n227 185
R313 VDD.n229 VDD.n228 185
R314 VDD.n226 VDD.n165 185
R315 VDD.n165 VDD.n163 185
R316 VDD.n153 VDD.n152 185
R317 VDD.n154 VDD.n153 185
R318 VDD.n240 VDD.n239 185
R319 VDD.n239 VDD.n238 185
R320 VDD.n241 VDD.n151 185
R321 VDD.n151 VDD.t7 185
R322 VDD.n243 VDD.n242 185
R323 VDD.n244 VDD.n243 185
R324 VDD.n150 VDD.n149 185
R325 VDD.n245 VDD.n150 185
R326 VDD.n248 VDD.n247 185
R327 VDD.n247 VDD.n246 185
R328 VDD.n249 VDD.n148 185
R329 VDD.n148 VDD.n147 185
R330 VDD.n251 VDD.n250 185
R331 VDD.n252 VDD.n251 185
R332 VDD.n145 VDD.n144 185
R333 VDD.n253 VDD.n145 185
R334 VDD.n256 VDD.n255 185
R335 VDD.n255 VDD.n254 185
R336 VDD.n257 VDD.n143 185
R337 VDD.n143 VDD.n134 185
R338 VDD.n283 VDD.n282 185
R339 VDD.n281 VDD.n142 185
R340 VDD.n280 VDD.n141 185
R341 VDD.n285 VDD.n141 185
R342 VDD.n279 VDD.n278 185
R343 VDD.n277 VDD.n276 185
R344 VDD.n275 VDD.n274 185
R345 VDD.n273 VDD.n272 185
R346 VDD.n271 VDD.n270 185
R347 VDD.n269 VDD.n268 185
R348 VDD.n267 VDD.n266 185
R349 VDD.n265 VDD.n264 185
R350 VDD.n263 VDD.n262 185
R351 VDD.n261 VDD.n260 185
R352 VDD.n259 VDD.n258 185
R353 VDD.n133 VDD.n132 185
R354 VDD.n287 VDD.n286 185
R355 VDD.n286 VDD.n285 185
R356 VDD.n288 VDD.n131 185
R357 VDD.n134 VDD.n131 185
R358 VDD.n291 VDD.n130 185
R359 VDD.n254 VDD.n130 185
R360 VDD.n292 VDD.n129 185
R361 VDD.n253 VDD.n129 185
R362 VDD.n293 VDD.n128 185
R363 VDD.n252 VDD.n128 185
R364 VDD.n146 VDD.n126 185
R365 VDD.n147 VDD.n146 185
R366 VDD.n297 VDD.n125 185
R367 VDD.n246 VDD.n125 185
R368 VDD.n298 VDD.n124 185
R369 VDD.n245 VDD.n124 185
R370 VDD.n299 VDD.n123 185
R371 VDD.n244 VDD.n123 185
R372 VDD.n156 VDD.n121 185
R373 VDD.n156 VDD.t7 185
R374 VDD.n237 VDD.n236 185
R375 VDD.n238 VDD.n237 185
R376 VDD.n235 VDD.n155 185
R377 VDD.n155 VDD.n154 185
R378 VDD.n161 VDD.n157 185
R379 VDD.n163 VDD.n161 185
R380 VDD.n231 VDD.n230 185
R381 VDD.n230 VDD.n229 185
R382 VDD.n160 VDD.n159 185
R383 VDD.n162 VDD.n160 185
R384 VDD.n221 VDD.n220 185
R385 VDD.n222 VDD.n221 185
R386 VDD.n170 VDD.n169 185
R387 VDD.n169 VDD.n168 185
R388 VDD.n216 VDD.n215 185
R389 VDD.n215 VDD.n214 185
R390 VDD.n58 VDD.n48 75.3262
R391 VDD.n62 VDD.n49 75.3262
R392 VDD.n66 VDD.n50 75.3262
R393 VDD.n69 VDD.n51 75.3262
R394 VDD.n74 VDD.n73 75.3262
R395 VDD.n77 VDD.n76 75.3262
R396 VDD.n16 VDD.n14 75.3262
R397 VDD.n25 VDD.n17 75.3262
R398 VDD.n29 VDD.n18 75.3262
R399 VDD.n33 VDD.n19 75.3262
R400 VDD.n37 VDD.n20 75.3262
R401 VDD.n24 VDD.n16 75.3262
R402 VDD.n28 VDD.n17 75.3262
R403 VDD.n32 VDD.n18 75.3262
R404 VDD.n36 VDD.n19 75.3262
R405 VDD.n21 VDD.n20 75.3262
R406 VDD.n76 VDD.n47 75.3262
R407 VDD.n74 VDD.n52 75.3262
R408 VDD.n67 VDD.n51 75.3262
R409 VDD.n63 VDD.n50 75.3262
R410 VDD.n59 VDD.n49 75.3262
R411 VDD.n55 VDD.n48 75.3262
R412 VDD.n284 VDD.n283 75.3262
R413 VDD.n278 VDD.n135 75.3262
R414 VDD.n275 VDD.n136 75.3262
R415 VDD.n271 VDD.n137 75.3262
R416 VDD.n267 VDD.n138 75.3262
R417 VDD.n263 VDD.n139 75.3262
R418 VDD.n259 VDD.n140 75.3262
R419 VDD.n208 VDD.n174 75.3262
R420 VDD.n207 VDD.n206 75.3262
R421 VDD.n200 VDD.n176 75.3262
R422 VDD.n199 VDD.n198 75.3262
R423 VDD.n192 VDD.n178 75.3262
R424 VDD.n191 VDD.n190 75.3262
R425 VDD.n184 VDD.n180 75.3262
R426 VDD.n183 VDD.n182 75.3262
R427 VDD.n182 VDD.n172 75.3262
R428 VDD.n185 VDD.n184 75.3262
R429 VDD.n190 VDD.n189 75.3262
R430 VDD.n193 VDD.n192 75.3262
R431 VDD.n198 VDD.n197 75.3262
R432 VDD.n201 VDD.n200 75.3262
R433 VDD.n206 VDD.n205 75.3262
R434 VDD.n209 VDD.n208 75.3262
R435 VDD.n284 VDD.n142 75.3262
R436 VDD.n276 VDD.n135 75.3262
R437 VDD.n272 VDD.n136 75.3262
R438 VDD.n268 VDD.n137 75.3262
R439 VDD.n264 VDD.n138 75.3262
R440 VDD.n260 VDD.n139 75.3262
R441 VDD.n140 VDD.n133 75.3262
R442 VDD.n105 VDD.n104 69.2711
R443 VDD.n100 VDD.n99 69.2711
R444 VDD.n79 VDD.n78 69.2711
R445 VDD.n56 VDD.n54 69.2711
R446 VDD.n212 VDD.n211 67.0123
R447 VDD.n216 VDD.n171 67.0123
R448 VDD.n282 VDD.n257 67.0123
R449 VDD.n288 VDD.n287 67.0123
R450 VDD.n75 VDD.n44 65.6835
R451 VDD.n102 VDD.n15 65.6835
R452 VDD.n214 VDD.n173 59.1291
R453 VDD.n285 VDD.n134 59.1291
R454 VDD.n82 VDD.n44 57.6734
R455 VDD.n113 VDD.n112 57.6734
R456 VDD.n96 VDD.n15 57.6734
R457 VDD.n102 VDD.n16 54.8384
R458 VDD.n102 VDD.n17 54.8384
R459 VDD.n102 VDD.n18 54.8384
R460 VDD.n102 VDD.n19 54.8384
R461 VDD.n102 VDD.n20 54.8384
R462 VDD.n76 VDD.n75 54.8384
R463 VDD.n75 VDD.n74 54.8384
R464 VDD.n75 VDD.n51 54.8384
R465 VDD.n75 VDD.n50 54.8384
R466 VDD.n75 VDD.n49 54.8384
R467 VDD.n75 VDD.n48 54.8384
R468 VDD.n182 VDD.n173 54.8384
R469 VDD.n184 VDD.n173 54.8384
R470 VDD.n190 VDD.n173 54.8384
R471 VDD.n192 VDD.n173 54.8384
R472 VDD.n198 VDD.n173 54.8384
R473 VDD.n200 VDD.n173 54.8384
R474 VDD.n206 VDD.n173 54.8384
R475 VDD.n208 VDD.n173 54.8384
R476 VDD.n285 VDD.n284 54.8384
R477 VDD.n285 VDD.n135 54.8384
R478 VDD.n285 VDD.n136 54.8384
R479 VDD.n285 VDD.n137 54.8384
R480 VDD.n285 VDD.n138 54.8384
R481 VDD.n285 VDD.n139 54.8384
R482 VDD.n285 VDD.n140 54.8384
R483 VDD.n289 VDD.t9 52.7308
R484 VDD.n217 VDD.t8 52.7308
R485 VDD.n86 VDD.t4 50.4642
R486 VDD.t3 VDD.n111 50.4642
R487 VDD.n214 VDD.n168 47.3034
R488 VDD.n222 VDD.n168 47.3034
R489 VDD.n222 VDD.n162 47.3034
R490 VDD.n229 VDD.n162 47.3034
R491 VDD.n229 VDD.n163 47.3034
R492 VDD.n163 VDD.n154 47.3034
R493 VDD.n238 VDD.n154 47.3034
R494 VDD.n238 VDD.t7 47.3034
R495 VDD.n244 VDD.t7 47.3034
R496 VDD.n245 VDD.n244 47.3034
R497 VDD.n246 VDD.n245 47.3034
R498 VDD.n246 VDD.n147 47.3034
R499 VDD.n252 VDD.n147 47.3034
R500 VDD.n253 VDD.n252 47.3034
R501 VDD.n254 VDD.n253 47.3034
R502 VDD.n254 VDD.n134 47.3034
R503 VDD.n85 VDD.t6 36.046
R504 VDD.t5 VDD.n85 36.046
R505 VDD.n94 VDD.t2 36.046
R506 VDD.t1 VDD.n94 36.046
R507 VDD.n104 VDD.n13 27.1064
R508 VDD.n23 VDD.n13 27.1064
R509 VDD.n26 VDD.n23 27.1064
R510 VDD.n27 VDD.n26 27.1064
R511 VDD.n30 VDD.n27 27.1064
R512 VDD.n31 VDD.n30 27.1064
R513 VDD.n34 VDD.n31 27.1064
R514 VDD.n35 VDD.n34 27.1064
R515 VDD.n38 VDD.n35 27.1064
R516 VDD.n39 VDD.n38 27.1064
R517 VDD.n100 VDD.n39 27.1064
R518 VDD.n80 VDD.n79 27.1064
R519 VDD.n80 VDD.n40 27.1064
R520 VDD.n88 VDD.n40 27.1064
R521 VDD.n89 VDD.n88 27.1064
R522 VDD.n90 VDD.n89 27.1064
R523 VDD.n91 VDD.n90 27.1064
R524 VDD.n92 VDD.n91 27.1064
R525 VDD.n98 VDD.n92 27.1064
R526 VDD.n99 VDD.n98 27.1064
R527 VDD.n57 VDD.n56 27.1064
R528 VDD.n60 VDD.n57 27.1064
R529 VDD.n61 VDD.n60 27.1064
R530 VDD.n64 VDD.n61 27.1064
R531 VDD.n65 VDD.n64 27.1064
R532 VDD.n68 VDD.n65 27.1064
R533 VDD.n70 VDD.n68 27.1064
R534 VDD.n71 VDD.n70 27.1064
R535 VDD.n72 VDD.n71 27.1064
R536 VDD.n72 VDD.n46 27.1064
R537 VDD.n78 VDD.n46 27.1064
R538 VDD.n43 VDD.n3 27.1064
R539 VDD.n116 VDD.n3 27.1064
R540 VDD.n116 VDD.n115 27.1064
R541 VDD.n109 VDD.n10 27.1064
R542 VDD.n109 VDD.n108 27.1064
R543 VDD.n108 VDD.n11 27.1064
R544 VDD.n211 VDD.n210 27.1064
R545 VDD.n210 VDD.n175 27.1064
R546 VDD.n204 VDD.n175 27.1064
R547 VDD.n204 VDD.n203 27.1064
R548 VDD.n203 VDD.n202 27.1064
R549 VDD.n202 VDD.n177 27.1064
R550 VDD.n196 VDD.n177 27.1064
R551 VDD.n196 VDD.n195 27.1064
R552 VDD.n195 VDD.n194 27.1064
R553 VDD.n194 VDD.n179 27.1064
R554 VDD.n188 VDD.n179 27.1064
R555 VDD.n188 VDD.n187 27.1064
R556 VDD.n187 VDD.n186 27.1064
R557 VDD.n186 VDD.n181 27.1064
R558 VDD.n181 VDD.n171 27.1064
R559 VDD.n212 VDD.n166 27.1064
R560 VDD.n224 VDD.n166 27.1064
R561 VDD.n225 VDD.n224 27.1064
R562 VDD.n227 VDD.n225 27.1064
R563 VDD.n227 VDD.n226 27.1064
R564 VDD.n226 VDD.n152 27.1064
R565 VDD.n240 VDD.n152 27.1064
R566 VDD.n241 VDD.n240 27.1064
R567 VDD.n242 VDD.n241 27.1064
R568 VDD.n242 VDD.n149 27.1064
R569 VDD.n248 VDD.n149 27.1064
R570 VDD.n249 VDD.n248 27.1064
R571 VDD.n250 VDD.n249 27.1064
R572 VDD.n250 VDD.n144 27.1064
R573 VDD.n256 VDD.n144 27.1064
R574 VDD.n257 VDD.n256 27.1064
R575 VDD.n282 VDD.n281 27.1064
R576 VDD.n281 VDD.n280 27.1064
R577 VDD.n280 VDD.n279 27.1064
R578 VDD.n279 VDD.n277 27.1064
R579 VDD.n277 VDD.n274 27.1064
R580 VDD.n274 VDD.n273 27.1064
R581 VDD.n273 VDD.n270 27.1064
R582 VDD.n270 VDD.n269 27.1064
R583 VDD.n269 VDD.n266 27.1064
R584 VDD.n266 VDD.n265 27.1064
R585 VDD.n265 VDD.n262 27.1064
R586 VDD.n262 VDD.n261 27.1064
R587 VDD.n261 VDD.n258 27.1064
R588 VDD.n258 VDD.n132 27.1064
R589 VDD.n287 VDD.n132 27.1064
R590 VDD.n216 VDD.n170 27.1064
R591 VDD.n220 VDD.n170 27.1064
R592 VDD.n220 VDD.n159 27.1064
R593 VDD.n231 VDD.n159 27.1064
R594 VDD.n231 VDD.n157 27.1064
R595 VDD.n235 VDD.n157 27.1064
R596 VDD.n236 VDD.n235 27.1064
R597 VDD.n236 VDD.n121 27.1064
R598 VDD.n299 VDD.n121 27.1064
R599 VDD.n299 VDD.n298 27.1064
R600 VDD.n298 VDD.n297 27.1064
R601 VDD.n297 VDD.n126 27.1064
R602 VDD.n293 VDD.n126 27.1064
R603 VDD.n293 VDD.n292 27.1064
R604 VDD.n292 VDD.n291 27.1064
R605 VDD.n291 VDD.n288 27.1064
R606 VDD.n82 VDD.t6 21.6278
R607 VDD.n86 VDD.t5 21.6278
R608 VDD.n111 VDD.t2 21.6278
R609 VDD.n96 VDD.t1 21.6278
R610 VDD.n289 VDD.n288 9.37422
R611 VDD.n217 VDD.n216 9.37422
R612 VDD.n109 VDD.n1 9.3005
R613 VDD.n108 VDD.n107 9.3005
R614 VDD.n3 VDD.n2 9.3005
R615 VDD.n117 VDD.n116 9.3005
R616 VDD.n291 VDD.n290 9.3005
R617 VDD.n292 VDD.n127 9.3005
R618 VDD.n294 VDD.n293 9.3005
R619 VDD.n295 VDD.n126 9.3005
R620 VDD.n297 VDD.n296 9.3005
R621 VDD.n298 VDD.n122 9.3005
R622 VDD.n235 VDD.n234 9.3005
R623 VDD.n233 VDD.n157 9.3005
R624 VDD.n232 VDD.n231 9.3005
R625 VDD.n159 VDD.n158 9.3005
R626 VDD.n220 VDD.n219 9.3005
R627 VDD.n218 VDD.n170 9.3005
R628 VDD.n300 VDD.n299 9.3005
R629 VDD.n301 VDD.n121 9.3005
R630 VDD.n236 VDD.n120 9.3005
R631 VDD.n113 VDD.t4 7.20961
R632 VDD.n112 VDD.t3 7.20961
R633 VDD.n303 VDD.t0 6.75328
R634 VDD.n302 VDD.t10 6.75328
R635 VDD.n54 VDD.n53 5.57074
R636 VDD.n106 VDD.n105 5.57074
R637 VDD.n115 VDD.n0 5.51637
R638 VDD.n10 VDD.n0 5.51637
R639 VDD.n106 VDD.n11 5.50248
R640 VDD.n53 VDD.n43 5.50248
R641 VDD.n303 VDD.n302 4.61286
R642 VDD.n107 VDD.n106 2.02735
R643 VDD.n53 VDD.n2 2.02735
R644 VDD.n119 VDD.n0 1.89332
R645 VDD.n304 VDD.n119 0.78425
R646 VDD VDD.n304 0.517167
R647 VDD.n301 VDD 0.452167
R648 VDD.n107 VDD.n1 0.115885
R649 VDD.n117 VDD.n2 0.115885
R650 VDD.n296 VDD.n122 0.115885
R651 VDD.n296 VDD.n295 0.115885
R652 VDD.n295 VDD.n294 0.115885
R653 VDD.n294 VDD.n127 0.115885
R654 VDD.n290 VDD.n127 0.115885
R655 VDD.n219 VDD.n218 0.115885
R656 VDD.n219 VDD.n158 0.115885
R657 VDD.n232 VDD.n158 0.115885
R658 VDD.n233 VDD.n232 0.115885
R659 VDD.n234 VDD.n233 0.115885
R660 VDD.n300 VDD.n122 0.108412
R661 VDD.n234 VDD.n120 0.108412
R662 VDD.n302 VDD.n301 0.0951053
R663 VDD.n301 VDD.n120 0.0486283
R664 VDD.n301 VDD.n300 0.0486283
R665 VDD.n118 VDD.n1 0.0453718
R666 VDD.n118 VDD.n117 0.0453718
R667 VDD.n290 VDD.n289 0.0421667
R668 VDD.n218 VDD.n217 0.0421667
R669 VDD.n304 VDD.n303 0.0301053
R670 VDD.n119 VDD.n118 0.0083125
R671 VSS.t2 VSS.n99 45125.2
R672 VSS.t1 VSS.t0 14500.5
R673 VSS.n264 VSS.t2 4825.15
R674 VSS.n264 VSS.t1 3651.38
R675 VSS.t0 VSS.n263 2604.08
R676 VSS.n743 VSS.n92 585
R677 VSS.n743 VSS.n154 585
R678 VSS.n744 VSS.n71 585
R679 VSS.n745 VSS.n744 585
R680 VSS.n742 VSS.n70 585
R681 VSS.n742 VSS.n741 585
R682 VSS.n156 VSS.n155 585
R683 VSS.n262 VSS.n156 585
R684 VSS.n162 VSS.n64 585
R685 VSS.n588 VSS.n162 585
R686 VSS.n577 VSS.n63 585
R687 VSS.n577 VSS.n576 585
R688 VSS.n578 VSS.n60 585
R689 VSS.n579 VSS.n578 585
R690 VSS.n574 VSS.n172 585
R691 VSS.n574 VSS.n573 585
R692 VSS.n171 VSS.n54 585
R693 VSS.n173 VSS.n171 585
R694 VSS.n181 VSS.n53 585
R695 VSS.n563 VSS.n181 585
R696 VSS.n551 VSS.n50 585
R697 VSS.n551 VSS.n179 585
R698 VSS.n553 VSS.n552 585
R699 VSS.n554 VSS.n553 585
R700 VSS.n550 VSS.n44 585
R701 VSS.n550 VSS.n549 585
R702 VSS.n190 VSS.n43 585
R703 VSS.n192 VSS.n190 585
R704 VSS.n199 VSS.n42 585
R705 VSS.n539 VSS.n199 585
R706 VSS.n343 VSS.n16 585
R707 VSS.n343 VSS.n198 585
R708 VSS.n345 VSS.n344 585
R709 VSS.n349 VSS.n346 585
R710 VSS.n351 VSS.n350 585
R711 VSS.n353 VSS.n352 585
R712 VSS.n355 VSS.n354 585
R713 VSS.n359 VSS.n341 585
R714 VSS.n361 VSS.n360 585
R715 VSS.n363 VSS.n362 585
R716 VSS.n365 VSS.n364 585
R717 VSS.n369 VSS.n339 585
R718 VSS.n371 VSS.n370 585
R719 VSS.n373 VSS.n372 585
R720 VSS.n375 VSS.n374 585
R721 VSS.n379 VSS.n337 585
R722 VSS.n381 VSS.n380 585
R723 VSS.n383 VSS.n382 585
R724 VSS.n385 VSS.n384 585
R725 VSS.n389 VSS.n335 585
R726 VSS.n391 VSS.n390 585
R727 VSS.n393 VSS.n392 585
R728 VSS.n395 VSS.n394 585
R729 VSS.n399 VSS.n333 585
R730 VSS.n401 VSS.n400 585
R731 VSS.n403 VSS.n402 585
R732 VSS.n405 VSS.n404 585
R733 VSS.n409 VSS.n331 585
R734 VSS.n411 VSS.n410 585
R735 VSS.n413 VSS.n412 585
R736 VSS.n415 VSS.n414 585
R737 VSS.n419 VSS.n329 585
R738 VSS.n421 VSS.n420 585
R739 VSS.n423 VSS.n422 585
R740 VSS.n425 VSS.n424 585
R741 VSS.n429 VSS.n327 585
R742 VSS.n431 VSS.n430 585
R743 VSS.n433 VSS.n432 585
R744 VSS.n435 VSS.n434 585
R745 VSS.n439 VSS.n325 585
R746 VSS.n441 VSS.n440 585
R747 VSS.n443 VSS.n442 585
R748 VSS.n445 VSS.n444 585
R749 VSS.n449 VSS.n323 585
R750 VSS.n451 VSS.n450 585
R751 VSS.n453 VSS.n452 585
R752 VSS.n455 VSS.n454 585
R753 VSS.n321 VSS.n320 585
R754 VSS.n460 VSS.n459 585
R755 VSS.n462 VSS.n460 585
R756 VSS.n735 VSS.n734 585
R757 VSS.n728 VSS.n596 585
R758 VSS.n730 VSS.n729 585
R759 VSS.n727 VSS.n726 585
R760 VSS.n725 VSS.n724 585
R761 VSS.n718 VSS.n598 585
R762 VSS.n720 VSS.n719 585
R763 VSS.n717 VSS.n716 585
R764 VSS.n715 VSS.n714 585
R765 VSS.n708 VSS.n600 585
R766 VSS.n710 VSS.n709 585
R767 VSS.n707 VSS.n706 585
R768 VSS.n705 VSS.n704 585
R769 VSS.n698 VSS.n602 585
R770 VSS.n700 VSS.n699 585
R771 VSS.n697 VSS.n696 585
R772 VSS.n695 VSS.n694 585
R773 VSS.n688 VSS.n604 585
R774 VSS.n690 VSS.n689 585
R775 VSS.n687 VSS.n686 585
R776 VSS.n685 VSS.n684 585
R777 VSS.n678 VSS.n606 585
R778 VSS.n680 VSS.n679 585
R779 VSS.n677 VSS.n676 585
R780 VSS.n675 VSS.n674 585
R781 VSS.n668 VSS.n608 585
R782 VSS.n670 VSS.n669 585
R783 VSS.n667 VSS.n666 585
R784 VSS.n665 VSS.n664 585
R785 VSS.n658 VSS.n610 585
R786 VSS.n660 VSS.n659 585
R787 VSS.n657 VSS.n656 585
R788 VSS.n655 VSS.n654 585
R789 VSS.n648 VSS.n612 585
R790 VSS.n650 VSS.n649 585
R791 VSS.n647 VSS.n646 585
R792 VSS.n645 VSS.n644 585
R793 VSS.n638 VSS.n614 585
R794 VSS.n640 VSS.n639 585
R795 VSS.n637 VSS.n636 585
R796 VSS.n635 VSS.n634 585
R797 VSS.n628 VSS.n616 585
R798 VSS.n630 VSS.n629 585
R799 VSS.n627 VSS.n626 585
R800 VSS.n625 VSS.n624 585
R801 VSS.n619 VSS.n618 585
R802 VSS.n620 VSS.n100 585
R803 VSS.n878 VSS.n100 585
R804 VSS.n737 VSS.n736 585
R805 VSS.n736 VSS.n154 585
R806 VSS.n738 VSS.n153 585
R807 VSS.n745 VSS.n153 585
R808 VSS.n740 VSS.n739 585
R809 VSS.n741 VSS.n740 585
R810 VSS.n158 VSS.n157 585
R811 VSS.n262 VSS.n157 585
R812 VSS.n590 VSS.n589 585
R813 VSS.n589 VSS.n588 585
R814 VSS.n161 VSS.n160 585
R815 VSS.n576 VSS.n161 585
R816 VSS.n570 VSS.n170 585
R817 VSS.n579 VSS.n170 585
R818 VSS.n572 VSS.n571 585
R819 VSS.n573 VSS.n572 585
R820 VSS.n175 VSS.n174 585
R821 VSS.n174 VSS.n173 585
R822 VSS.n565 VSS.n564 585
R823 VSS.n564 VSS.n563 585
R824 VSS.n178 VSS.n177 585
R825 VSS.n179 VSS.n178 585
R826 VSS.n546 VSS.n189 585
R827 VSS.n554 VSS.n189 585
R828 VSS.n548 VSS.n547 585
R829 VSS.n549 VSS.n548 585
R830 VSS.n194 VSS.n193 585
R831 VSS.n193 VSS.n192 585
R832 VSS.n541 VSS.n540 585
R833 VSS.n540 VSS.n539 585
R834 VSS.n197 VSS.n196 585
R835 VSS.n198 VSS.n197 585
R836 VSS.n202 VSS.n200 585
R837 VSS.n200 VSS.n198 585
R838 VSS.n538 VSS.n537 585
R839 VSS.n539 VSS.n538 585
R840 VSS.n203 VSS.n201 585
R841 VSS.n201 VSS.n192 585
R842 VSS.n188 VSS.n187 585
R843 VSS.n549 VSS.n188 585
R844 VSS.n556 VSS.n555 585
R845 VSS.n555 VSS.n554 585
R846 VSS.n184 VSS.n182 585
R847 VSS.n182 VSS.n179 585
R848 VSS.n562 VSS.n561 585
R849 VSS.n563 VSS.n562 585
R850 VSS.n185 VSS.n183 585
R851 VSS.n183 VSS.n173 585
R852 VSS.n169 VSS.n168 585
R853 VSS.n573 VSS.n169 585
R854 VSS.n581 VSS.n580 585
R855 VSS.n580 VSS.n579 585
R856 VSS.n165 VSS.n163 585
R857 VSS.n576 VSS.n163 585
R858 VSS.n587 VSS.n586 585
R859 VSS.n588 VSS.n587 585
R860 VSS.n166 VSS.n164 585
R861 VSS.n262 VSS.n164 585
R862 VSS.n151 VSS.n150 585
R863 VSS.n741 VSS.n151 585
R864 VSS.n747 VSS.n746 585
R865 VSS.n746 VSS.n745 585
R866 VSS.n147 VSS.n145 585
R867 VSS.n154 VSS.n145 585
R868 VSS.n886 VSS.n95 585
R869 VSS.n880 VSS.n94 585
R870 VSS.n882 VSS.n881 585
R871 VSS.n810 VSS.n97 585
R872 VSS.n812 VSS.n811 585
R873 VSS.n809 VSS.n808 585
R874 VSS.n816 VSS.n807 585
R875 VSS.n817 VSS.n806 585
R876 VSS.n818 VSS.n805 585
R877 VSS.n803 VSS.n802 585
R878 VSS.n822 VSS.n801 585
R879 VSS.n823 VSS.n800 585
R880 VSS.n824 VSS.n799 585
R881 VSS.n797 VSS.n796 585
R882 VSS.n828 VSS.n795 585
R883 VSS.n829 VSS.n794 585
R884 VSS.n830 VSS.n793 585
R885 VSS.n791 VSS.n790 585
R886 VSS.n834 VSS.n789 585
R887 VSS.n835 VSS.n788 585
R888 VSS.n836 VSS.n787 585
R889 VSS.n785 VSS.n784 585
R890 VSS.n840 VSS.n783 585
R891 VSS.n841 VSS.n782 585
R892 VSS.n842 VSS.n781 585
R893 VSS.n779 VSS.n778 585
R894 VSS.n846 VSS.n777 585
R895 VSS.n847 VSS.n776 585
R896 VSS.n848 VSS.n775 585
R897 VSS.n773 VSS.n772 585
R898 VSS.n852 VSS.n771 585
R899 VSS.n853 VSS.n770 585
R900 VSS.n854 VSS.n769 585
R901 VSS.n767 VSS.n766 585
R902 VSS.n858 VSS.n765 585
R903 VSS.n859 VSS.n764 585
R904 VSS.n860 VSS.n763 585
R905 VSS.n761 VSS.n760 585
R906 VSS.n864 VSS.n759 585
R907 VSS.n865 VSS.n758 585
R908 VSS.n866 VSS.n757 585
R909 VSS.n755 VSS.n754 585
R910 VSS.n870 VSS.n753 585
R911 VSS.n871 VSS.n752 585
R912 VSS.n872 VSS.n751 585
R913 VSS.n148 VSS.n146 585
R914 VSS.n877 VSS.n876 585
R915 VSS.n878 VSS.n877 585
R916 VSS.n887 VSS.n93 585
R917 VSS.n154 VSS.n93 585
R918 VSS.n152 VSS.n69 585
R919 VSS.n745 VSS.n152 585
R920 VSS.n892 VSS.n68 585
R921 VSS.n741 VSS.n68 585
R922 VSS.n893 VSS.n67 585
R923 VSS.n262 VSS.n67 585
R924 VSS.n894 VSS.n66 585
R925 VSS.n588 VSS.n66 585
R926 VSS.n575 VSS.n59 585
R927 VSS.n576 VSS.n575 585
R928 VSS.n899 VSS.n58 585
R929 VSS.n579 VSS.n58 585
R930 VSS.n900 VSS.n57 585
R931 VSS.n573 VSS.n57 585
R932 VSS.n901 VSS.n56 585
R933 VSS.n173 VSS.n56 585
R934 VSS.n180 VSS.n49 585
R935 VSS.n563 VSS.n180 585
R936 VSS.n906 VSS.n48 585
R937 VSS.n179 VSS.n48 585
R938 VSS.n907 VSS.n47 585
R939 VSS.n554 VSS.n47 585
R940 VSS.n908 VSS.n46 585
R941 VSS.n549 VSS.n46 585
R942 VSS.n191 VSS.n41 585
R943 VSS.n192 VSS.n191 585
R944 VSS.n912 VSS.n40 585
R945 VSS.n539 VSS.n40 585
R946 VSS.n913 VSS.n39 585
R947 VSS.n198 VSS.n39 585
R948 VSS.n532 VSS.n205 585
R949 VSS.n531 VSS.n206 585
R950 VSS.n530 VSS.n207 585
R951 VSS.n462 VSS.n207 585
R952 VSS.n265 VSS.n208 585
R953 VSS.n526 VSS.n210 585
R954 VSS.n525 VSS.n211 585
R955 VSS.n524 VSS.n212 585
R956 VSS.n268 VSS.n213 585
R957 VSS.n520 VSS.n215 585
R958 VSS.n519 VSS.n216 585
R959 VSS.n518 VSS.n217 585
R960 VSS.n271 VSS.n218 585
R961 VSS.n514 VSS.n220 585
R962 VSS.n513 VSS.n221 585
R963 VSS.n512 VSS.n222 585
R964 VSS.n274 VSS.n223 585
R965 VSS.n508 VSS.n225 585
R966 VSS.n507 VSS.n226 585
R967 VSS.n506 VSS.n227 585
R968 VSS.n277 VSS.n228 585
R969 VSS.n502 VSS.n230 585
R970 VSS.n501 VSS.n231 585
R971 VSS.n500 VSS.n232 585
R972 VSS.n280 VSS.n233 585
R973 VSS.n496 VSS.n235 585
R974 VSS.n495 VSS.n236 585
R975 VSS.n494 VSS.n237 585
R976 VSS.n283 VSS.n238 585
R977 VSS.n490 VSS.n240 585
R978 VSS.n489 VSS.n241 585
R979 VSS.n488 VSS.n242 585
R980 VSS.n286 VSS.n243 585
R981 VSS.n484 VSS.n245 585
R982 VSS.n483 VSS.n246 585
R983 VSS.n482 VSS.n247 585
R984 VSS.n289 VSS.n248 585
R985 VSS.n478 VSS.n250 585
R986 VSS.n477 VSS.n251 585
R987 VSS.n476 VSS.n252 585
R988 VSS.n292 VSS.n253 585
R989 VSS.n472 VSS.n255 585
R990 VSS.n471 VSS.n256 585
R991 VSS.n470 VSS.n257 585
R992 VSS.n295 VSS.n258 585
R993 VSS.n466 VSS.n260 585
R994 VSS.n465 VSS.n464 585
R995 VSS.n261 VSS.n38 585
R996 VSS.n743 VSS.n100 509.738
R997 VSS.n736 VSS.n735 509.738
R998 VSS.n460 VSS.n197 509.738
R999 VSS.n344 VSS.n343 509.738
R1000 VSS.n877 VSS.n145 509.738
R1001 VSS.n95 VSS.n93 509.738
R1002 VSS.n261 VSS.n39 509.738
R1003 VSS.n205 VSS.n200 509.738
R1004 VSS.n462 VSS.n264 398.317
R1005 VSS.n35 VSS.n34 256.483
R1006 VSS.n25 VSS.n24 256.483
R1007 VSS.n90 VSS.n89 256.483
R1008 VSS.n80 VSS.n79 256.483
R1009 VSS.n462 VSS.n297 254.01
R1010 VSS.n462 VSS.n298 254.01
R1011 VSS.n462 VSS.n299 254.01
R1012 VSS.n462 VSS.n300 254.01
R1013 VSS.n462 VSS.n301 254.01
R1014 VSS.n462 VSS.n302 254.01
R1015 VSS.n462 VSS.n303 254.01
R1016 VSS.n462 VSS.n304 254.01
R1017 VSS.n462 VSS.n305 254.01
R1018 VSS.n462 VSS.n306 254.01
R1019 VSS.n462 VSS.n307 254.01
R1020 VSS.n462 VSS.n308 254.01
R1021 VSS.n462 VSS.n309 254.01
R1022 VSS.n462 VSS.n310 254.01
R1023 VSS.n462 VSS.n311 254.01
R1024 VSS.n462 VSS.n312 254.01
R1025 VSS.n462 VSS.n313 254.01
R1026 VSS.n462 VSS.n314 254.01
R1027 VSS.n462 VSS.n315 254.01
R1028 VSS.n462 VSS.n316 254.01
R1029 VSS.n462 VSS.n317 254.01
R1030 VSS.n462 VSS.n318 254.01
R1031 VSS.n462 VSS.n319 254.01
R1032 VSS.n878 VSS.n123 254.01
R1033 VSS.n878 VSS.n122 254.01
R1034 VSS.n878 VSS.n121 254.01
R1035 VSS.n878 VSS.n120 254.01
R1036 VSS.n878 VSS.n119 254.01
R1037 VSS.n878 VSS.n118 254.01
R1038 VSS.n878 VSS.n117 254.01
R1039 VSS.n878 VSS.n116 254.01
R1040 VSS.n878 VSS.n115 254.01
R1041 VSS.n878 VSS.n114 254.01
R1042 VSS.n878 VSS.n113 254.01
R1043 VSS.n878 VSS.n112 254.01
R1044 VSS.n878 VSS.n111 254.01
R1045 VSS.n878 VSS.n110 254.01
R1046 VSS.n878 VSS.n109 254.01
R1047 VSS.n878 VSS.n108 254.01
R1048 VSS.n878 VSS.n107 254.01
R1049 VSS.n878 VSS.n106 254.01
R1050 VSS.n878 VSS.n105 254.01
R1051 VSS.n878 VSS.n104 254.01
R1052 VSS.n878 VSS.n103 254.01
R1053 VSS.n878 VSS.n102 254.01
R1054 VSS.n878 VSS.n101 254.01
R1055 VSS.n879 VSS.n878 254.01
R1056 VSS.n878 VSS.n98 254.01
R1057 VSS.n878 VSS.n124 254.01
R1058 VSS.n878 VSS.n125 254.01
R1059 VSS.n878 VSS.n126 254.01
R1060 VSS.n878 VSS.n127 254.01
R1061 VSS.n878 VSS.n128 254.01
R1062 VSS.n878 VSS.n129 254.01
R1063 VSS.n878 VSS.n130 254.01
R1064 VSS.n878 VSS.n131 254.01
R1065 VSS.n878 VSS.n132 254.01
R1066 VSS.n878 VSS.n133 254.01
R1067 VSS.n878 VSS.n134 254.01
R1068 VSS.n878 VSS.n135 254.01
R1069 VSS.n878 VSS.n136 254.01
R1070 VSS.n878 VSS.n137 254.01
R1071 VSS.n878 VSS.n138 254.01
R1072 VSS.n878 VSS.n139 254.01
R1073 VSS.n878 VSS.n140 254.01
R1074 VSS.n878 VSS.n141 254.01
R1075 VSS.n878 VSS.n142 254.01
R1076 VSS.n878 VSS.n143 254.01
R1077 VSS.n878 VSS.n144 254.01
R1078 VSS.n462 VSS.n461 254.01
R1079 VSS.n462 VSS.n266 254.01
R1080 VSS.n462 VSS.n267 254.01
R1081 VSS.n462 VSS.n269 254.01
R1082 VSS.n462 VSS.n270 254.01
R1083 VSS.n462 VSS.n272 254.01
R1084 VSS.n462 VSS.n273 254.01
R1085 VSS.n462 VSS.n275 254.01
R1086 VSS.n462 VSS.n276 254.01
R1087 VSS.n462 VSS.n278 254.01
R1088 VSS.n462 VSS.n279 254.01
R1089 VSS.n462 VSS.n281 254.01
R1090 VSS.n462 VSS.n282 254.01
R1091 VSS.n462 VSS.n284 254.01
R1092 VSS.n462 VSS.n285 254.01
R1093 VSS.n462 VSS.n287 254.01
R1094 VSS.n462 VSS.n288 254.01
R1095 VSS.n462 VSS.n290 254.01
R1096 VSS.n462 VSS.n291 254.01
R1097 VSS.n462 VSS.n293 254.01
R1098 VSS.n462 VSS.n294 254.01
R1099 VSS.n462 VSS.n296 254.01
R1100 VSS.n463 VSS.n462 254.01
R1101 VSS.n34 VSS.n33 185
R1102 VSS.n30 VSS.n29 185
R1103 VSS.n20 VSS.n19 185
R1104 VSS.n24 VSS.n23 185
R1105 VSS.n89 VSS.n88 185
R1106 VSS.n85 VSS.n84 185
R1107 VSS.n75 VSS.n74 185
R1108 VSS.n79 VSS.n78 185
R1109 VSS.n21 VSS.t14 180.934
R1110 VSS.n76 VSS.t4 180.934
R1111 VSS.n31 VSS.t20 180.934
R1112 VSS.n86 VSS.t15 180.934
R1113 VSS.n618 VSS.n100 177.3
R1114 VSS.n626 VSS.n625 177.3
R1115 VSS.n629 VSS.n628 177.3
R1116 VSS.n636 VSS.n635 177.3
R1117 VSS.n639 VSS.n638 177.3
R1118 VSS.n646 VSS.n645 177.3
R1119 VSS.n649 VSS.n648 177.3
R1120 VSS.n656 VSS.n655 177.3
R1121 VSS.n659 VSS.n658 177.3
R1122 VSS.n666 VSS.n665 177.3
R1123 VSS.n669 VSS.n668 177.3
R1124 VSS.n676 VSS.n675 177.3
R1125 VSS.n679 VSS.n678 177.3
R1126 VSS.n686 VSS.n685 177.3
R1127 VSS.n689 VSS.n688 177.3
R1128 VSS.n696 VSS.n695 177.3
R1129 VSS.n699 VSS.n698 177.3
R1130 VSS.n706 VSS.n705 177.3
R1131 VSS.n709 VSS.n708 177.3
R1132 VSS.n716 VSS.n715 177.3
R1133 VSS.n719 VSS.n718 177.3
R1134 VSS.n726 VSS.n725 177.3
R1135 VSS.n729 VSS.n728 177.3
R1136 VSS.n540 VSS.n197 177.3
R1137 VSS.n540 VSS.n193 177.3
R1138 VSS.n548 VSS.n193 177.3
R1139 VSS.n548 VSS.n189 177.3
R1140 VSS.n189 VSS.n178 177.3
R1141 VSS.n564 VSS.n178 177.3
R1142 VSS.n564 VSS.n174 177.3
R1143 VSS.n572 VSS.n174 177.3
R1144 VSS.n572 VSS.n170 177.3
R1145 VSS.n170 VSS.n161 177.3
R1146 VSS.n589 VSS.n161 177.3
R1147 VSS.n589 VSS.n157 177.3
R1148 VSS.n740 VSS.n157 177.3
R1149 VSS.n740 VSS.n153 177.3
R1150 VSS.n736 VSS.n153 177.3
R1151 VSS.n350 VSS.n349 177.3
R1152 VSS.n354 VSS.n353 177.3
R1153 VSS.n360 VSS.n359 177.3
R1154 VSS.n364 VSS.n363 177.3
R1155 VSS.n370 VSS.n369 177.3
R1156 VSS.n374 VSS.n373 177.3
R1157 VSS.n380 VSS.n379 177.3
R1158 VSS.n384 VSS.n383 177.3
R1159 VSS.n390 VSS.n389 177.3
R1160 VSS.n394 VSS.n393 177.3
R1161 VSS.n400 VSS.n399 177.3
R1162 VSS.n404 VSS.n403 177.3
R1163 VSS.n410 VSS.n409 177.3
R1164 VSS.n414 VSS.n413 177.3
R1165 VSS.n420 VSS.n419 177.3
R1166 VSS.n424 VSS.n423 177.3
R1167 VSS.n430 VSS.n429 177.3
R1168 VSS.n434 VSS.n433 177.3
R1169 VSS.n440 VSS.n439 177.3
R1170 VSS.n444 VSS.n443 177.3
R1171 VSS.n450 VSS.n449 177.3
R1172 VSS.n454 VSS.n453 177.3
R1173 VSS.n460 VSS.n320 177.3
R1174 VSS.n343 VSS.n199 177.3
R1175 VSS.n199 VSS.n190 177.3
R1176 VSS.n550 VSS.n190 177.3
R1177 VSS.n553 VSS.n550 177.3
R1178 VSS.n553 VSS.n551 177.3
R1179 VSS.n551 VSS.n181 177.3
R1180 VSS.n181 VSS.n171 177.3
R1181 VSS.n574 VSS.n171 177.3
R1182 VSS.n578 VSS.n574 177.3
R1183 VSS.n578 VSS.n577 177.3
R1184 VSS.n577 VSS.n162 177.3
R1185 VSS.n162 VSS.n156 177.3
R1186 VSS.n742 VSS.n156 177.3
R1187 VSS.n744 VSS.n742 177.3
R1188 VSS.n744 VSS.n743 177.3
R1189 VSS.n877 VSS.n146 177.3
R1190 VSS.n752 VSS.n751 177.3
R1191 VSS.n754 VSS.n753 177.3
R1192 VSS.n758 VSS.n757 177.3
R1193 VSS.n760 VSS.n759 177.3
R1194 VSS.n764 VSS.n763 177.3
R1195 VSS.n766 VSS.n765 177.3
R1196 VSS.n770 VSS.n769 177.3
R1197 VSS.n772 VSS.n771 177.3
R1198 VSS.n776 VSS.n775 177.3
R1199 VSS.n778 VSS.n777 177.3
R1200 VSS.n782 VSS.n781 177.3
R1201 VSS.n784 VSS.n783 177.3
R1202 VSS.n788 VSS.n787 177.3
R1203 VSS.n790 VSS.n789 177.3
R1204 VSS.n794 VSS.n793 177.3
R1205 VSS.n796 VSS.n795 177.3
R1206 VSS.n800 VSS.n799 177.3
R1207 VSS.n802 VSS.n801 177.3
R1208 VSS.n806 VSS.n805 177.3
R1209 VSS.n808 VSS.n807 177.3
R1210 VSS.n811 VSS.n810 177.3
R1211 VSS.n881 VSS.n880 177.3
R1212 VSS.n40 VSS.n39 177.3
R1213 VSS.n191 VSS.n40 177.3
R1214 VSS.n191 VSS.n46 177.3
R1215 VSS.n47 VSS.n46 177.3
R1216 VSS.n48 VSS.n47 177.3
R1217 VSS.n180 VSS.n48 177.3
R1218 VSS.n180 VSS.n56 177.3
R1219 VSS.n57 VSS.n56 177.3
R1220 VSS.n58 VSS.n57 177.3
R1221 VSS.n575 VSS.n58 177.3
R1222 VSS.n575 VSS.n66 177.3
R1223 VSS.n67 VSS.n66 177.3
R1224 VSS.n68 VSS.n67 177.3
R1225 VSS.n152 VSS.n68 177.3
R1226 VSS.n152 VSS.n93 177.3
R1227 VSS.n207 VSS.n206 177.3
R1228 VSS.n265 VSS.n207 177.3
R1229 VSS.n211 VSS.n210 177.3
R1230 VSS.n268 VSS.n212 177.3
R1231 VSS.n216 VSS.n215 177.3
R1232 VSS.n271 VSS.n217 177.3
R1233 VSS.n221 VSS.n220 177.3
R1234 VSS.n274 VSS.n222 177.3
R1235 VSS.n226 VSS.n225 177.3
R1236 VSS.n277 VSS.n227 177.3
R1237 VSS.n231 VSS.n230 177.3
R1238 VSS.n280 VSS.n232 177.3
R1239 VSS.n236 VSS.n235 177.3
R1240 VSS.n283 VSS.n237 177.3
R1241 VSS.n241 VSS.n240 177.3
R1242 VSS.n286 VSS.n242 177.3
R1243 VSS.n246 VSS.n245 177.3
R1244 VSS.n289 VSS.n247 177.3
R1245 VSS.n251 VSS.n250 177.3
R1246 VSS.n292 VSS.n252 177.3
R1247 VSS.n256 VSS.n255 177.3
R1248 VSS.n295 VSS.n257 177.3
R1249 VSS.n464 VSS.n260 177.3
R1250 VSS.n538 VSS.n200 177.3
R1251 VSS.n538 VSS.n201 177.3
R1252 VSS.n201 VSS.n188 177.3
R1253 VSS.n555 VSS.n188 177.3
R1254 VSS.n555 VSS.n182 177.3
R1255 VSS.n562 VSS.n182 177.3
R1256 VSS.n562 VSS.n183 177.3
R1257 VSS.n183 VSS.n169 177.3
R1258 VSS.n580 VSS.n169 177.3
R1259 VSS.n580 VSS.n163 177.3
R1260 VSS.n587 VSS.n163 177.3
R1261 VSS.n587 VSS.n164 177.3
R1262 VSS.n164 VSS.n151 177.3
R1263 VSS.n746 VSS.n151 177.3
R1264 VSS.n746 VSS.n145 177.3
R1265 VSS.n34 VSS.n29 144
R1266 VSS.n24 VSS.n19 144
R1267 VSS.n89 VSS.n84 144
R1268 VSS.n79 VSS.n74 144
R1269 VSS.n625 VSS.n101 76.985
R1270 VSS.n629 VSS.n102 76.985
R1271 VSS.n635 VSS.n103 76.985
R1272 VSS.n639 VSS.n104 76.985
R1273 VSS.n645 VSS.n105 76.985
R1274 VSS.n649 VSS.n106 76.985
R1275 VSS.n655 VSS.n107 76.985
R1276 VSS.n659 VSS.n108 76.985
R1277 VSS.n665 VSS.n109 76.985
R1278 VSS.n669 VSS.n110 76.985
R1279 VSS.n675 VSS.n111 76.985
R1280 VSS.n679 VSS.n112 76.985
R1281 VSS.n685 VSS.n113 76.985
R1282 VSS.n689 VSS.n114 76.985
R1283 VSS.n695 VSS.n115 76.985
R1284 VSS.n699 VSS.n116 76.985
R1285 VSS.n705 VSS.n117 76.985
R1286 VSS.n709 VSS.n118 76.985
R1287 VSS.n715 VSS.n119 76.985
R1288 VSS.n719 VSS.n120 76.985
R1289 VSS.n725 VSS.n121 76.985
R1290 VSS.n729 VSS.n122 76.985
R1291 VSS.n735 VSS.n123 76.985
R1292 VSS.n344 VSS.n297 76.985
R1293 VSS.n350 VSS.n298 76.985
R1294 VSS.n354 VSS.n299 76.985
R1295 VSS.n360 VSS.n300 76.985
R1296 VSS.n364 VSS.n301 76.985
R1297 VSS.n370 VSS.n302 76.985
R1298 VSS.n374 VSS.n303 76.985
R1299 VSS.n380 VSS.n304 76.985
R1300 VSS.n384 VSS.n305 76.985
R1301 VSS.n390 VSS.n306 76.985
R1302 VSS.n394 VSS.n307 76.985
R1303 VSS.n400 VSS.n308 76.985
R1304 VSS.n404 VSS.n309 76.985
R1305 VSS.n410 VSS.n310 76.985
R1306 VSS.n414 VSS.n311 76.985
R1307 VSS.n420 VSS.n312 76.985
R1308 VSS.n424 VSS.n313 76.985
R1309 VSS.n430 VSS.n314 76.985
R1310 VSS.n434 VSS.n315 76.985
R1311 VSS.n440 VSS.n316 76.985
R1312 VSS.n444 VSS.n317 76.985
R1313 VSS.n450 VSS.n318 76.985
R1314 VSS.n454 VSS.n319 76.985
R1315 VSS.n349 VSS.n297 76.985
R1316 VSS.n353 VSS.n298 76.985
R1317 VSS.n359 VSS.n299 76.985
R1318 VSS.n363 VSS.n300 76.985
R1319 VSS.n369 VSS.n301 76.985
R1320 VSS.n373 VSS.n302 76.985
R1321 VSS.n379 VSS.n303 76.985
R1322 VSS.n383 VSS.n304 76.985
R1323 VSS.n389 VSS.n305 76.985
R1324 VSS.n393 VSS.n306 76.985
R1325 VSS.n399 VSS.n307 76.985
R1326 VSS.n403 VSS.n308 76.985
R1327 VSS.n409 VSS.n309 76.985
R1328 VSS.n413 VSS.n310 76.985
R1329 VSS.n419 VSS.n311 76.985
R1330 VSS.n423 VSS.n312 76.985
R1331 VSS.n429 VSS.n313 76.985
R1332 VSS.n433 VSS.n314 76.985
R1333 VSS.n439 VSS.n315 76.985
R1334 VSS.n443 VSS.n316 76.985
R1335 VSS.n449 VSS.n317 76.985
R1336 VSS.n453 VSS.n318 76.985
R1337 VSS.n320 VSS.n319 76.985
R1338 VSS.n728 VSS.n123 76.985
R1339 VSS.n726 VSS.n122 76.985
R1340 VSS.n718 VSS.n121 76.985
R1341 VSS.n716 VSS.n120 76.985
R1342 VSS.n708 VSS.n119 76.985
R1343 VSS.n706 VSS.n118 76.985
R1344 VSS.n698 VSS.n117 76.985
R1345 VSS.n696 VSS.n116 76.985
R1346 VSS.n688 VSS.n115 76.985
R1347 VSS.n686 VSS.n114 76.985
R1348 VSS.n678 VSS.n113 76.985
R1349 VSS.n676 VSS.n112 76.985
R1350 VSS.n668 VSS.n111 76.985
R1351 VSS.n666 VSS.n110 76.985
R1352 VSS.n658 VSS.n109 76.985
R1353 VSS.n656 VSS.n108 76.985
R1354 VSS.n648 VSS.n107 76.985
R1355 VSS.n646 VSS.n106 76.985
R1356 VSS.n638 VSS.n105 76.985
R1357 VSS.n636 VSS.n104 76.985
R1358 VSS.n628 VSS.n103 76.985
R1359 VSS.n626 VSS.n102 76.985
R1360 VSS.n618 VSS.n101 76.985
R1361 VSS.n751 VSS.n144 76.985
R1362 VSS.n753 VSS.n143 76.985
R1363 VSS.n757 VSS.n142 76.985
R1364 VSS.n759 VSS.n141 76.985
R1365 VSS.n763 VSS.n140 76.985
R1366 VSS.n765 VSS.n139 76.985
R1367 VSS.n769 VSS.n138 76.985
R1368 VSS.n771 VSS.n137 76.985
R1369 VSS.n775 VSS.n136 76.985
R1370 VSS.n777 VSS.n135 76.985
R1371 VSS.n781 VSS.n134 76.985
R1372 VSS.n783 VSS.n133 76.985
R1373 VSS.n787 VSS.n132 76.985
R1374 VSS.n789 VSS.n131 76.985
R1375 VSS.n793 VSS.n130 76.985
R1376 VSS.n795 VSS.n129 76.985
R1377 VSS.n799 VSS.n128 76.985
R1378 VSS.n801 VSS.n127 76.985
R1379 VSS.n805 VSS.n126 76.985
R1380 VSS.n807 VSS.n125 76.985
R1381 VSS.n811 VSS.n124 76.985
R1382 VSS.n881 VSS.n98 76.985
R1383 VSS.n879 VSS.n95 76.985
R1384 VSS.n461 VSS.n205 76.985
R1385 VSS.n266 VSS.n265 76.985
R1386 VSS.n267 VSS.n211 76.985
R1387 VSS.n269 VSS.n268 76.985
R1388 VSS.n270 VSS.n216 76.985
R1389 VSS.n272 VSS.n271 76.985
R1390 VSS.n273 VSS.n221 76.985
R1391 VSS.n275 VSS.n274 76.985
R1392 VSS.n276 VSS.n226 76.985
R1393 VSS.n278 VSS.n277 76.985
R1394 VSS.n279 VSS.n231 76.985
R1395 VSS.n281 VSS.n280 76.985
R1396 VSS.n282 VSS.n236 76.985
R1397 VSS.n284 VSS.n283 76.985
R1398 VSS.n285 VSS.n241 76.985
R1399 VSS.n287 VSS.n286 76.985
R1400 VSS.n288 VSS.n246 76.985
R1401 VSS.n290 VSS.n289 76.985
R1402 VSS.n291 VSS.n251 76.985
R1403 VSS.n293 VSS.n292 76.985
R1404 VSS.n294 VSS.n256 76.985
R1405 VSS.n296 VSS.n295 76.985
R1406 VSS.n464 VSS.n463 76.985
R1407 VSS.n880 VSS.n879 76.985
R1408 VSS.n810 VSS.n98 76.985
R1409 VSS.n808 VSS.n124 76.985
R1410 VSS.n806 VSS.n125 76.985
R1411 VSS.n802 VSS.n126 76.985
R1412 VSS.n800 VSS.n127 76.985
R1413 VSS.n796 VSS.n128 76.985
R1414 VSS.n794 VSS.n129 76.985
R1415 VSS.n790 VSS.n130 76.985
R1416 VSS.n788 VSS.n131 76.985
R1417 VSS.n784 VSS.n132 76.985
R1418 VSS.n782 VSS.n133 76.985
R1419 VSS.n778 VSS.n134 76.985
R1420 VSS.n776 VSS.n135 76.985
R1421 VSS.n772 VSS.n136 76.985
R1422 VSS.n770 VSS.n137 76.985
R1423 VSS.n766 VSS.n138 76.985
R1424 VSS.n764 VSS.n139 76.985
R1425 VSS.n760 VSS.n140 76.985
R1426 VSS.n758 VSS.n141 76.985
R1427 VSS.n754 VSS.n142 76.985
R1428 VSS.n752 VSS.n143 76.985
R1429 VSS.n146 VSS.n144 76.985
R1430 VSS.n461 VSS.n206 76.985
R1431 VSS.n266 VSS.n210 76.985
R1432 VSS.n267 VSS.n212 76.985
R1433 VSS.n269 VSS.n215 76.985
R1434 VSS.n270 VSS.n217 76.985
R1435 VSS.n272 VSS.n220 76.985
R1436 VSS.n273 VSS.n222 76.985
R1437 VSS.n275 VSS.n225 76.985
R1438 VSS.n276 VSS.n227 76.985
R1439 VSS.n278 VSS.n230 76.985
R1440 VSS.n279 VSS.n232 76.985
R1441 VSS.n281 VSS.n235 76.985
R1442 VSS.n282 VSS.n237 76.985
R1443 VSS.n284 VSS.n240 76.985
R1444 VSS.n285 VSS.n242 76.985
R1445 VSS.n287 VSS.n245 76.985
R1446 VSS.n288 VSS.n247 76.985
R1447 VSS.n290 VSS.n250 76.985
R1448 VSS.n291 VSS.n252 76.985
R1449 VSS.n293 VSS.n255 76.985
R1450 VSS.n294 VSS.n257 76.985
R1451 VSS.n296 VSS.n260 76.985
R1452 VSS.n463 VSS.n261 76.985
R1453 VSS.t20 VSS.n29 72.0005
R1454 VSS.t14 VSS.n19 72.0005
R1455 VSS.t15 VSS.n84 72.0005
R1456 VSS.t4 VSS.n74 72.0005
R1457 VSS.n462 VSS.n198 51.4625
R1458 VSS.n539 VSS.n198 37.0531
R1459 VSS.n549 VSS.n192 37.0531
R1460 VSS.n563 VSS.n179 37.0531
R1461 VSS.n573 VSS.n173 37.0531
R1462 VSS.n745 VSS.n154 37.0531
R1463 VSS.n878 VSS.n99 36.0239
R1464 VSS.n539 VSS.t13 34.9947
R1465 VSS.n554 VSS.t21 33.4508
R1466 VSS.n620 VSS.n92 33.1205
R1467 VSS.n737 VSS.n734 33.1205
R1468 VSS.n459 VSS.n196 33.1205
R1469 VSS.n345 VSS.n16 33.1205
R1470 VSS.n532 VSS.n202 33.1205
R1471 VSS.n876 VSS.n147 33.1205
R1472 VSS.n887 VSS.n886 33.1205
R1473 VSS.n913 VSS.n38 33.1205
R1474 VSS.t11 VSS.n179 30.8777
R1475 VSS.n576 VSS.t5 30.8777
R1476 VSS.n579 VSS.t25 29.3338
R1477 VSS.n33 VSS.n28 27.1064
R1478 VSS.n33 VSS.n30 27.1064
R1479 VSS.n23 VSS.n20 27.1064
R1480 VSS.n23 VSS.n18 27.1064
R1481 VSS.n88 VSS.n83 27.1064
R1482 VSS.n88 VSS.n85 27.1064
R1483 VSS.n78 VSS.n75 27.1064
R1484 VSS.n78 VSS.n73 27.1064
R1485 VSS.n741 VSS.t23 26.2461
R1486 VSS.n36 VSS.n35 25.7818
R1487 VSS.n26 VSS.n25 25.7818
R1488 VSS.n91 VSS.n90 25.7818
R1489 VSS.n81 VSS.n80 25.7818
R1490 VSS.n904 VSS.n52 24.9139
R1491 VSS.n897 VSS.n62 24.9139
R1492 VSS.n904 VSS.n51 24.9139
R1493 VSS.n897 VSS.n61 24.9139
R1494 VSS.t9 VSS.n173 22.6438
R1495 VSS.n573 VSS.t7 22.6438
R1496 VSS.n263 VSS.t24 22.6438
R1497 VSS.t3 VSS.t22 18.0122
R1498 VSS.n745 VSS.t22 16.983
R1499 VSS.n154 VSS.n99 15.4391
R1500 VSS.n563 VSS.t9 14.4099
R1501 VSS.n579 VSS.t7 14.4099
R1502 VSS.n263 VSS.n262 12.866
R1503 VSS.n620 VSS.n619 11.5205
R1504 VSS.n624 VSS.n619 11.5205
R1505 VSS.n627 VSS.n624 11.5205
R1506 VSS.n630 VSS.n627 11.5205
R1507 VSS.n630 VSS.n616 11.5205
R1508 VSS.n634 VSS.n616 11.5205
R1509 VSS.n637 VSS.n634 11.5205
R1510 VSS.n640 VSS.n637 11.5205
R1511 VSS.n640 VSS.n614 11.5205
R1512 VSS.n644 VSS.n614 11.5205
R1513 VSS.n647 VSS.n644 11.5205
R1514 VSS.n650 VSS.n647 11.5205
R1515 VSS.n650 VSS.n612 11.5205
R1516 VSS.n654 VSS.n612 11.5205
R1517 VSS.n657 VSS.n654 11.5205
R1518 VSS.n660 VSS.n657 11.5205
R1519 VSS.n660 VSS.n610 11.5205
R1520 VSS.n664 VSS.n610 11.5205
R1521 VSS.n667 VSS.n664 11.5205
R1522 VSS.n670 VSS.n667 11.5205
R1523 VSS.n670 VSS.n608 11.5205
R1524 VSS.n674 VSS.n608 11.5205
R1525 VSS.n677 VSS.n674 11.5205
R1526 VSS.n680 VSS.n677 11.5205
R1527 VSS.n680 VSS.n606 11.5205
R1528 VSS.n684 VSS.n606 11.5205
R1529 VSS.n687 VSS.n684 11.5205
R1530 VSS.n690 VSS.n687 11.5205
R1531 VSS.n690 VSS.n604 11.5205
R1532 VSS.n694 VSS.n604 11.5205
R1533 VSS.n697 VSS.n694 11.5205
R1534 VSS.n700 VSS.n697 11.5205
R1535 VSS.n700 VSS.n602 11.5205
R1536 VSS.n704 VSS.n602 11.5205
R1537 VSS.n707 VSS.n704 11.5205
R1538 VSS.n710 VSS.n707 11.5205
R1539 VSS.n710 VSS.n600 11.5205
R1540 VSS.n714 VSS.n600 11.5205
R1541 VSS.n717 VSS.n714 11.5205
R1542 VSS.n720 VSS.n717 11.5205
R1543 VSS.n720 VSS.n598 11.5205
R1544 VSS.n724 VSS.n598 11.5205
R1545 VSS.n727 VSS.n724 11.5205
R1546 VSS.n730 VSS.n727 11.5205
R1547 VSS.n730 VSS.n596 11.5205
R1548 VSS.n734 VSS.n596 11.5205
R1549 VSS.n541 VSS.n196 11.5205
R1550 VSS.n541 VSS.n194 11.5205
R1551 VSS.n547 VSS.n194 11.5205
R1552 VSS.n547 VSS.n546 11.5205
R1553 VSS.n546 VSS.n177 11.5205
R1554 VSS.n565 VSS.n177 11.5205
R1555 VSS.n565 VSS.n175 11.5205
R1556 VSS.n571 VSS.n175 11.5205
R1557 VSS.n571 VSS.n570 11.5205
R1558 VSS.n570 VSS.n160 11.5205
R1559 VSS.n590 VSS.n160 11.5205
R1560 VSS.n590 VSS.n158 11.5205
R1561 VSS.n739 VSS.n158 11.5205
R1562 VSS.n739 VSS.n738 11.5205
R1563 VSS.n738 VSS.n737 11.5205
R1564 VSS.n346 VSS.n345 11.5205
R1565 VSS.n351 VSS.n346 11.5205
R1566 VSS.n352 VSS.n351 11.5205
R1567 VSS.n355 VSS.n352 11.5205
R1568 VSS.n355 VSS.n341 11.5205
R1569 VSS.n361 VSS.n341 11.5205
R1570 VSS.n362 VSS.n361 11.5205
R1571 VSS.n365 VSS.n362 11.5205
R1572 VSS.n365 VSS.n339 11.5205
R1573 VSS.n371 VSS.n339 11.5205
R1574 VSS.n372 VSS.n371 11.5205
R1575 VSS.n375 VSS.n372 11.5205
R1576 VSS.n375 VSS.n337 11.5205
R1577 VSS.n381 VSS.n337 11.5205
R1578 VSS.n382 VSS.n381 11.5205
R1579 VSS.n385 VSS.n382 11.5205
R1580 VSS.n385 VSS.n335 11.5205
R1581 VSS.n391 VSS.n335 11.5205
R1582 VSS.n392 VSS.n391 11.5205
R1583 VSS.n395 VSS.n392 11.5205
R1584 VSS.n395 VSS.n333 11.5205
R1585 VSS.n401 VSS.n333 11.5205
R1586 VSS.n402 VSS.n401 11.5205
R1587 VSS.n405 VSS.n402 11.5205
R1588 VSS.n405 VSS.n331 11.5205
R1589 VSS.n411 VSS.n331 11.5205
R1590 VSS.n412 VSS.n411 11.5205
R1591 VSS.n415 VSS.n412 11.5205
R1592 VSS.n415 VSS.n329 11.5205
R1593 VSS.n421 VSS.n329 11.5205
R1594 VSS.n422 VSS.n421 11.5205
R1595 VSS.n425 VSS.n422 11.5205
R1596 VSS.n425 VSS.n327 11.5205
R1597 VSS.n431 VSS.n327 11.5205
R1598 VSS.n432 VSS.n431 11.5205
R1599 VSS.n435 VSS.n432 11.5205
R1600 VSS.n435 VSS.n325 11.5205
R1601 VSS.n441 VSS.n325 11.5205
R1602 VSS.n442 VSS.n441 11.5205
R1603 VSS.n445 VSS.n442 11.5205
R1604 VSS.n445 VSS.n323 11.5205
R1605 VSS.n451 VSS.n323 11.5205
R1606 VSS.n452 VSS.n451 11.5205
R1607 VSS.n455 VSS.n452 11.5205
R1608 VSS.n455 VSS.n321 11.5205
R1609 VSS.n459 VSS.n321 11.5205
R1610 VSS.n42 VSS.n16 11.5205
R1611 VSS.n43 VSS.n42 11.5205
R1612 VSS.n44 VSS.n43 11.5205
R1613 VSS.n552 VSS.n44 11.5205
R1614 VSS.n552 VSS.n50 11.5205
R1615 VSS.n53 VSS.n50 11.5205
R1616 VSS.n54 VSS.n53 11.5205
R1617 VSS.n172 VSS.n54 11.5205
R1618 VSS.n172 VSS.n60 11.5205
R1619 VSS.n63 VSS.n60 11.5205
R1620 VSS.n64 VSS.n63 11.5205
R1621 VSS.n155 VSS.n64 11.5205
R1622 VSS.n155 VSS.n70 11.5205
R1623 VSS.n71 VSS.n70 11.5205
R1624 VSS.n92 VSS.n71 11.5205
R1625 VSS.n537 VSS.n202 11.5205
R1626 VSS.n537 VSS.n203 11.5205
R1627 VSS.n203 VSS.n187 11.5205
R1628 VSS.n556 VSS.n187 11.5205
R1629 VSS.n556 VSS.n184 11.5205
R1630 VSS.n561 VSS.n184 11.5205
R1631 VSS.n561 VSS.n185 11.5205
R1632 VSS.n185 VSS.n168 11.5205
R1633 VSS.n581 VSS.n168 11.5205
R1634 VSS.n581 VSS.n165 11.5205
R1635 VSS.n586 VSS.n165 11.5205
R1636 VSS.n586 VSS.n166 11.5205
R1637 VSS.n166 VSS.n150 11.5205
R1638 VSS.n747 VSS.n150 11.5205
R1639 VSS.n747 VSS.n147 11.5205
R1640 VSS.n876 VSS.n148 11.5205
R1641 VSS.n872 VSS.n148 11.5205
R1642 VSS.n872 VSS.n871 11.5205
R1643 VSS.n871 VSS.n870 11.5205
R1644 VSS.n870 VSS.n755 11.5205
R1645 VSS.n866 VSS.n755 11.5205
R1646 VSS.n866 VSS.n865 11.5205
R1647 VSS.n865 VSS.n864 11.5205
R1648 VSS.n864 VSS.n761 11.5205
R1649 VSS.n860 VSS.n761 11.5205
R1650 VSS.n860 VSS.n859 11.5205
R1651 VSS.n859 VSS.n858 11.5205
R1652 VSS.n858 VSS.n767 11.5205
R1653 VSS.n854 VSS.n767 11.5205
R1654 VSS.n854 VSS.n853 11.5205
R1655 VSS.n853 VSS.n852 11.5205
R1656 VSS.n852 VSS.n773 11.5205
R1657 VSS.n848 VSS.n773 11.5205
R1658 VSS.n848 VSS.n847 11.5205
R1659 VSS.n847 VSS.n846 11.5205
R1660 VSS.n846 VSS.n779 11.5205
R1661 VSS.n842 VSS.n779 11.5205
R1662 VSS.n842 VSS.n841 11.5205
R1663 VSS.n841 VSS.n840 11.5205
R1664 VSS.n840 VSS.n785 11.5205
R1665 VSS.n836 VSS.n785 11.5205
R1666 VSS.n836 VSS.n835 11.5205
R1667 VSS.n835 VSS.n834 11.5205
R1668 VSS.n834 VSS.n791 11.5205
R1669 VSS.n830 VSS.n791 11.5205
R1670 VSS.n830 VSS.n829 11.5205
R1671 VSS.n829 VSS.n828 11.5205
R1672 VSS.n828 VSS.n797 11.5205
R1673 VSS.n824 VSS.n797 11.5205
R1674 VSS.n824 VSS.n823 11.5205
R1675 VSS.n823 VSS.n822 11.5205
R1676 VSS.n822 VSS.n803 11.5205
R1677 VSS.n818 VSS.n803 11.5205
R1678 VSS.n818 VSS.n817 11.5205
R1679 VSS.n817 VSS.n816 11.5205
R1680 VSS.n816 VSS.n809 11.5205
R1681 VSS.n812 VSS.n809 11.5205
R1682 VSS.n812 VSS.n97 11.5205
R1683 VSS.n882 VSS.n97 11.5205
R1684 VSS.n882 VSS.n94 11.5205
R1685 VSS.n886 VSS.n94 11.5205
R1686 VSS.n913 VSS.n912 11.5205
R1687 VSS.n912 VSS.n41 11.5205
R1688 VSS.n908 VSS.n41 11.5205
R1689 VSS.n908 VSS.n907 11.5205
R1690 VSS.n907 VSS.n906 11.5205
R1691 VSS.n906 VSS.n49 11.5205
R1692 VSS.n901 VSS.n49 11.5205
R1693 VSS.n901 VSS.n900 11.5205
R1694 VSS.n900 VSS.n899 11.5205
R1695 VSS.n899 VSS.n59 11.5205
R1696 VSS.n894 VSS.n59 11.5205
R1697 VSS.n894 VSS.n893 11.5205
R1698 VSS.n893 VSS.n892 11.5205
R1699 VSS.n892 VSS.n69 11.5205
R1700 VSS.n887 VSS.n69 11.5205
R1701 VSS.n532 VSS.n531 11.5205
R1702 VSS.n531 VSS.n530 11.5205
R1703 VSS.n530 VSS.n208 11.5205
R1704 VSS.n526 VSS.n208 11.5205
R1705 VSS.n526 VSS.n525 11.5205
R1706 VSS.n525 VSS.n524 11.5205
R1707 VSS.n524 VSS.n213 11.5205
R1708 VSS.n520 VSS.n213 11.5205
R1709 VSS.n520 VSS.n519 11.5205
R1710 VSS.n519 VSS.n518 11.5205
R1711 VSS.n518 VSS.n218 11.5205
R1712 VSS.n514 VSS.n218 11.5205
R1713 VSS.n514 VSS.n513 11.5205
R1714 VSS.n513 VSS.n512 11.5205
R1715 VSS.n512 VSS.n223 11.5205
R1716 VSS.n508 VSS.n223 11.5205
R1717 VSS.n508 VSS.n507 11.5205
R1718 VSS.n507 VSS.n506 11.5205
R1719 VSS.n506 VSS.n228 11.5205
R1720 VSS.n502 VSS.n228 11.5205
R1721 VSS.n502 VSS.n501 11.5205
R1722 VSS.n501 VSS.n500 11.5205
R1723 VSS.n500 VSS.n233 11.5205
R1724 VSS.n496 VSS.n233 11.5205
R1725 VSS.n496 VSS.n495 11.5205
R1726 VSS.n495 VSS.n494 11.5205
R1727 VSS.n494 VSS.n238 11.5205
R1728 VSS.n490 VSS.n238 11.5205
R1729 VSS.n490 VSS.n489 11.5205
R1730 VSS.n489 VSS.n488 11.5205
R1731 VSS.n488 VSS.n243 11.5205
R1732 VSS.n484 VSS.n243 11.5205
R1733 VSS.n484 VSS.n483 11.5205
R1734 VSS.n483 VSS.n482 11.5205
R1735 VSS.n482 VSS.n248 11.5205
R1736 VSS.n478 VSS.n248 11.5205
R1737 VSS.n478 VSS.n477 11.5205
R1738 VSS.n477 VSS.n476 11.5205
R1739 VSS.n476 VSS.n253 11.5205
R1740 VSS.n472 VSS.n253 11.5205
R1741 VSS.n472 VSS.n471 11.5205
R1742 VSS.n471 VSS.n470 11.5205
R1743 VSS.n470 VSS.n258 11.5205
R1744 VSS.n466 VSS.n258 11.5205
R1745 VSS.n466 VSS.n465 11.5205
R1746 VSS.n465 VSS.n38 11.5205
R1747 VSS.n262 VSS.t23 10.8075
R1748 VSS.n23 VSS.n22 9.3005
R1749 VSS.n18 VSS.n17 9.3005
R1750 VSS.n28 VSS.n27 9.3005
R1751 VSS.n33 VSS.n32 9.3005
R1752 VSS.n78 VSS.n77 9.3005
R1753 VSS.n73 VSS.n72 9.3005
R1754 VSS.n83 VSS.n82 9.3005
R1755 VSS.n88 VSS.n87 9.3005
R1756 VSS.n542 VSS.n541 9.3005
R1757 VSS.n543 VSS.n194 9.3005
R1758 VSS.n547 VSS.n544 9.3005
R1759 VSS.n546 VSS.n545 9.3005
R1760 VSS.n177 VSS.n176 9.3005
R1761 VSS.n566 VSS.n565 9.3005
R1762 VSS.n567 VSS.n175 9.3005
R1763 VSS.n571 VSS.n568 9.3005
R1764 VSS.n570 VSS.n569 9.3005
R1765 VSS.n160 VSS.n159 9.3005
R1766 VSS.n591 VSS.n590 9.3005
R1767 VSS.n592 VSS.n158 9.3005
R1768 VSS.n739 VSS.n593 9.3005
R1769 VSS.n738 VSS.n594 9.3005
R1770 VSS.n737 VSS.n595 9.3005
R1771 VSS.n196 VSS.n195 9.3005
R1772 VSS.n345 VSS.n14 9.3005
R1773 VSS.n347 VSS.n346 9.3005
R1774 VSS.n351 VSS.n348 9.3005
R1775 VSS.n352 VSS.n342 9.3005
R1776 VSS.n356 VSS.n355 9.3005
R1777 VSS.n357 VSS.n341 9.3005
R1778 VSS.n361 VSS.n358 9.3005
R1779 VSS.n362 VSS.n340 9.3005
R1780 VSS.n366 VSS.n365 9.3005
R1781 VSS.n367 VSS.n339 9.3005
R1782 VSS.n371 VSS.n368 9.3005
R1783 VSS.n372 VSS.n338 9.3005
R1784 VSS.n376 VSS.n375 9.3005
R1785 VSS.n377 VSS.n337 9.3005
R1786 VSS.n381 VSS.n378 9.3005
R1787 VSS.n382 VSS.n336 9.3005
R1788 VSS.n386 VSS.n385 9.3005
R1789 VSS.n387 VSS.n335 9.3005
R1790 VSS.n391 VSS.n388 9.3005
R1791 VSS.n392 VSS.n334 9.3005
R1792 VSS.n396 VSS.n395 9.3005
R1793 VSS.n397 VSS.n333 9.3005
R1794 VSS.n401 VSS.n398 9.3005
R1795 VSS.n402 VSS.n332 9.3005
R1796 VSS.n406 VSS.n405 9.3005
R1797 VSS.n407 VSS.n331 9.3005
R1798 VSS.n411 VSS.n408 9.3005
R1799 VSS.n412 VSS.n330 9.3005
R1800 VSS.n416 VSS.n415 9.3005
R1801 VSS.n417 VSS.n329 9.3005
R1802 VSS.n421 VSS.n418 9.3005
R1803 VSS.n422 VSS.n328 9.3005
R1804 VSS.n426 VSS.n425 9.3005
R1805 VSS.n427 VSS.n327 9.3005
R1806 VSS.n431 VSS.n428 9.3005
R1807 VSS.n432 VSS.n326 9.3005
R1808 VSS.n436 VSS.n435 9.3005
R1809 VSS.n437 VSS.n325 9.3005
R1810 VSS.n441 VSS.n438 9.3005
R1811 VSS.n442 VSS.n324 9.3005
R1812 VSS.n446 VSS.n445 9.3005
R1813 VSS.n447 VSS.n323 9.3005
R1814 VSS.n451 VSS.n448 9.3005
R1815 VSS.n452 VSS.n322 9.3005
R1816 VSS.n456 VSS.n455 9.3005
R1817 VSS.n457 VSS.n321 9.3005
R1818 VSS.n459 VSS.n458 9.3005
R1819 VSS.n533 VSS.n532 9.3005
R1820 VSS.n531 VSS.n204 9.3005
R1821 VSS.n530 VSS.n529 9.3005
R1822 VSS.n528 VSS.n208 9.3005
R1823 VSS.n527 VSS.n526 9.3005
R1824 VSS.n525 VSS.n209 9.3005
R1825 VSS.n524 VSS.n523 9.3005
R1826 VSS.n522 VSS.n213 9.3005
R1827 VSS.n521 VSS.n520 9.3005
R1828 VSS.n519 VSS.n214 9.3005
R1829 VSS.n518 VSS.n517 9.3005
R1830 VSS.n516 VSS.n218 9.3005
R1831 VSS.n515 VSS.n514 9.3005
R1832 VSS.n513 VSS.n219 9.3005
R1833 VSS.n512 VSS.n511 9.3005
R1834 VSS.n510 VSS.n223 9.3005
R1835 VSS.n509 VSS.n508 9.3005
R1836 VSS.n507 VSS.n224 9.3005
R1837 VSS.n506 VSS.n505 9.3005
R1838 VSS.n504 VSS.n228 9.3005
R1839 VSS.n503 VSS.n502 9.3005
R1840 VSS.n501 VSS.n229 9.3005
R1841 VSS.n500 VSS.n499 9.3005
R1842 VSS.n498 VSS.n233 9.3005
R1843 VSS.n497 VSS.n496 9.3005
R1844 VSS.n495 VSS.n234 9.3005
R1845 VSS.n494 VSS.n493 9.3005
R1846 VSS.n492 VSS.n238 9.3005
R1847 VSS.n491 VSS.n490 9.3005
R1848 VSS.n489 VSS.n239 9.3005
R1849 VSS.n488 VSS.n487 9.3005
R1850 VSS.n486 VSS.n243 9.3005
R1851 VSS.n485 VSS.n484 9.3005
R1852 VSS.n483 VSS.n244 9.3005
R1853 VSS.n482 VSS.n481 9.3005
R1854 VSS.n480 VSS.n248 9.3005
R1855 VSS.n479 VSS.n478 9.3005
R1856 VSS.n477 VSS.n249 9.3005
R1857 VSS.n476 VSS.n475 9.3005
R1858 VSS.n474 VSS.n253 9.3005
R1859 VSS.n473 VSS.n472 9.3005
R1860 VSS.n471 VSS.n254 9.3005
R1861 VSS.n470 VSS.n469 9.3005
R1862 VSS.n468 VSS.n258 9.3005
R1863 VSS.n467 VSS.n466 9.3005
R1864 VSS.n465 VSS.n259 9.3005
R1865 VSS.n38 VSS.n15 9.3005
R1866 VSS.n534 VSS.n202 9.3005
R1867 VSS.n537 VSS.n536 9.3005
R1868 VSS.n535 VSS.n203 9.3005
R1869 VSS.n187 VSS.n186 9.3005
R1870 VSS.n557 VSS.n556 9.3005
R1871 VSS.n558 VSS.n184 9.3005
R1872 VSS.n561 VSS.n560 9.3005
R1873 VSS.n559 VSS.n185 9.3005
R1874 VSS.n168 VSS.n167 9.3005
R1875 VSS.n582 VSS.n581 9.3005
R1876 VSS.n583 VSS.n165 9.3005
R1877 VSS.n586 VSS.n585 9.3005
R1878 VSS.n584 VSS.n166 9.3005
R1879 VSS.n150 VSS.n149 9.3005
R1880 VSS.n748 VSS.n747 9.3005
R1881 VSS.n749 VSS.n147 9.3005
R1882 VSS.n886 VSS.n885 9.3005
R1883 VSS.n884 VSS.n94 9.3005
R1884 VSS.n883 VSS.n882 9.3005
R1885 VSS.n97 VSS.n96 9.3005
R1886 VSS.n813 VSS.n812 9.3005
R1887 VSS.n814 VSS.n809 9.3005
R1888 VSS.n816 VSS.n815 9.3005
R1889 VSS.n817 VSS.n804 9.3005
R1890 VSS.n819 VSS.n818 9.3005
R1891 VSS.n820 VSS.n803 9.3005
R1892 VSS.n822 VSS.n821 9.3005
R1893 VSS.n823 VSS.n798 9.3005
R1894 VSS.n825 VSS.n824 9.3005
R1895 VSS.n826 VSS.n797 9.3005
R1896 VSS.n828 VSS.n827 9.3005
R1897 VSS.n829 VSS.n792 9.3005
R1898 VSS.n831 VSS.n830 9.3005
R1899 VSS.n832 VSS.n791 9.3005
R1900 VSS.n834 VSS.n833 9.3005
R1901 VSS.n835 VSS.n786 9.3005
R1902 VSS.n837 VSS.n836 9.3005
R1903 VSS.n838 VSS.n785 9.3005
R1904 VSS.n840 VSS.n839 9.3005
R1905 VSS.n841 VSS.n780 9.3005
R1906 VSS.n843 VSS.n842 9.3005
R1907 VSS.n844 VSS.n779 9.3005
R1908 VSS.n846 VSS.n845 9.3005
R1909 VSS.n847 VSS.n774 9.3005
R1910 VSS.n849 VSS.n848 9.3005
R1911 VSS.n850 VSS.n773 9.3005
R1912 VSS.n852 VSS.n851 9.3005
R1913 VSS.n853 VSS.n768 9.3005
R1914 VSS.n855 VSS.n854 9.3005
R1915 VSS.n856 VSS.n767 9.3005
R1916 VSS.n858 VSS.n857 9.3005
R1917 VSS.n859 VSS.n762 9.3005
R1918 VSS.n861 VSS.n860 9.3005
R1919 VSS.n862 VSS.n761 9.3005
R1920 VSS.n864 VSS.n863 9.3005
R1921 VSS.n865 VSS.n756 9.3005
R1922 VSS.n867 VSS.n866 9.3005
R1923 VSS.n868 VSS.n755 9.3005
R1924 VSS.n870 VSS.n869 9.3005
R1925 VSS.n871 VSS.n750 9.3005
R1926 VSS.n873 VSS.n872 9.3005
R1927 VSS.n874 VSS.n148 9.3005
R1928 VSS.n876 VSS.n875 9.3005
R1929 VSS.n734 VSS.n733 9.3005
R1930 VSS.n732 VSS.n596 9.3005
R1931 VSS.n731 VSS.n730 9.3005
R1932 VSS.n727 VSS.n597 9.3005
R1933 VSS.n724 VSS.n723 9.3005
R1934 VSS.n722 VSS.n598 9.3005
R1935 VSS.n721 VSS.n720 9.3005
R1936 VSS.n717 VSS.n599 9.3005
R1937 VSS.n714 VSS.n713 9.3005
R1938 VSS.n712 VSS.n600 9.3005
R1939 VSS.n711 VSS.n710 9.3005
R1940 VSS.n707 VSS.n601 9.3005
R1941 VSS.n704 VSS.n703 9.3005
R1942 VSS.n702 VSS.n602 9.3005
R1943 VSS.n701 VSS.n700 9.3005
R1944 VSS.n697 VSS.n603 9.3005
R1945 VSS.n694 VSS.n693 9.3005
R1946 VSS.n692 VSS.n604 9.3005
R1947 VSS.n691 VSS.n690 9.3005
R1948 VSS.n687 VSS.n605 9.3005
R1949 VSS.n684 VSS.n683 9.3005
R1950 VSS.n682 VSS.n606 9.3005
R1951 VSS.n681 VSS.n680 9.3005
R1952 VSS.n677 VSS.n607 9.3005
R1953 VSS.n674 VSS.n673 9.3005
R1954 VSS.n672 VSS.n608 9.3005
R1955 VSS.n671 VSS.n670 9.3005
R1956 VSS.n667 VSS.n609 9.3005
R1957 VSS.n664 VSS.n663 9.3005
R1958 VSS.n662 VSS.n610 9.3005
R1959 VSS.n661 VSS.n660 9.3005
R1960 VSS.n657 VSS.n611 9.3005
R1961 VSS.n654 VSS.n653 9.3005
R1962 VSS.n652 VSS.n612 9.3005
R1963 VSS.n651 VSS.n650 9.3005
R1964 VSS.n647 VSS.n613 9.3005
R1965 VSS.n644 VSS.n643 9.3005
R1966 VSS.n642 VSS.n614 9.3005
R1967 VSS.n641 VSS.n640 9.3005
R1968 VSS.n637 VSS.n615 9.3005
R1969 VSS.n634 VSS.n633 9.3005
R1970 VSS.n632 VSS.n616 9.3005
R1971 VSS.n631 VSS.n630 9.3005
R1972 VSS.n627 VSS.n617 9.3005
R1973 VSS.n624 VSS.n623 9.3005
R1974 VSS.n622 VSS.n619 9.3005
R1975 VSS.n621 VSS.n620 9.3005
R1976 VSS.n914 VSS.n16 9.3005
R1977 VSS.n911 VSS.n42 9.3005
R1978 VSS.n910 VSS.n43 9.3005
R1979 VSS.n909 VSS.n44 9.3005
R1980 VSS.n552 VSS.n45 9.3005
R1981 VSS.n905 VSS.n50 9.3005
R1982 VSS.n903 VSS.n53 9.3005
R1983 VSS.n902 VSS.n54 9.3005
R1984 VSS.n172 VSS.n55 9.3005
R1985 VSS.n898 VSS.n60 9.3005
R1986 VSS.n896 VSS.n63 9.3005
R1987 VSS.n895 VSS.n64 9.3005
R1988 VSS.n155 VSS.n65 9.3005
R1989 VSS.n891 VSS.n70 9.3005
R1990 VSS.n890 VSS.n71 9.3005
R1991 VSS.n888 VSS.n92 9.3005
R1992 VSS.n888 VSS.n887 9.3005
R1993 VSS.n890 VSS.n69 9.3005
R1994 VSS.n892 VSS.n891 9.3005
R1995 VSS.n893 VSS.n65 9.3005
R1996 VSS.n895 VSS.n894 9.3005
R1997 VSS.n896 VSS.n59 9.3005
R1998 VSS.n899 VSS.n898 9.3005
R1999 VSS.n900 VSS.n55 9.3005
R2000 VSS.n902 VSS.n901 9.3005
R2001 VSS.n903 VSS.n49 9.3005
R2002 VSS.n906 VSS.n905 9.3005
R2003 VSS.n907 VSS.n45 9.3005
R2004 VSS.n909 VSS.n908 9.3005
R2005 VSS.n910 VSS.n41 9.3005
R2006 VSS.n912 VSS.n911 9.3005
R2007 VSS.n914 VSS.n913 9.3005
R2008 VSS.n35 VSS.n28 9.2683
R2009 VSS.n25 VSS.n18 9.2683
R2010 VSS.n90 VSS.n83 9.2683
R2011 VSS.n80 VSS.n73 9.2683
R2012 VSS.n576 VSS.t25 7.7198
R2013 VSS.n31 VSS.n30 6.31057
R2014 VSS.n86 VSS.n85 6.31057
R2015 VSS.n21 VSS.n20 6.31055
R2016 VSS.n76 VSS.n75 6.31055
R2017 VSS.n554 VSS.t11 6.17594
R2018 VSS.n588 VSS.t5 6.17594
R2019 VSS.n52 VSS.t19 6.0005
R2020 VSS.n52 VSS.t18 6.0005
R2021 VSS.n51 VSS.t12 6.0005
R2022 VSS.n51 VSS.t10 6.0005
R2023 VSS.n62 VSS.t17 6.0005
R2024 VSS.n62 VSS.t16 6.0005
R2025 VSS.n61 VSS.t8 6.0005
R2026 VSS.n61 VSS.t6 6.0005
R2027 VSS.n549 VSS.t21 3.60284
R2028 VSS.n943 VSS.n942 3.48626
R2029 VSS.n920 VSS.n919 3.4105
R2030 VSS.n921 VSS.n11 3.4105
R2031 VSS.n923 VSS.n922 3.4105
R2032 VSS.n9 VSS.n8 3.4105
R2033 VSS.n928 VSS.n927 3.4105
R2034 VSS.n929 VSS.n7 3.4105
R2035 VSS.n931 VSS.n930 3.4105
R2036 VSS.n5 VSS.n4 3.4105
R2037 VSS.n937 VSS.n936 3.4105
R2038 VSS.n938 VSS.n3 3.4105
R2039 VSS.n940 VSS.n939 3.4105
R2040 VSS.n919 VSS.n918 3.4105
R2041 VSS.n11 VSS.n10 3.4105
R2042 VSS.n924 VSS.n923 3.4105
R2043 VSS.n925 VSS.n9 3.4105
R2044 VSS.n927 VSS.n926 3.4105
R2045 VSS.n7 VSS.n6 3.4105
R2046 VSS.n932 VSS.n931 3.4105
R2047 VSS.n933 VSS.n5 3.4105
R2048 VSS.n936 VSS.n935 3.4105
R2049 VSS.n934 VSS.n3 3.4105
R2050 VSS.n940 VSS.n2 3.4105
R2051 VSS.n942 VSS.n941 3.4105
R2052 VSS.n944 VSS.n943 2.85775
R2053 VSS.t13 VSS.n192 2.05898
R2054 VSS.n741 VSS.t3 2.05898
R2055 VSS.n939 VSS.n1 1.79814
R2056 VSS.n588 VSS.t24 1.54436
R2057 VSS.n22 VSS.n21 1.16652
R2058 VSS.n77 VSS.n76 1.16652
R2059 VSS.n32 VSS.n31 1.1665
R2060 VSS.n87 VSS.n86 1.1665
R2061 VSS.n13 VSS.n12 0.492095
R2062 VSS.n917 VSS.n13 0.491119
R2063 VSS.n458 VSS.n195 0.323938
R2064 VSS.n733 VSS.n595 0.323938
R2065 VSS.n534 VSS.n533 0.323938
R2066 VSS.n875 VSS.n749 0.323938
R2067 VSS.n37 VSS.n26 0.296333
R2068 VSS.n37 VSS.n36 0.296333
R2069 VSS.n889 VSS.n81 0.296333
R2070 VSS.n889 VSS.n91 0.296333
R2071 VSS.n944 VSS 0.270841
R2072 VSS.n915 VSS.n14 0.167687
R2073 VSS.n915 VSS.n15 0.167687
R2074 VSS.n885 VSS.n0 0.167687
R2075 VSS.n621 VSS.n0 0.167687
R2076 VSS.n22 VSS.n17 0.1505
R2077 VSS.n26 VSS.n17 0.1505
R2078 VSS.n36 VSS.n27 0.1505
R2079 VSS.n32 VSS.n27 0.1505
R2080 VSS.n77 VSS.n72 0.1505
R2081 VSS.n81 VSS.n72 0.1505
R2082 VSS.n91 VSS.n82 0.1505
R2083 VSS.n87 VSS.n82 0.1505
R2084 VSS.n945 VSS.n944 0.140339
R2085 VSS.n347 VSS.n14 0.113
R2086 VSS.n348 VSS.n347 0.113
R2087 VSS.n348 VSS.n342 0.113
R2088 VSS.n356 VSS.n342 0.113
R2089 VSS.n357 VSS.n356 0.113
R2090 VSS.n358 VSS.n357 0.113
R2091 VSS.n358 VSS.n340 0.113
R2092 VSS.n366 VSS.n340 0.113
R2093 VSS.n367 VSS.n366 0.113
R2094 VSS.n368 VSS.n367 0.113
R2095 VSS.n368 VSS.n338 0.113
R2096 VSS.n376 VSS.n338 0.113
R2097 VSS.n377 VSS.n376 0.113
R2098 VSS.n378 VSS.n377 0.113
R2099 VSS.n378 VSS.n336 0.113
R2100 VSS.n386 VSS.n336 0.113
R2101 VSS.n387 VSS.n386 0.113
R2102 VSS.n388 VSS.n387 0.113
R2103 VSS.n388 VSS.n334 0.113
R2104 VSS.n396 VSS.n334 0.113
R2105 VSS.n397 VSS.n396 0.113
R2106 VSS.n398 VSS.n397 0.113
R2107 VSS.n398 VSS.n332 0.113
R2108 VSS.n406 VSS.n332 0.113
R2109 VSS.n407 VSS.n406 0.113
R2110 VSS.n408 VSS.n407 0.113
R2111 VSS.n408 VSS.n330 0.113
R2112 VSS.n416 VSS.n330 0.113
R2113 VSS.n417 VSS.n416 0.113
R2114 VSS.n418 VSS.n417 0.113
R2115 VSS.n418 VSS.n328 0.113
R2116 VSS.n426 VSS.n328 0.113
R2117 VSS.n427 VSS.n426 0.113
R2118 VSS.n428 VSS.n427 0.113
R2119 VSS.n428 VSS.n326 0.113
R2120 VSS.n436 VSS.n326 0.113
R2121 VSS.n437 VSS.n436 0.113
R2122 VSS.n438 VSS.n437 0.113
R2123 VSS.n438 VSS.n324 0.113
R2124 VSS.n446 VSS.n324 0.113
R2125 VSS.n447 VSS.n446 0.113
R2126 VSS.n448 VSS.n447 0.113
R2127 VSS.n448 VSS.n322 0.113
R2128 VSS.n456 VSS.n322 0.113
R2129 VSS.n457 VSS.n456 0.113
R2130 VSS.n458 VSS.n457 0.113
R2131 VSS.n542 VSS.n195 0.113
R2132 VSS.n543 VSS.n542 0.113
R2133 VSS.n544 VSS.n543 0.113
R2134 VSS.n545 VSS.n544 0.113
R2135 VSS.n545 VSS.n176 0.113
R2136 VSS.n566 VSS.n176 0.113
R2137 VSS.n567 VSS.n566 0.113
R2138 VSS.n568 VSS.n567 0.113
R2139 VSS.n569 VSS.n568 0.113
R2140 VSS.n569 VSS.n159 0.113
R2141 VSS.n591 VSS.n159 0.113
R2142 VSS.n592 VSS.n591 0.113
R2143 VSS.n593 VSS.n592 0.113
R2144 VSS.n594 VSS.n593 0.113
R2145 VSS.n595 VSS.n594 0.113
R2146 VSS.n533 VSS.n204 0.113
R2147 VSS.n529 VSS.n204 0.113
R2148 VSS.n529 VSS.n528 0.113
R2149 VSS.n528 VSS.n527 0.113
R2150 VSS.n527 VSS.n209 0.113
R2151 VSS.n523 VSS.n209 0.113
R2152 VSS.n523 VSS.n522 0.113
R2153 VSS.n522 VSS.n521 0.113
R2154 VSS.n521 VSS.n214 0.113
R2155 VSS.n517 VSS.n214 0.113
R2156 VSS.n517 VSS.n516 0.113
R2157 VSS.n516 VSS.n515 0.113
R2158 VSS.n515 VSS.n219 0.113
R2159 VSS.n511 VSS.n219 0.113
R2160 VSS.n511 VSS.n510 0.113
R2161 VSS.n510 VSS.n509 0.113
R2162 VSS.n509 VSS.n224 0.113
R2163 VSS.n505 VSS.n224 0.113
R2164 VSS.n505 VSS.n504 0.113
R2165 VSS.n504 VSS.n503 0.113
R2166 VSS.n503 VSS.n229 0.113
R2167 VSS.n499 VSS.n229 0.113
R2168 VSS.n499 VSS.n498 0.113
R2169 VSS.n498 VSS.n497 0.113
R2170 VSS.n497 VSS.n234 0.113
R2171 VSS.n493 VSS.n234 0.113
R2172 VSS.n493 VSS.n492 0.113
R2173 VSS.n492 VSS.n491 0.113
R2174 VSS.n491 VSS.n239 0.113
R2175 VSS.n487 VSS.n239 0.113
R2176 VSS.n487 VSS.n486 0.113
R2177 VSS.n486 VSS.n485 0.113
R2178 VSS.n485 VSS.n244 0.113
R2179 VSS.n481 VSS.n244 0.113
R2180 VSS.n481 VSS.n480 0.113
R2181 VSS.n480 VSS.n479 0.113
R2182 VSS.n479 VSS.n249 0.113
R2183 VSS.n475 VSS.n249 0.113
R2184 VSS.n475 VSS.n474 0.113
R2185 VSS.n474 VSS.n473 0.113
R2186 VSS.n473 VSS.n254 0.113
R2187 VSS.n469 VSS.n254 0.113
R2188 VSS.n469 VSS.n468 0.113
R2189 VSS.n468 VSS.n467 0.113
R2190 VSS.n467 VSS.n259 0.113
R2191 VSS.n259 VSS.n15 0.113
R2192 VSS.n536 VSS.n534 0.113
R2193 VSS.n536 VSS.n535 0.113
R2194 VSS.n535 VSS.n186 0.113
R2195 VSS.n557 VSS.n186 0.113
R2196 VSS.n558 VSS.n557 0.113
R2197 VSS.n560 VSS.n558 0.113
R2198 VSS.n560 VSS.n559 0.113
R2199 VSS.n559 VSS.n167 0.113
R2200 VSS.n582 VSS.n167 0.113
R2201 VSS.n583 VSS.n582 0.113
R2202 VSS.n585 VSS.n583 0.113
R2203 VSS.n585 VSS.n584 0.113
R2204 VSS.n584 VSS.n149 0.113
R2205 VSS.n748 VSS.n149 0.113
R2206 VSS.n749 VSS.n748 0.113
R2207 VSS.n875 VSS.n874 0.113
R2208 VSS.n874 VSS.n873 0.113
R2209 VSS.n873 VSS.n750 0.113
R2210 VSS.n869 VSS.n750 0.113
R2211 VSS.n869 VSS.n868 0.113
R2212 VSS.n868 VSS.n867 0.113
R2213 VSS.n867 VSS.n756 0.113
R2214 VSS.n863 VSS.n756 0.113
R2215 VSS.n863 VSS.n862 0.113
R2216 VSS.n862 VSS.n861 0.113
R2217 VSS.n861 VSS.n762 0.113
R2218 VSS.n857 VSS.n762 0.113
R2219 VSS.n857 VSS.n856 0.113
R2220 VSS.n856 VSS.n855 0.113
R2221 VSS.n855 VSS.n768 0.113
R2222 VSS.n851 VSS.n768 0.113
R2223 VSS.n851 VSS.n850 0.113
R2224 VSS.n850 VSS.n849 0.113
R2225 VSS.n849 VSS.n774 0.113
R2226 VSS.n845 VSS.n774 0.113
R2227 VSS.n845 VSS.n844 0.113
R2228 VSS.n844 VSS.n843 0.113
R2229 VSS.n843 VSS.n780 0.113
R2230 VSS.n839 VSS.n780 0.113
R2231 VSS.n839 VSS.n838 0.113
R2232 VSS.n838 VSS.n837 0.113
R2233 VSS.n837 VSS.n786 0.113
R2234 VSS.n833 VSS.n786 0.113
R2235 VSS.n833 VSS.n832 0.113
R2236 VSS.n832 VSS.n831 0.113
R2237 VSS.n831 VSS.n792 0.113
R2238 VSS.n827 VSS.n792 0.113
R2239 VSS.n827 VSS.n826 0.113
R2240 VSS.n826 VSS.n825 0.113
R2241 VSS.n825 VSS.n798 0.113
R2242 VSS.n821 VSS.n798 0.113
R2243 VSS.n821 VSS.n820 0.113
R2244 VSS.n820 VSS.n819 0.113
R2245 VSS.n819 VSS.n804 0.113
R2246 VSS.n815 VSS.n804 0.113
R2247 VSS.n815 VSS.n814 0.113
R2248 VSS.n814 VSS.n813 0.113
R2249 VSS.n813 VSS.n96 0.113
R2250 VSS.n883 VSS.n96 0.113
R2251 VSS.n884 VSS.n883 0.113
R2252 VSS.n885 VSS.n884 0.113
R2253 VSS.n622 VSS.n621 0.113
R2254 VSS.n623 VSS.n622 0.113
R2255 VSS.n623 VSS.n617 0.113
R2256 VSS.n631 VSS.n617 0.113
R2257 VSS.n632 VSS.n631 0.113
R2258 VSS.n633 VSS.n632 0.113
R2259 VSS.n633 VSS.n615 0.113
R2260 VSS.n641 VSS.n615 0.113
R2261 VSS.n642 VSS.n641 0.113
R2262 VSS.n643 VSS.n642 0.113
R2263 VSS.n643 VSS.n613 0.113
R2264 VSS.n651 VSS.n613 0.113
R2265 VSS.n652 VSS.n651 0.113
R2266 VSS.n653 VSS.n652 0.113
R2267 VSS.n653 VSS.n611 0.113
R2268 VSS.n661 VSS.n611 0.113
R2269 VSS.n662 VSS.n661 0.113
R2270 VSS.n663 VSS.n662 0.113
R2271 VSS.n663 VSS.n609 0.113
R2272 VSS.n671 VSS.n609 0.113
R2273 VSS.n672 VSS.n671 0.113
R2274 VSS.n673 VSS.n672 0.113
R2275 VSS.n673 VSS.n607 0.113
R2276 VSS.n681 VSS.n607 0.113
R2277 VSS.n682 VSS.n681 0.113
R2278 VSS.n683 VSS.n682 0.113
R2279 VSS.n683 VSS.n605 0.113
R2280 VSS.n691 VSS.n605 0.113
R2281 VSS.n692 VSS.n691 0.113
R2282 VSS.n693 VSS.n692 0.113
R2283 VSS.n693 VSS.n603 0.113
R2284 VSS.n701 VSS.n603 0.113
R2285 VSS.n702 VSS.n701 0.113
R2286 VSS.n703 VSS.n702 0.113
R2287 VSS.n703 VSS.n601 0.113
R2288 VSS.n711 VSS.n601 0.113
R2289 VSS.n712 VSS.n711 0.113
R2290 VSS.n713 VSS.n712 0.113
R2291 VSS.n713 VSS.n599 0.113
R2292 VSS.n721 VSS.n599 0.113
R2293 VSS.n722 VSS.n721 0.113
R2294 VSS.n723 VSS.n722 0.113
R2295 VSS.n723 VSS.n597 0.113
R2296 VSS.n731 VSS.n597 0.113
R2297 VSS.n732 VSS.n731 0.113
R2298 VSS.n733 VSS.n732 0.113
R2299 VSS.n920 VSS.n12 0.0762576
R2300 VSS.n921 VSS.n920 0.0762576
R2301 VSS.n922 VSS.n921 0.0762576
R2302 VSS.n922 VSS.n8 0.0762576
R2303 VSS.n928 VSS.n8 0.0762576
R2304 VSS.n929 VSS.n928 0.0762576
R2305 VSS.n930 VSS.n929 0.0762576
R2306 VSS.n930 VSS.n4 0.0762576
R2307 VSS.n937 VSS.n4 0.0762576
R2308 VSS.n938 VSS.n937 0.0762576
R2309 VSS.n939 VSS.n938 0.0762576
R2310 VSS.n918 VSS.n917 0.0762576
R2311 VSS.n918 VSS.n10 0.0762576
R2312 VSS.n924 VSS.n10 0.0762576
R2313 VSS.n925 VSS.n924 0.0762576
R2314 VSS.n926 VSS.n925 0.0762576
R2315 VSS.n926 VSS.n6 0.0762576
R2316 VSS.n932 VSS.n6 0.0762576
R2317 VSS.n933 VSS.n932 0.0762576
R2318 VSS.n935 VSS.n933 0.0762576
R2319 VSS.n935 VSS.n934 0.0762576
R2320 VSS.n934 VSS.n2 0.0762576
R2321 VSS.n942 VSS.n2 0.0762576
R2322 VSS.n917 VSS.n916 0.0666765
R2323 VSS.n916 VSS.n12 0.0666765
R2324 VSS.n919 VSS.n13 0.03564
R2325 VSS.n915 VSS.n914 0.0228214
R2326 VSS.n888 VSS.n0 0.0228214
R2327 VSS.n911 VSS.n910 0.0165714
R2328 VSS.n910 VSS.n909 0.0165714
R2329 VSS.n909 VSS.n45 0.0165714
R2330 VSS.n905 VSS.n45 0.0165714
R2331 VSS.n903 VSS.n902 0.0165714
R2332 VSS.n902 VSS.n55 0.0165714
R2333 VSS.n898 VSS.n55 0.0165714
R2334 VSS.n896 VSS.n895 0.0165714
R2335 VSS.n895 VSS.n65 0.0165714
R2336 VSS.n891 VSS.n65 0.0165714
R2337 VSS.n891 VSS.n890 0.0165714
R2338 VSS.n914 VSS.n37 0.0138929
R2339 VSS.n889 VSS.n888 0.0138929
R2340 VSS VSS.n945 0.0138929
R2341 VSS.n904 VSS.n903 0.0121071
R2342 VSS.n898 VSS.n897 0.0121071
R2343 VSS.n919 VSS.n11 0.0099
R2344 VSS.n923 VSS.n11 0.0099
R2345 VSS.n923 VSS.n9 0.0099
R2346 VSS.n927 VSS.n9 0.0099
R2347 VSS.n927 VSS.n7 0.0099
R2348 VSS.n931 VSS.n7 0.0099
R2349 VSS.n931 VSS.n5 0.0099
R2350 VSS.n936 VSS.n5 0.0099
R2351 VSS.n936 VSS.n3 0.0099
R2352 VSS.n940 VSS.n3 0.0099
R2353 VSS.n941 VSS.n940 0.0099
R2354 VSS.n945 VSS.n0 0.00942857
R2355 VSS.n943 VSS.n1 0.00574517
R2356 VSS.n941 VSS.n1 0.00564204
R2357 VSS.n905 VSS.n904 0.00496429
R2358 VSS.n897 VSS.n896 0.00496429
R2359 VSS.n911 VSS.n37 0.00317857
R2360 VSS.n890 VSS.n889 0.00317857
R2361 VSS.n916 VSS.n915 0.00161607
C0 sa sp 1.21882f
C1 gi outn 5.45922f
C2 inn outp 0.41664f
C3 outp nb 0.14193f
C4 outp VDD 7.91288f
C5 a_1156_10545# VDD 0.34272f
C6 outp sn 5.62091f
C7 outn sp 5.73149f
C8 gi inp 0
C9 inn gi 0
C10 gi nb 0
C11 inp sp 0.63352f
C12 gi VDD 4.4579f
C13 gi sn 1.22402f
C14 inn sp -0
C15 outp a_1156_10545# 0.07168f
C16 nb sp 1.66152f
C17 sp VDD 4.30246f
C18 sn sp 2.52049f
C19 outn lna_lo_n 0.3547f
C20 outp gi 0.17964f
C21 gi a_1156_10545# 0.57651f
C22 sa outn 0.02058f
C23 outp sp 1.09055f
C24 a_1156_10545# sp 0.58933f
C25 lna_lo_n VDD 0.52892f
C26 lna_lo_n sn 0.01607f
C27 sa inp 0
C28 gi sp 1.32404f
C29 sa VDD 0.87034f
C30 outp lna_lo_n 0.00644f
C31 inp outn 0.41674f
C32 inn outn 0
C33 nb outn 0.14205f
C34 outn VDD 7.49006f
C35 outp sa 0.20178f
C36 outn sn 0.08961f
C37 sa a_1156_10545# 3.31468f
C38 gi lna_lo_n 0.04388f
C39 inp nb 0.04485f
C40 inp VDD 0.04792f
C41 inp sn 0
C42 inn nb 0.04485f
C43 inn VDD 0.04792f
C44 gi sa 0.34677f
C45 nb VDD 0.07639f
C46 inn sn 0.63363f
C47 nb sn 1.70822f
C48 sn VDD 5.64385f
C49 outp outn 0.2445f
C50 outn a_1156_10545# 0.4588f
C51 lna_lo_n VSS 0.94042f
C52 inn VSS 1.11837f
C53 nb VSS 11.86814f
C54 inp VSS 1.11846f
C55 outn VSS 7.11291f
C56 outp VSS 7.6409f
C57 VDD VSS 25.97172f
C58 sn VSS 8.78787f
C59 sp VSS 8.78341f
C60 a_1156_10545# VSS 0.79834f
C61 gi VSS 2.52514f
C62 sa VSS 0.80399f
C63 VDD.n1 VSS 0.00971f
C64 VDD.n2 VSS 0.04075f
C65 VDD.n3 VSS 0.0061f
C66 VDD.n4 VSS 0.0061f
C67 VDD.n5 VSS 0.0061f
C68 VDD.t4 VSS 0.10633f
C69 VDD.n6 VSS 0.0061f
C70 VDD.n7 VSS 0.0061f
C71 VDD.n8 VSS 0.0061f
C72 VDD.t2 VSS 0.10633f
C73 VDD.n9 VSS 0.0061f
C74 VDD.n10 VSS 0.0061f
C75 VDD.n11 VSS 0.0061f
C76 VDD.n12 VSS 0.01164f
C77 VDD.n13 VSS 0.0061f
C78 VDD.n14 VSS 0.0061f
C79 VDD.n15 VSS 0.22742f
C80 VDD.n21 VSS 0.0061f
C81 VDD.n22 VSS 0.01164f
C82 VDD.n23 VSS 0.0061f
C83 VDD.n24 VSS 0.0061f
C84 VDD.n25 VSS 0.0061f
C85 VDD.n26 VSS 0.0061f
C86 VDD.n27 VSS 0.0061f
C87 VDD.n28 VSS 0.0061f
C88 VDD.n29 VSS 0.0061f
C89 VDD.n30 VSS 0.0061f
C90 VDD.n31 VSS 0.0061f
C91 VDD.n32 VSS 0.0061f
C92 VDD.n33 VSS 0.0061f
C93 VDD.n34 VSS 0.0061f
C94 VDD.n35 VSS 0.0061f
C95 VDD.n36 VSS 0.0061f
C96 VDD.n37 VSS 0.0061f
C97 VDD.n38 VSS 0.0061f
C98 VDD.n39 VSS 0.0061f
C99 VDD.n40 VSS 0.0061f
C100 VDD.n41 VSS 0.0061f
C101 VDD.t6 VSS 0.10633f
C102 VDD.n42 VSS 0.01164f
C103 VDD.n43 VSS 0.0061f
C104 VDD.n44 VSS 0.22742f
C105 VDD.n45 VSS 0.01164f
C106 VDD.n46 VSS 0.0061f
C107 VDD.n47 VSS 0.0061f
C108 VDD.n52 VSS 0.0061f
C109 VDD.n53 VSS 0.00162f
C110 VDD.n54 VSS 0.01181f
C111 VDD.n55 VSS 0.01148f
C112 VDD.n56 VSS 0.01148f
C113 VDD.n57 VSS 0.0061f
C114 VDD.n58 VSS 0.0061f
C115 VDD.n59 VSS 0.0061f
C116 VDD.n60 VSS 0.0061f
C117 VDD.n61 VSS 0.0061f
C118 VDD.n62 VSS 0.0061f
C119 VDD.n63 VSS 0.0061f
C120 VDD.n64 VSS 0.0061f
C121 VDD.n65 VSS 0.0061f
C122 VDD.n66 VSS 0.0061f
C123 VDD.n67 VSS 0.0061f
C124 VDD.n68 VSS 0.0061f
C125 VDD.n69 VSS 0.0061f
C126 VDD.n70 VSS 0.0061f
C127 VDD.n71 VSS 0.0061f
C128 VDD.n72 VSS 0.0061f
C129 VDD.n73 VSS 0.0061f
C130 VDD.n75 VSS 0.35147f
C131 VDD.n77 VSS 0.01148f
C132 VDD.n78 VSS 0.01148f
C133 VDD.n79 VSS 0.01164f
C134 VDD.n80 VSS 0.0061f
C135 VDD.n81 VSS 0.0061f
C136 VDD.n82 VSS 0.1462f
C137 VDD.n83 VSS 0.0061f
C138 VDD.n84 VSS 0.0061f
C139 VDD.n85 VSS 0.13291f
C140 VDD.t5 VSS 0.10633f
C141 VDD.n86 VSS 0.13291f
C142 VDD.n87 VSS 0.0061f
C143 VDD.n88 VSS 0.0061f
C144 VDD.n89 VSS 0.0061f
C145 VDD.n90 VSS 0.0061f
C146 VDD.n91 VSS 0.0061f
C147 VDD.n92 VSS 0.0061f
C148 VDD.n93 VSS 0.0061f
C149 VDD.n94 VSS 0.13291f
C150 VDD.t1 VSS 0.10633f
C151 VDD.n95 VSS 0.0061f
C152 VDD.n96 VSS 0.1462f
C153 VDD.n97 VSS 0.0061f
C154 VDD.n98 VSS 0.0061f
C155 VDD.n99 VSS 0.01164f
C156 VDD.n100 VSS 0.01148f
C157 VDD.n101 VSS 0.01148f
C158 VDD.n102 VSS 0.35147f
C159 VDD.n103 VSS 0.01148f
C160 VDD.n104 VSS 0.01148f
C161 VDD.n105 VSS 0.01181f
C162 VDD.n106 VSS 0.00162f
C163 VDD.n107 VSS 0.04075f
C164 VDD.n108 VSS 0.0061f
C165 VDD.n109 VSS 0.0061f
C166 VDD.n110 VSS 0.0061f
C167 VDD.n111 VSS 0.13291f
C168 VDD.t3 VSS 0.10633f
C169 VDD.n112 VSS 0.11962f
C170 VDD.n113 VSS 0.11962f
C171 VDD.n114 VSS 0.0061f
C172 VDD.n115 VSS 0.0061f
C173 VDD.n116 VSS 0.0061f
C174 VDD.n117 VSS 0.00971f
C175 VDD.n118 VSS 0.02297f
C176 VDD.n119 VSS 0.25986f
C177 VDD.t0 VSS 1.18017f
C178 VDD.t10 VSS 1.18017f
C179 VDD.n120 VSS 0.02631f
C180 VDD.n121 VSS 0.0061f
C181 VDD.n122 VSS 0.01361f
C182 VDD.n123 VSS 0.0061f
C183 VDD.n124 VSS 0.0061f
C184 VDD.n125 VSS 0.0061f
C185 VDD.n126 VSS 0.0061f
C186 VDD.n127 VSS 0.01399f
C187 VDD.n128 VSS 0.0061f
C188 VDD.n129 VSS 0.0061f
C189 VDD.n130 VSS 0.0061f
C190 VDD.n131 VSS 0.0113f
C191 VDD.n132 VSS 0.0061f
C192 VDD.n133 VSS 0.0061f
C193 VDD.n134 VSS 0.29168f
C194 VDD.n141 VSS 0.0061f
C195 VDD.n142 VSS 0.0061f
C196 VDD.n143 VSS 0.0113f
C197 VDD.n144 VSS 0.0061f
C198 VDD.n145 VSS 0.0061f
C199 VDD.n146 VSS 0.0061f
C200 VDD.n147 VSS 0.25927f
C201 VDD.n148 VSS 0.0061f
C202 VDD.n149 VSS 0.0061f
C203 VDD.n150 VSS 0.0061f
C204 VDD.t7 VSS 0.25927f
C205 VDD.n151 VSS 0.0061f
C206 VDD.n152 VSS 0.0061f
C207 VDD.n153 VSS 0.0061f
C208 VDD.n154 VSS 0.25927f
C209 VDD.n155 VSS 0.0061f
C210 VDD.n156 VSS 0.0061f
C211 VDD.n157 VSS 0.0061f
C212 VDD.n158 VSS 0.01399f
C213 VDD.n159 VSS 0.0061f
C214 VDD.n160 VSS 0.0061f
C215 VDD.n161 VSS 0.0061f
C216 VDD.n162 VSS 0.25927f
C217 VDD.n163 VSS 0.25927f
C218 VDD.n164 VSS 0.0061f
C219 VDD.n165 VSS 0.0061f
C220 VDD.n166 VSS 0.0061f
C221 VDD.n167 VSS 0.0061f
C222 VDD.n168 VSS 0.25927f
C223 VDD.n169 VSS 0.0061f
C224 VDD.n170 VSS 0.0061f
C225 VDD.t8 VSS 0.1418f
C226 VDD.n171 VSS 0.01131f
C227 VDD.n172 VSS 0.01131f
C228 VDD.n173 VSS 0.44292f
C229 VDD.n174 VSS 0.01131f
C230 VDD.n175 VSS 0.0061f
C231 VDD.n176 VSS 0.0061f
C232 VDD.n177 VSS 0.0061f
C233 VDD.n178 VSS 0.0061f
C234 VDD.n179 VSS 0.0061f
C235 VDD.n180 VSS 0.0061f
C236 VDD.n181 VSS 0.0061f
C237 VDD.n183 VSS 0.0061f
C238 VDD.n185 VSS 0.0061f
C239 VDD.n186 VSS 0.0061f
C240 VDD.n187 VSS 0.0061f
C241 VDD.n188 VSS 0.0061f
C242 VDD.n189 VSS 0.0061f
C243 VDD.n191 VSS 0.0061f
C244 VDD.n193 VSS 0.0061f
C245 VDD.n194 VSS 0.0061f
C246 VDD.n195 VSS 0.0061f
C247 VDD.n196 VSS 0.0061f
C248 VDD.n197 VSS 0.0061f
C249 VDD.n199 VSS 0.0061f
C250 VDD.n201 VSS 0.0061f
C251 VDD.n202 VSS 0.0061f
C252 VDD.n203 VSS 0.0061f
C253 VDD.n204 VSS 0.0061f
C254 VDD.n205 VSS 0.0061f
C255 VDD.n207 VSS 0.0061f
C256 VDD.n209 VSS 0.0061f
C257 VDD.n210 VSS 0.0061f
C258 VDD.n211 VSS 0.01131f
C259 VDD.n212 VSS 0.0113f
C260 VDD.n213 VSS 0.0113f
C261 VDD.n214 VSS 0.29168f
C262 VDD.n215 VSS 0.0113f
C263 VDD.n216 VSS 0.0114f
C264 VDD.n217 VSS 0.22403f
C265 VDD.n218 VSS 0.00952f
C266 VDD.n219 VSS 0.01399f
C267 VDD.n220 VSS 0.0061f
C268 VDD.n221 VSS 0.0061f
C269 VDD.n222 VSS 0.25927f
C270 VDD.n223 VSS 0.0061f
C271 VDD.n224 VSS 0.0061f
C272 VDD.n225 VSS 0.0061f
C273 VDD.n226 VSS 0.0061f
C274 VDD.n227 VSS 0.0061f
C275 VDD.n228 VSS 0.0061f
C276 VDD.n229 VSS 0.25927f
C277 VDD.n230 VSS 0.0061f
C278 VDD.n231 VSS 0.0061f
C279 VDD.n232 VSS 0.01399f
C280 VDD.n233 VSS 0.01399f
C281 VDD.n234 VSS 0.01361f
C282 VDD.n235 VSS 0.0061f
C283 VDD.n236 VSS 0.0061f
C284 VDD.n237 VSS 0.0061f
C285 VDD.n238 VSS 0.25927f
C286 VDD.n239 VSS 0.0061f
C287 VDD.n240 VSS 0.0061f
C288 VDD.n241 VSS 0.0061f
C289 VDD.n242 VSS 0.0061f
C290 VDD.n243 VSS 0.0061f
C291 VDD.n244 VSS 0.25927f
C292 VDD.n245 VSS 0.25927f
C293 VDD.n246 VSS 0.25927f
C294 VDD.n247 VSS 0.0061f
C295 VDD.n248 VSS 0.0061f
C296 VDD.n249 VSS 0.0061f
C297 VDD.n250 VSS 0.0061f
C298 VDD.n251 VSS 0.0061f
C299 VDD.n252 VSS 0.25927f
C300 VDD.n253 VSS 0.25927f
C301 VDD.n254 VSS 0.25927f
C302 VDD.n255 VSS 0.0061f
C303 VDD.n256 VSS 0.0061f
C304 VDD.n257 VSS 0.0113f
C305 VDD.n258 VSS 0.0061f
C306 VDD.n259 VSS 0.0061f
C307 VDD.n260 VSS 0.0061f
C308 VDD.n261 VSS 0.0061f
C309 VDD.n262 VSS 0.0061f
C310 VDD.n263 VSS 0.0061f
C311 VDD.n264 VSS 0.0061f
C312 VDD.n265 VSS 0.0061f
C313 VDD.n266 VSS 0.0061f
C314 VDD.n267 VSS 0.0061f
C315 VDD.n268 VSS 0.0061f
C316 VDD.n269 VSS 0.0061f
C317 VDD.n270 VSS 0.0061f
C318 VDD.n271 VSS 0.0061f
C319 VDD.n272 VSS 0.0061f
C320 VDD.n273 VSS 0.0061f
C321 VDD.n274 VSS 0.0061f
C322 VDD.n275 VSS 0.0061f
C323 VDD.n276 VSS 0.0061f
C324 VDD.n277 VSS 0.0061f
C325 VDD.n278 VSS 0.0061f
C326 VDD.n279 VSS 0.0061f
C327 VDD.n280 VSS 0.0061f
C328 VDD.n281 VSS 0.0061f
C329 VDD.n282 VSS 0.01131f
C330 VDD.n283 VSS 0.01131f
C331 VDD.n285 VSS 0.44292f
C332 VDD.n286 VSS 0.01131f
C333 VDD.n287 VSS 0.01131f
C334 VDD.n288 VSS 0.0114f
C335 VDD.t9 VSS 0.1418f
C336 VDD.n289 VSS 0.22403f
C337 VDD.n290 VSS 0.00952f
C338 VDD.n291 VSS 0.0061f
C339 VDD.n292 VSS 0.0061f
C340 VDD.n293 VSS 0.0061f
C341 VDD.n294 VSS 0.01399f
C342 VDD.n295 VSS 0.01399f
C343 VDD.n296 VSS 0.01399f
C344 VDD.n297 VSS 0.0061f
C345 VDD.n298 VSS 0.0061f
C346 VDD.n299 VSS 0.0061f
C347 VDD.n300 VSS 0.02631f
C348 VDD.n301 VSS 0.80486f
C349 VDD.n302 VSS 7.90023f
C350 VDD.n303 VSS 7.22407f
C351 VDD.n304 VSS 1.50467f
C352 outp.t5 VSS 1.2033f
C353 outp.n0 VSS 0.30933f
C354 outp.n1 VSS 0.30933f
C355 outp.n2 VSS 0.01147f
C356 outp.n3 VSS 0.01984f
C357 outp.t2 VSS 0.0991f
C358 outp.n4 VSS 0.09446f
C359 outp.t1 VSS 0.0991f
C360 outp.n5 VSS 0.21813f
C361 outp.n6 VSS 0.0066f
C362 outp.n7 VSS 0.03695f
C363 outp.n8 VSS 0.08498f
C364 outp.n9 VSS 0.01147f
C365 outp.n10 VSS 0.01984f
C366 outp.t4 VSS 0.0991f
C367 outp.n11 VSS 0.09446f
C368 outp.t3 VSS 0.0991f
C369 outp.n12 VSS 0.21813f
C370 outp.n13 VSS 0.0066f
C371 outp.n14 VSS 0.03695f
C372 outp.n15 VSS 0.13492f
C373 outp.n16 VSS 1.64705f
C374 outp.n17 VSS 3.11338f
C375 outp.t0 VSS 2.94589f
C376 outp.n18 VSS 3.06541f
C377 outn.t0 VSS 3.28375f
C378 outn.t1 VSS 1.6491f
C379 outn.n0 VSS 0.51378f
C380 outn.n1 VSS 0.51378f
C381 outn.n2 VSS 0.02131f
C382 outn.t3 VSS 0.13586f
C383 outn.t2 VSS 0.13586f
C384 outn.n3 VSS 0.29904f
C385 outn.n4 VSS 0.03979f
C386 outn.n5 VSS 0.0272f
C387 outn.n6 VSS 0.01573f
C388 outn.n7 VSS 0.0384f
C389 outn.n8 VSS 0.1165f
C390 outn.n9 VSS 0.02131f
C391 outn.t5 VSS 0.13586f
C392 outn.t4 VSS 0.13586f
C393 outn.n10 VSS 0.29904f
C394 outn.n11 VSS 0.03979f
C395 outn.n12 VSS 0.0272f
C396 outn.n13 VSS 0.01573f
C397 outn.n14 VSS 0.0384f
C398 outn.n15 VSS 0.18497f
C399 outn.n16 VSS 2.16807f
C400 outn.n17 VSS 0.70567f
C401 outn.n18 VSS 4.22396f
C402 outn.n19 VSS 1.79341f
C403 inp.t3 VSS 0.1108f
C404 inp.t0 VSS 0.12031f
C405 inp.t1 VSS 0.1108f
C406 inp.n0 VSS 0.26684f
C407 inp.t2 VSS 0.1203f
C408 inp.n1 VSS 0.13319f
C409 inp.n2 VSS 0.15074f
C410 nb.t6 VSS 0.14858f
C411 nb.t7 VSS 0.12964f
C412 nb.n0 VSS 0.19996f
C413 nb.t8 VSS 0.14855f
C414 nb.n1 VSS 0.11642f
C415 nb.t9 VSS 0.12964f
C416 nb.n2 VSS 0.10239f
C417 nb.t10 VSS 0.14855f
C418 nb.n3 VSS 0.11642f
C419 nb.t11 VSS 0.12964f
C420 nb.n4 VSS 0.18477f
C421 nb.t0 VSS 0.14858f
C422 nb.t1 VSS 0.12964f
C423 nb.n5 VSS 0.19996f
C424 nb.t2 VSS 0.14855f
C425 nb.n6 VSS 0.11642f
C426 nb.t3 VSS 0.12964f
C427 nb.n7 VSS 0.10239f
C428 nb.t4 VSS 0.14855f
C429 nb.n8 VSS 0.11642f
C430 nb.t5 VSS 0.12964f
C431 nb.n9 VSS 0.18476f
C432 nb.n10 VSS 0.46843f
C433 inn.t3 VSS 0.11073f
C434 inn.t0 VSS 0.12022f
C435 inn.t1 VSS 0.11073f
C436 inn.n0 VSS 0.26665f
C437 inn.t2 VSS 0.12022f
C438 inn.n1 VSS 0.1331f
C439 inn.n2 VSS 0.15064f
C440 lna_lo_n.n0 VSS 0.01547f
C441 lna_lo_n.n1 VSS 0.01361f
C442 lna_lo_n.n2 VSS 0.03021f
C443 lna_lo_n.n3 VSS 0.0134f
C444 lna_lo_n.n4 VSS 0.02222f
C445 lna_lo_n.n5 VSS 0.0268f
C446 lna_lo_n.t0 VSS 0.00726f
C447 lna_lo_n.n6 VSS 0.02898f
C448 lna_lo_n.n7 VSS 0.0268f
C449 lna_lo_n.n8 VSS 0.0134f
C450 lna_lo_n.n9 VSS 0.01991f
C451 lna_lo_n.n10 VSS 0.01991f
C452 lna_lo_n.n11 VSS 0.08669f
C453 lna_lo_n.n12 VSS 0.02829f
C454 lna_lo_n.n13 VSS 0.02028f
C455 lna_lo_n.n14 VSS 0.0268f
C456 lna_lo_n.n15 VSS 0.05341f
C457 lna_lo_n.n16 VSS 0.05033f
C458 lna_lo_n.n17 VSS 0.16607f
.ends
