* amp_dp: magic R+C extraction of layout/amp_dp.gds (layout/pex.sh)
.subckt amp_dp inp inn nb outp outn VDD VSS
X0 outn.t5 inp.t9 tail VSS.t86 sky130_fd_pr__nfet_01v8 ad=0.75 pd=5.3 as=0.7375 ps=5.295 w=5 l=0.15
X1 outn.t9 inp.t5 tail VSS.t90 sky130_fd_pr__nfet_01v8 ad=0.75 pd=5.3 as=0.75 ps=5.3 w=5 l=0.15
X2 tail nb.t29 VSS.t21 VSS.t20 sky130_fd_pr__nfet_01v8 ad=0.45 pd=3.3 as=0.45 ps=3.3 w=3 l=0.5
X3 VSS.t75 nb.t2 tail VSS.t74 sky130_fd_pr__nfet_01v8 ad=0.45 pd=3.3 as=0.45 ps=3.3 w=3 l=0.5
X4 tail nb.t19 VSS.t41 VSS.t40 sky130_fd_pr__nfet_01v8 ad=0.45 pd=3.3 as=0.9 ps=6.6 w=3 l=0.5
X5 tail nb.t21 VSS.t37 VSS.t36 sky130_fd_pr__nfet_01v8 ad=0.45 pd=3.3 as=0.45 ps=3.3 w=3 l=0.5
X6 VSS.t3 nb.t38 tail VSS.t2 sky130_fd_pr__nfet_01v8 ad=0.45 pd=3.3 as=0.45 ps=3.3 w=3 l=0.5
X7 VSS.t23 nb.t28 tail VSS.t22 sky130_fd_pr__nfet_01v8 ad=0.45 pd=3.3 as=0.45 ps=3.3 w=3 l=0.5
X8 VSS.t71 nb.t4 tail VSS.t70 sky130_fd_pr__nfet_01v8 ad=0.45 pd=3.3 as=0.45 ps=3.3 w=3 l=0.5
X9 tail nb.t1 VSS.t77 VSS.t76 sky130_fd_pr__nfet_01v8 ad=0.45 pd=3.3 as=0.45 ps=3.3 w=3 l=0.5
X10 tail nb.t11 VSS.t57 VSS.t56 sky130_fd_pr__nfet_01v8 ad=0.45 pd=3.3 as=0.45 ps=3.3 w=3 l=0.5
X11 VSS.t63 nb.t8 tail VSS.t62 sky130_fd_pr__nfet_01v8 ad=0.45 pd=3.3 as=0.45 ps=3.3 w=3 l=0.5
X12 outp.t13 inn.t11 tail VSS.t102 sky130_fd_pr__nfet_01v8 ad=0.75 pd=5.3 as=0.75 ps=5.3 w=5 l=0.15
X13 tail nb.t37 VSS.t5 VSS.t4 sky130_fd_pr__nfet_01v8 ad=0.45 pd=3.3 as=0.45 ps=3.3 w=3 l=0.5
X14 VSS.t39 nb.t20 tail VSS.t38 sky130_fd_pr__nfet_01v8 ad=0.9 pd=6.6 as=0.45 ps=3.3 w=3 l=0.5
X15 tail nb.t15 VSS.t49 VSS.t48 sky130_fd_pr__nfet_01v8 ad=0.45 pd=3.3 as=0.45 ps=3.3 w=3 l=0.5
X16 VSS.t55 nb.t12 tail VSS.t54 sky130_fd_pr__nfet_01v8 ad=0.45 pd=3.3 as=0.45 ps=3.3 w=3 l=0.5
X17 tail inp.t8 outn.t7 VSS.t87 sky130_fd_pr__nfet_01v8 ad=1.525 pd=10.61 as=0.75 ps=5.3 w=5 l=0.15
X18 tail inn.t10 outp.t5 VSS.t103 sky130_fd_pr__nfet_01v8 ad=0.7375 pd=5.295 as=0.75 ps=5.3 w=5 l=0.15
X19 tail inn.t4 outp.t11 VSS.t109 sky130_fd_pr__nfet_01v8 ad=0.75 pd=5.3 as=0.75 ps=5.3 w=5 l=0.15
X20 tail nb.t27 VSS.t25 VSS.t24 sky130_fd_pr__nfet_01v8 ad=0.45 pd=3.3 as=0.45 ps=3.3 w=3 l=0.5
X21 outn.t14 inp.t15 tail VSS.t80 sky130_fd_pr__nfet_01v8 ad=0.75 pd=5.3 as=1.5 ps=10.6 w=5 l=0.15
X22 outp.t9 inn.t3 tail VSS.t110 sky130_fd_pr__nfet_01v8 ad=0.75 pd=5.3 as=0.75 ps=5.3 w=5 l=0.15
X23 VSS.t31 nb.t24 tail VSS.t30 sky130_fd_pr__nfet_01v8 ad=0.45 pd=3.3 as=0.45 ps=3.3 w=3 l=0.5
X24 tail inp.t14 outn.t15 VSS.t81 sky130_fd_pr__nfet_01v8 ad=0.75 pd=5.3 as=0.75 ps=5.3 w=5 l=0.15
X25 outp.t4 inn.t9 tail VSS.t104 sky130_fd_pr__nfet_01v8 ad=0.75 pd=5.3 as=0.7375 ps=5.295 w=5 l=0.15
X26 VSS.t11 nb.t34 tail VSS.t10 sky130_fd_pr__nfet_01v8 ad=0.45 pd=3.3 as=0.45 ps=3.3 w=3 l=0.5
X27 tail inn.t8 outp.t7 VSS.t105 sky130_fd_pr__nfet_01v8 ad=1.525 pd=10.61 as=0.75 ps=5.3 w=5 l=0.15
X28 tail inn.t2 outp.t3 VSS.t111 sky130_fd_pr__nfet_01v8 ad=0.7375 pd=5.295 as=0.75 ps=5.3 w=5 l=0.15
X29 tail inp.t4 outn.t0 VSS.t91 sky130_fd_pr__nfet_01v8 ad=0.75 pd=5.3 as=0.75 ps=5.3 w=5 l=0.15
X30 tail nb.t31 VSS.t17 VSS.t16 sky130_fd_pr__nfet_01v8 ad=0.45 pd=3.3 as=0.45 ps=3.3 w=3 l=0.5
X31 outp.t0 inn.t15 tail VSS.t98 sky130_fd_pr__nfet_01v8 ad=0.75 pd=5.3 as=1.5 ps=10.6 w=5 l=0.15
X32 VSS.t51 nb.t14 tail VSS.t50 sky130_fd_pr__nfet_01v8 ad=0.45 pd=3.3 as=0.45 ps=3.3 w=3 l=0.5
X33 outp.t14 inn.t1 tail VSS.t112 sky130_fd_pr__nfet_01v8 ad=0.75 pd=5.3 as=0.7375 ps=5.295 w=5 l=0.15
X34 outn.t1 inp.t3 tail VSS.t92 sky130_fd_pr__nfet_01v8 ad=0.75 pd=5.3 as=0.75 ps=5.3 w=5 l=0.15
X35 tail inn.t14 outp.t10 VSS.t99 sky130_fd_pr__nfet_01v8 ad=0.75 pd=5.3 as=0.75 ps=5.3 w=5 l=0.15
X36 VSS.t43 nb.t18 tail VSS.t42 sky130_fd_pr__nfet_01v8 ad=0.45 pd=3.3 as=0.45 ps=3.3 w=3 l=0.5
X37 tail inn.t0 outp.t6 VSS.t113 sky130_fd_pr__nfet_01v8 ad=1.525 pd=10.61 as=0.75 ps=5.3 w=5 l=0.15
X38 tail inp.t2 outn.t12 VSS.t93 sky130_fd_pr__nfet_01v8 ad=0.7375 pd=5.295 as=0.75 ps=5.3 w=5 l=0.15
X39 VSS.t19 nb.t30 tail VSS.t18 sky130_fd_pr__nfet_01v8 ad=0.45 pd=3.3 as=0.45 ps=3.3 w=3 l=0.5
X40 tail nb.t3 VSS.t73 VSS.t72 sky130_fd_pr__nfet_01v8 ad=0.45 pd=3.3 as=0.45 ps=3.3 w=3 l=0.5
X41 VSS.t79 nb.t0 tail VSS.t78 sky130_fd_pr__nfet_01v8 ad=0.9 pd=6.6 as=0.45 ps=3.3 w=3 l=0.5
X42 VDD.t0 outp.t16 VSS.t96 sky130_fd_pr__res_high_po_1p41 l=3.14
X43 VSS.t59 nb.t10 tail VSS.t58 sky130_fd_pr__nfet_01v8 ad=0.45 pd=3.3 as=0.45 ps=3.3 w=3 l=0.5
X44 tail nb.t7 VSS.t65 VSS.t64 sky130_fd_pr__nfet_01v8 ad=0.45 pd=3.3 as=0.45 ps=3.3 w=3 l=0.5
X45 tail nb.t39 VSS.t1 VSS.t0 sky130_fd_pr__nfet_01v8 ad=0.45 pd=3.3 as=0.9 ps=6.6 w=3 l=0.5
X46 VSS.t35 nb.t22 tail VSS.t34 sky130_fd_pr__nfet_01v8 ad=0.45 pd=3.3 as=0.45 ps=3.3 w=3 l=0.5
X47 tail nb.t17 VSS.t45 VSS.t44 sky130_fd_pr__nfet_01v8 ad=0.45 pd=3.3 as=0.45 ps=3.3 w=3 l=0.5
X48 VSS.t7 nb.t36 tail VSS.t6 sky130_fd_pr__nfet_01v8 ad=0.45 pd=3.3 as=0.45 ps=3.3 w=3 l=0.5
X49 VDD.t1 outn.t16 VSS.t97 sky130_fd_pr__res_high_po_1p41 l=3.14
X50 VSS.t27 nb.t26 tail VSS.t26 sky130_fd_pr__nfet_01v8 ad=0.45 pd=3.3 as=0.45 ps=3.3 w=3 l=0.5
X51 outn.t2 inp.t13 tail VSS.t82 sky130_fd_pr__nfet_01v8 ad=0.75 pd=5.3 as=0.75 ps=5.3 w=5 l=0.15
X52 outp.t12 inn.t7 tail VSS.t106 sky130_fd_pr__nfet_01v8 ad=0.75 pd=5.3 as=1.5 ps=10.6 w=5 l=0.15
X53 tail nb.t23 VSS.t33 VSS.t32 sky130_fd_pr__nfet_01v8 ad=0.45 pd=3.3 as=0.45 ps=3.3 w=3 l=0.5
X54 tail nb.t9 VSS.t61 VSS.t60 sky130_fd_pr__nfet_01v8 ad=0.45 pd=3.3 as=0.45 ps=3.3 w=3 l=0.5
X55 outn.t6 inp.t1 tail VSS.t94 sky130_fd_pr__nfet_01v8 ad=0.75 pd=5.3 as=0.7375 ps=5.295 w=5 l=0.15
X56 tail nb.t33 VSS.t13 VSS.t12 sky130_fd_pr__nfet_01v8 ad=0.45 pd=3.3 as=0.45 ps=3.3 w=3 l=0.5
X57 VSS.t67 nb.t6 tail VSS.t66 sky130_fd_pr__nfet_01v8 ad=0.45 pd=3.3 as=0.45 ps=3.3 w=3 l=0.5
X58 tail inp.t12 outn.t8 VSS.t83 sky130_fd_pr__nfet_01v8 ad=0.75 pd=5.3 as=0.75 ps=5.3 w=5 l=0.15
X59 tail inn.t6 outp.t2 VSS.t107 sky130_fd_pr__nfet_01v8 ad=0.75 pd=5.3 as=0.75 ps=5.3 w=5 l=0.15
X60 VSS.t47 nb.t16 tail VSS.t46 sky130_fd_pr__nfet_01v8 ad=0.45 pd=3.3 as=0.45 ps=3.3 w=3 l=0.5
X61 tail nb.t13 VSS.t53 VSS.t52 sky130_fd_pr__nfet_01v8 ad=0.45 pd=3.3 as=0.45 ps=3.3 w=3 l=0.5
X62 outp.t1 inn.t13 tail VSS.t100 sky130_fd_pr__nfet_01v8 ad=0.75 pd=5.3 as=0.75 ps=5.3 w=5 l=0.15
X63 tail inp.t0 outn.t4 VSS.t95 sky130_fd_pr__nfet_01v8 ad=1.525 pd=10.61 as=0.75 ps=5.3 w=5 l=0.15
X64 tail nb.t35 VSS.t9 VSS.t8 sky130_fd_pr__nfet_01v8 ad=0.45 pd=3.3 as=0.45 ps=3.3 w=3 l=0.5
X65 outn.t3 inp.t11 tail VSS.t84 sky130_fd_pr__nfet_01v8 ad=0.75 pd=5.3 as=0.75 ps=5.3 w=5 l=0.15
X66 outp.t15 inn.t5 tail VSS.t108 sky130_fd_pr__nfet_01v8 ad=0.75 pd=5.3 as=0.75 ps=5.3 w=5 l=0.15
X67 outn.t13 inp.t7 tail VSS.t88 sky130_fd_pr__nfet_01v8 ad=0.75 pd=5.3 as=1.5 ps=10.6 w=5 l=0.15
X68 tail nb.t25 VSS.t29 VSS.t28 sky130_fd_pr__nfet_01v8 ad=0.45 pd=3.3 as=0.45 ps=3.3 w=3 l=0.5
X69 tail inp.t10 outn.t10 VSS.t85 sky130_fd_pr__nfet_01v8 ad=0.7375 pd=5.295 as=0.75 ps=5.3 w=5 l=0.15
X70 tail inn.t12 outp.t8 VSS.t101 sky130_fd_pr__nfet_01v8 ad=0.75 pd=5.3 as=0.75 ps=5.3 w=5 l=0.15
X71 tail inp.t6 outn.t11 VSS.t89 sky130_fd_pr__nfet_01v8 ad=0.75 pd=5.3 as=0.75 ps=5.3 w=5 l=0.15
X72 VSS.t15 nb.t32 tail VSS.t14 sky130_fd_pr__nfet_01v8 ad=0.45 pd=3.3 as=0.45 ps=3.3 w=3 l=0.5
X73 tail nb.t5 VSS.t69 VSS.t68 sky130_fd_pr__nfet_01v8 ad=0.45 pd=3.3 as=0.45 ps=3.3 w=3 l=0.5
R0 nb.n0 nb.t0 408.575
R1 nb.n38 nb.t38 408.567
R2 nb.n36 nb.t36 408.567
R3 nb.n34 nb.t34 408.567
R4 nb.n32 nb.t32 408.567
R5 nb.n30 nb.t30 408.567
R6 nb.n28 nb.t28 408.567
R7 nb.n26 nb.t26 408.567
R8 nb.n24 nb.t24 408.567
R9 nb.n22 nb.t22 408.567
R10 nb.n20 nb.t20 408.567
R11 nb.n18 nb.t18 408.567
R12 nb.n16 nb.t16 408.567
R13 nb.n14 nb.t14 408.567
R14 nb.n12 nb.t12 408.567
R15 nb.n10 nb.t10 408.567
R16 nb.n8 nb.t8 408.567
R17 nb.n6 nb.t6 408.567
R18 nb.n4 nb.t4 408.567
R19 nb.n2 nb.t2 408.567
R20 nb.n39 nb.t39 341.096
R21 nb.n37 nb.t37 341.087
R22 nb.n35 nb.t35 341.087
R23 nb.n33 nb.t33 341.087
R24 nb.n31 nb.t31 341.087
R25 nb.n29 nb.t29 341.087
R26 nb.n27 nb.t27 341.087
R27 nb.n25 nb.t25 341.087
R28 nb.n23 nb.t23 341.087
R29 nb.n21 nb.t21 341.087
R30 nb.n19 nb.t19 341.087
R31 nb.n17 nb.t17 341.087
R32 nb.n15 nb.t15 341.087
R33 nb.n13 nb.t13 341.087
R34 nb.n11 nb.t11 341.087
R35 nb.n9 nb.t9 341.087
R36 nb.n7 nb.t7 341.087
R37 nb.n5 nb.t5 341.087
R38 nb.n3 nb.t3 341.087
R39 nb.n1 nb.t1 341.087
R40 nb nb.n39 1.77805
R41 nb.n0 nb 1.71085
R42 nb.n20 nb.n19 0.269317
R43 nb.n2 nb.n1 0.108027
R44 nb.n3 nb.n2 0.108027
R45 nb.n4 nb.n3 0.108027
R46 nb.n5 nb.n4 0.108027
R47 nb.n6 nb.n5 0.108027
R48 nb.n7 nb.n6 0.108027
R49 nb.n8 nb.n7 0.108027
R50 nb.n9 nb.n8 0.108027
R51 nb.n10 nb.n9 0.108027
R52 nb.n11 nb.n10 0.108027
R53 nb.n12 nb.n11 0.108027
R54 nb.n13 nb.n12 0.108027
R55 nb.n14 nb.n13 0.108027
R56 nb.n15 nb.n14 0.108027
R57 nb.n16 nb.n15 0.108027
R58 nb.n17 nb.n16 0.108027
R59 nb.n18 nb.n17 0.108027
R60 nb.n19 nb.n18 0.108027
R61 nb.n21 nb.n20 0.108027
R62 nb.n22 nb.n21 0.108027
R63 nb.n23 nb.n22 0.108027
R64 nb.n24 nb.n23 0.108027
R65 nb.n25 nb.n24 0.108027
R66 nb.n26 nb.n25 0.108027
R67 nb.n27 nb.n26 0.108027
R68 nb.n28 nb.n27 0.108027
R69 nb.n29 nb.n28 0.108027
R70 nb.n30 nb.n29 0.108027
R71 nb.n31 nb.n30 0.108027
R72 nb.n32 nb.n31 0.108027
R73 nb.n33 nb.n32 0.108027
R74 nb.n34 nb.n33 0.108027
R75 nb.n35 nb.n34 0.108027
R76 nb.n36 nb.n35 0.108027
R77 nb.n37 nb.n36 0.108027
R78 nb.n38 nb.n37 0.108027
R79 nb.n1 nb.n0 0.0992903
R80 nb.n39 nb.n38 0.0992903
R81 outp.n2 outp.n0 19.8788
R82 outp.n2 outp.n1 19.6916
R83 outp.n4 outp.n3 19.6916
R84 outp.n6 outp.n5 19.6916
R85 outp.n8 outp.n7 19.6916
R86 outp.n10 outp.n9 19.6916
R87 outp.n12 outp.n11 19.6916
R88 outp.n14 outp.n13 19.6916
R89 outp.n3 outp.t5 3.7205
R90 outp.n11 outp.t3 3.7205
R91 outp.n0 outp.t10 3.6005
R92 outp.n0 outp.t0 3.6005
R93 outp.n1 outp.t8 3.6005
R94 outp.n1 outp.t1 3.6005
R95 outp.n5 outp.t7 3.6005
R96 outp.n5 outp.t4 3.6005
R97 outp.n7 outp.t2 3.6005
R98 outp.n7 outp.t12 3.6005
R99 outp.n9 outp.t11 3.6005
R100 outp.n9 outp.t15 3.6005
R101 outp.n13 outp.t6 3.6005
R102 outp.n13 outp.t14 3.6005
R103 outp.n3 outp.t13 3.4805
R104 outp.n11 outp.t9 3.4805
R105 outp.n15 outp.n14 1.55879
R106 outp outp.n15 1.46167
R107 outp.n15 outp.t16 1.01967
R108 outp.n8 outp.n6 0.439042
R109 outp.n14 outp.n12 0.188
R110 outp.n10 outp.n8 0.188
R111 outp.n6 outp.n4 0.188
R112 outp.n12 outp.n10 0.186958
R113 outp.n4 outp.n2 0.186958
R114 outn.n1 outn.n0 19.6622
R115 outn.n3 outn.n2 19.6622
R116 outn.n5 outn.n4 19.6622
R117 outn.n7 outn.n6 19.6622
R118 outn.n9 outn.n8 19.6622
R119 outn.n11 outn.n10 19.6622
R120 outn.n13 outn.n12 19.6622
R121 outn.n15 outn.n14 19.6622
R122 outn.n4 outn.t10 3.7205
R123 outn.n12 outn.t12 3.7205
R124 outn.n0 outn.t15 3.6005
R125 outn.n0 outn.t14 3.6005
R126 outn.n2 outn.t8 3.6005
R127 outn.n2 outn.t2 3.6005
R128 outn.n6 outn.t7 3.6005
R129 outn.n6 outn.t5 3.6005
R130 outn.n8 outn.t11 3.6005
R131 outn.n8 outn.t13 3.6005
R132 outn.n10 outn.t0 3.6005
R133 outn.n10 outn.t9 3.6005
R134 outn.n14 outn.t4 3.6005
R135 outn.n14 outn.t6 3.6005
R136 outn.n4 outn.t3 3.4805
R137 outn.n12 outn.t1 3.4805
R138 outn.n9 outn.n7 2.43904
R139 outn outn.n15 1.79975
R140 outn.n1 outn.t16 1.73113
R141 outn.n15 outn.n13 0.188
R142 outn.n11 outn.n9 0.188
R143 outn.n7 outn.n5 0.188
R144 outn.n3 outn.n1 0.188
R145 outn.n13 outn.n11 0.186958
R146 outn.n5 outn.n3 0.186958
R147 inn.n0 inn.t0 1283.35
R148 inn.n7 inn.t14 1283.29
R149 inn.n9 inn.t12 1283.29
R150 inn.n11 inn.t10 1283.29
R151 inn.n13 inn.t8 1283.29
R152 inn.n5 inn.t6 1283.29
R153 inn.n3 inn.t4 1283.29
R154 inn.n1 inn.t2 1283.29
R155 inn.n7 inn.t15 1058.42
R156 inn.n8 inn.t13 1058.36
R157 inn.n10 inn.t11 1058.36
R158 inn.n12 inn.t9 1058.36
R159 inn.n6 inn.t7 1058.36
R160 inn.n4 inn.t5 1058.36
R161 inn.n2 inn.t3 1058.36
R162 inn.n0 inn.t1 1058.36
R163 inn inn.n14 5.82434
R164 inn.n14 inn.n6 0.112059
R165 inn.n14 inn.n13 0.111387
R166 inn.n2 inn.n1 0.0609839
R167 inn.n3 inn.n2 0.0609839
R168 inn.n4 inn.n3 0.0609839
R169 inn.n5 inn.n4 0.0609839
R170 inn.n6 inn.n5 0.0609839
R171 inn.n13 inn.n12 0.0609839
R172 inn.n11 inn.n10 0.0609839
R173 inn.n10 inn.n9 0.0609839
R174 inn.n9 inn.n8 0.0609839
R175 inn.n8 inn.n7 0.0609839
R176 inn.n1 inn.n0 0.0603118
R177 inn.n12 inn.n11 0.0603118
R178 inp.n7 inp.t8 1283.35
R179 inp.n0 inp.t0 1283.35
R180 inp.n10 inp.t14 1283.29
R181 inp.n12 inp.t12 1283.29
R182 inp.n8 inp.t10 1283.29
R183 inp.n3 inp.t6 1283.29
R184 inp.n5 inp.t4 1283.29
R185 inp.n1 inp.t2 1283.29
R186 inp.n10 inp.t15 1058.42
R187 inp.n3 inp.t7 1058.42
R188 inp.n11 inp.t13 1058.36
R189 inp.n9 inp.t11 1058.36
R190 inp.n7 inp.t9 1058.36
R191 inp.n4 inp.t5 1058.36
R192 inp.n2 inp.t3 1058.36
R193 inp.n0 inp.t1 1058.36
R194 inp.n14 inp.n6 6.03507
R195 inp inp.n14 4.4445
R196 inp.n14 inp.n13 2.43507
R197 inp.n2 inp.n1 0.0609839
R198 inp.n5 inp.n4 0.0609839
R199 inp.n4 inp.n3 0.0609839
R200 inp.n9 inp.n8 0.0609839
R201 inp.n12 inp.n11 0.0609839
R202 inp.n11 inp.n10 0.0609839
R203 inp.n1 inp.n0 0.0603118
R204 inp.n8 inp.n7 0.0603118
R205 inp.n6 inp.n2 0.0307419
R206 inp.n6 inp.n5 0.0307419
R207 inp.n13 inp.n9 0.0307419
R208 inp inp.n12 0.0300699
R209 inp.n13 inp 0.00117204
R210 VDD.n0 VDD.t1 2.49453
R211 VDD.n0 VDD.t0 2.49453
R212 VDD VDD.n0 1.52712
R213 VSS.n484 VSS.n483 585
R214 VSS.n483 VSS.n482 585
R215 VSS.n330 VSS.n329 585
R216 VSS.n329 VSS.n328 585
R217 VSS.n489 VSS.n488 585
R218 VSS.t78 VSS.n489 585
R219 VSS.n321 VSS.n320 585
R220 VSS.n322 VSS.n321 585
R221 VSS.n500 VSS.n499 585
R222 VSS.n499 VSS.n498 585
R223 VSS.n318 VSS.n317 585
R224 VSS.n317 VSS.n316 585
R225 VSS.n505 VSS.n504 585
R226 VSS.n506 VSS.n505 585
R227 VSS.n308 VSS.n307 585
R228 VSS.n309 VSS.n308 585
R229 VSS.n517 VSS.n516 585
R230 VSS.n516 VSS.n515 585
R231 VSS.n305 VSS.n304 585
R232 VSS.n304 VSS.n303 585
R233 VSS.n522 VSS.n521 585
R234 VSS.n523 VSS.n522 585
R235 VSS.n295 VSS.n294 585
R236 VSS.n296 VSS.n295 585
R237 VSS.n534 VSS.n533 585
R238 VSS.n533 VSS.n532 585
R239 VSS.n292 VSS.n291 585
R240 VSS.n531 VSS.n291 585
R241 VSS.n539 VSS.n538 585
R242 VSS.n540 VSS.n539 585
R243 VSS.n283 VSS.n282 585
R244 VSS.n290 VSS.n283 585
R245 VSS.n552 VSS.n551 585
R246 VSS.n551 VSS.n550 585
R247 VSS.n280 VSS.n279 585
R248 VSS.n549 VSS.n279 585
R249 VSS.n557 VSS.n556 585
R250 VSS.n558 VSS.n557 585
R251 VSS.n271 VSS.n270 585
R252 VSS.n278 VSS.n271 585
R253 VSS.n569 VSS.n568 585
R254 VSS.n568 VSS.n567 585
R255 VSS.n268 VSS.n267 585
R256 VSS.n267 VSS.n265 585
R257 VSS.n574 VSS.n573 585
R258 VSS.t60 VSS.n574 585
R259 VSS.n258 VSS.n257 585
R260 VSS.n266 VSS.n258 585
R261 VSS.n586 VSS.n585 585
R262 VSS.n585 VSS.n584 585
R263 VSS.n255 VSS.n254 585
R264 VSS.n583 VSS.n254 585
R265 VSS.n591 VSS.n590 585
R266 VSS.n592 VSS.n591 585
R267 VSS.n246 VSS.n245 585
R268 VSS.n253 VSS.n246 585
R269 VSS.n603 VSS.n602 585
R270 VSS.n602 VSS.n601 585
R271 VSS.n243 VSS.n242 585
R272 VSS.n242 VSS.n240 585
R273 VSS.n608 VSS.n607 585
R274 VSS.n609 VSS.n608 585
R275 VSS.n233 VSS.n232 585
R276 VSS.n241 VSS.n233 585
R277 VSS.n620 VSS.n619 585
R278 VSS.n619 VSS.n618 585
R279 VSS.n230 VSS.n229 585
R280 VSS.n617 VSS.n229 585
R281 VSS.n625 VSS.n624 585
R282 VSS.n626 VSS.n625 585
R283 VSS.n222 VSS.n221 585
R284 VSS.n228 VSS.n222 585
R285 VSS.n639 VSS.n638 585
R286 VSS.n638 VSS.n637 585
R287 VSS.n219 VSS.n218 585
R288 VSS.n636 VSS.n218 585
R289 VSS.n644 VSS.n643 585
R290 VSS.n645 VSS.n644 585
R291 VSS.n211 VSS.n210 585
R292 VSS.n217 VSS.n211 585
R293 VSS.n657 VSS.n656 585
R294 VSS.n656 VSS.n655 585
R295 VSS.n208 VSS.n207 585
R296 VSS.n207 VSS.n205 585
R297 VSS.n662 VSS.n661 585
R298 VSS.t42 VSS.n662 585
R299 VSS.n199 VSS.n198 585
R300 VSS.n206 VSS.n199 585
R301 VSS.n673 VSS.n672 585
R302 VSS.n672 VSS.n671 585
R303 VSS.n196 VSS.n195 585
R304 VSS.n195 VSS.n194 585
R305 VSS.n678 VSS.n677 585
R306 VSS.n679 VSS.n678 585
R307 VSS.n177 VSS.n176 585
R308 VSS.n178 VSS.n177 585
R309 VSS.n701 VSS.n700 585
R310 VSS.n700 VSS.n699 585
R311 VSS.n174 VSS.n173 585
R312 VSS.n698 VSS.n173 585
R313 VSS.n706 VSS.n705 585
R314 VSS.n707 VSS.n706 585
R315 VSS.n165 VSS.n164 585
R316 VSS.n172 VSS.n165 585
R317 VSS.n717 VSS.n716 585
R318 VSS.n716 VSS.t36 585
R319 VSS.n162 VSS.n161 585
R320 VSS.n166 VSS.n161 585
R321 VSS.n722 VSS.n721 585
R322 VSS.n723 VSS.n722 585
R323 VSS.n153 VSS.n152 585
R324 VSS.n160 VSS.n153 585
R325 VSS.n734 VSS.n733 585
R326 VSS.n733 VSS.n732 585
R327 VSS.n150 VSS.n149 585
R328 VSS.n149 VSS.n148 585
R329 VSS.n739 VSS.n738 585
R330 VSS.n740 VSS.n739 585
R331 VSS.n140 VSS.n139 585
R332 VSS.n141 VSS.n140 585
R333 VSS.n750 VSS.n749 585
R334 VSS.n749 VSS.n748 585
R335 VSS.n137 VSS.n136 585
R336 VSS.n136 VSS.n134 585
R337 VSS.n755 VSS.n754 585
R338 VSS.n756 VSS.n755 585
R339 VSS.n127 VSS.n126 585
R340 VSS.n135 VSS.n127 585
R341 VSS.n767 VSS.n766 585
R342 VSS.n766 VSS.n765 585
R343 VSS.n124 VSS.n123 585
R344 VSS.n764 VSS.n123 585
R345 VSS.n772 VSS.n771 585
R346 VSS.n773 VSS.n772 585
R347 VSS.n115 VSS.n114 585
R348 VSS.n122 VSS.n115 585
R349 VSS.n785 VSS.n784 585
R350 VSS.n784 VSS.n783 585
R351 VSS.n112 VSS.n111 585
R352 VSS.n782 VSS.n111 585
R353 VSS.n790 VSS.n789 585
R354 VSS.n791 VSS.n790 585
R355 VSS.n103 VSS.n102 585
R356 VSS.n110 VSS.n103 585
R357 VSS.n801 VSS.n800 585
R358 VSS.n800 VSS.t18 585
R359 VSS.n100 VSS.n99 585
R360 VSS.n99 VSS.n98 585
R361 VSS.n806 VSS.n805 585
R362 VSS.n807 VSS.n806 585
R363 VSS.n90 VSS.n89 585
R364 VSS.n91 VSS.n90 585
R365 VSS.n818 VSS.n817 585
R366 VSS.n817 VSS.n816 585
R367 VSS.n87 VSS.n86 585
R368 VSS.n86 VSS.n84 585
R369 VSS.n823 VSS.n822 585
R370 VSS.n824 VSS.n823 585
R371 VSS.n77 VSS.n76 585
R372 VSS.n85 VSS.n77 585
R373 VSS.n835 VSS.n834 585
R374 VSS.n834 VSS.n833 585
R375 VSS.n74 VSS.n73 585
R376 VSS.n73 VSS.n71 585
R377 VSS.n840 VSS.n839 585
R378 VSS.n841 VSS.n840 585
R379 VSS.n65 VSS.n64 585
R380 VSS.n72 VSS.n65 585
R381 VSS.n854 VSS.n853 585
R382 VSS.n853 VSS.n852 585
R383 VSS.n62 VSS.n61 585
R384 VSS.n851 VSS.n61 585
R385 VSS.n859 VSS.n858 585
R386 VSS.n860 VSS.n859 585
R387 VSS.n54 VSS.n53 585
R388 VSS.n60 VSS.n54 585
R389 VSS.n873 VSS.n872 585
R390 VSS.n872 VSS.n871 585
R391 VSS.n50 VSS.n48 585
R392 VSS.n870 VSS.n48 585
R393 VSS.n879 VSS.n878 585
R394 VSS.n880 VSS.n879 585
R395 VSS.n51 VSS.n49 585
R396 VSS.n49 VSS.n47 585
R397 VSS.n41 VSS.n40 585
R398 VSS.t0 VSS.n41 585
R399 VSS.n892 VSS.n891 585
R400 VSS.n891 VSS.n890 585
R401 VSS.n37 VSS.n35 585
R402 VSS.n35 VSS.n16 585
R403 VSS.n1008 VSS.n1007 585
R404 VSS.n15 VSS.n14 585
R405 VSS.n949 VSS.n946 585
R406 VSS.n950 VSS.n945 585
R407 VSS.n951 VSS.n944 585
R408 VSS.n942 VSS.n941 585
R409 VSS.n955 VSS.n940 585
R410 VSS.n956 VSS.n939 585
R411 VSS.n957 VSS.n938 585
R412 VSS.n936 VSS.n935 585
R413 VSS.n961 VSS.n934 585
R414 VSS.n962 VSS.n933 585
R415 VSS.n963 VSS.n932 585
R416 VSS.n930 VSS.n929 585
R417 VSS.n967 VSS.n928 585
R418 VSS.n968 VSS.n927 585
R419 VSS.n969 VSS.n926 585
R420 VSS.n924 VSS.n923 585
R421 VSS.n973 VSS.n922 585
R422 VSS.n974 VSS.n921 585
R423 VSS.n975 VSS.n920 585
R424 VSS.n918 VSS.n917 585
R425 VSS.n979 VSS.n916 585
R426 VSS.n980 VSS.n915 585
R427 VSS.n981 VSS.n914 585
R428 VSS.n912 VSS.n911 585
R429 VSS.n985 VSS.n910 585
R430 VSS.n986 VSS.n909 585
R431 VSS.n987 VSS.n908 585
R432 VSS.n906 VSS.n905 585
R433 VSS.n991 VSS.n904 585
R434 VSS.n992 VSS.n903 585
R435 VSS.n993 VSS.n902 585
R436 VSS.n900 VSS.n899 585
R437 VSS.n997 VSS.n898 585
R438 VSS.n998 VSS.n897 585
R439 VSS.n999 VSS.n896 585
R440 VSS.n38 VSS.n36 585
R441 VSS.n1004 VSS.n1003 585
R442 VSS.n1005 VSS.n1004 585
R443 VSS.n1009 VSS.n13 585
R444 VSS.n16 VSS.n13 585
R445 VSS.n889 VSS.n12 585
R446 VSS.n890 VSS.n889 585
R447 VSS.n888 VSS.n887 585
R448 VSS.n888 VSS.t0 585
R449 VSS.n43 VSS.n42 585
R450 VSS.n47 VSS.n42 585
R451 VSS.n882 VSS.n881 585
R452 VSS.n881 VSS.n880 585
R453 VSS.n46 VSS.n45 585
R454 VSS.n870 VSS.n46 585
R455 VSS.n869 VSS.n868 585
R456 VSS.n871 VSS.n869 585
R457 VSS.n56 VSS.n55 585
R458 VSS.n60 VSS.n55 585
R459 VSS.n862 VSS.n861 585
R460 VSS.n861 VSS.n860 585
R461 VSS.n59 VSS.n58 585
R462 VSS.n851 VSS.n59 585
R463 VSS.n850 VSS.n849 585
R464 VSS.n852 VSS.n850 585
R465 VSS.n67 VSS.n66 585
R466 VSS.n72 VSS.n66 585
R467 VSS.n843 VSS.n842 585
R468 VSS.n842 VSS.n841 585
R469 VSS.n70 VSS.n69 585
R470 VSS.n71 VSS.n70 585
R471 VSS.n832 VSS.n831 585
R472 VSS.n833 VSS.n832 585
R473 VSS.n79 VSS.n78 585
R474 VSS.n85 VSS.n78 585
R475 VSS.n826 VSS.n825 585
R476 VSS.n825 VSS.n824 585
R477 VSS.n83 VSS.n82 585
R478 VSS.n84 VSS.n83 585
R479 VSS.n815 VSS.n814 585
R480 VSS.n816 VSS.n815 585
R481 VSS.n93 VSS.n92 585
R482 VSS.n92 VSS.n91 585
R483 VSS.n809 VSS.n808 585
R484 VSS.n808 VSS.n807 585
R485 VSS.n97 VSS.n96 585
R486 VSS.n98 VSS.n97 585
R487 VSS.n799 VSS.n798 585
R488 VSS.t18 VSS.n799 585
R489 VSS.n105 VSS.n104 585
R490 VSS.n110 VSS.n104 585
R491 VSS.n793 VSS.n792 585
R492 VSS.n792 VSS.n791 585
R493 VSS.n109 VSS.n108 585
R494 VSS.n782 VSS.n109 585
R495 VSS.n781 VSS.n780 585
R496 VSS.n783 VSS.n781 585
R497 VSS.n117 VSS.n116 585
R498 VSS.n122 VSS.n116 585
R499 VSS.n775 VSS.n774 585
R500 VSS.n774 VSS.n773 585
R501 VSS.n121 VSS.n120 585
R502 VSS.n764 VSS.n121 585
R503 VSS.n763 VSS.n762 585
R504 VSS.n765 VSS.n763 585
R505 VSS.n129 VSS.n128 585
R506 VSS.n135 VSS.n128 585
R507 VSS.n758 VSS.n757 585
R508 VSS.n757 VSS.n756 585
R509 VSS.n133 VSS.n132 585
R510 VSS.n134 VSS.n133 585
R511 VSS.n747 VSS.n746 585
R512 VSS.n748 VSS.n747 585
R513 VSS.n143 VSS.n142 585
R514 VSS.n142 VSS.n141 585
R515 VSS.n742 VSS.n741 585
R516 VSS.n741 VSS.n740 585
R517 VSS.n147 VSS.n146 585
R518 VSS.n148 VSS.n147 585
R519 VSS.n731 VSS.n730 585
R520 VSS.n732 VSS.n731 585
R521 VSS.n155 VSS.n154 585
R522 VSS.n160 VSS.n154 585
R523 VSS.n725 VSS.n724 585
R524 VSS.n724 VSS.n723 585
R525 VSS.n159 VSS.n158 585
R526 VSS.n166 VSS.n159 585
R527 VSS.n715 VSS.n714 585
R528 VSS.t36 VSS.n715 585
R529 VSS.n168 VSS.n167 585
R530 VSS.n172 VSS.n167 585
R531 VSS.n709 VSS.n708 585
R532 VSS.n708 VSS.n707 585
R533 VSS.n171 VSS.n170 585
R534 VSS.n698 VSS.n171 585
R535 VSS.n697 VSS.n696 585
R536 VSS.n699 VSS.n697 585
R537 VSS.n180 VSS.n179 585
R538 VSS.n179 VSS.n178 585
R539 VSS.n681 VSS.n680 585
R540 VSS.n680 VSS.n679 585
R541 VSS.n193 VSS.n192 585
R542 VSS.n194 VSS.n193 585
R543 VSS.n670 VSS.n669 585
R544 VSS.n671 VSS.n670 585
R545 VSS.n201 VSS.n200 585
R546 VSS.n206 VSS.n200 585
R547 VSS.n664 VSS.n663 585
R548 VSS.n663 VSS.t42 585
R549 VSS.n204 VSS.n203 585
R550 VSS.n205 VSS.n204 585
R551 VSS.n654 VSS.n653 585
R552 VSS.n655 VSS.n654 585
R553 VSS.n213 VSS.n212 585
R554 VSS.n217 VSS.n212 585
R555 VSS.n647 VSS.n646 585
R556 VSS.n646 VSS.n645 585
R557 VSS.n216 VSS.n215 585
R558 VSS.n636 VSS.n216 585
R559 VSS.n635 VSS.n634 585
R560 VSS.n637 VSS.n635 585
R561 VSS.n224 VSS.n223 585
R562 VSS.n228 VSS.n223 585
R563 VSS.n628 VSS.n627 585
R564 VSS.n627 VSS.n626 585
R565 VSS.n227 VSS.n226 585
R566 VSS.n617 VSS.n227 585
R567 VSS.n616 VSS.n615 585
R568 VSS.n618 VSS.n616 585
R569 VSS.n235 VSS.n234 585
R570 VSS.n241 VSS.n234 585
R571 VSS.n611 VSS.n610 585
R572 VSS.n610 VSS.n609 585
R573 VSS.n239 VSS.n238 585
R574 VSS.n240 VSS.n239 585
R575 VSS.n600 VSS.n599 585
R576 VSS.n601 VSS.n600 585
R577 VSS.n248 VSS.n247 585
R578 VSS.n253 VSS.n247 585
R579 VSS.n594 VSS.n593 585
R580 VSS.n593 VSS.n592 585
R581 VSS.n252 VSS.n251 585
R582 VSS.n583 VSS.n252 585
R583 VSS.n582 VSS.n581 585
R584 VSS.n584 VSS.n582 585
R585 VSS.n260 VSS.n259 585
R586 VSS.n266 VSS.n259 585
R587 VSS.n576 VSS.n575 585
R588 VSS.n575 VSS.t60 585
R589 VSS.n264 VSS.n263 585
R590 VSS.n265 VSS.n264 585
R591 VSS.n566 VSS.n565 585
R592 VSS.n567 VSS.n566 585
R593 VSS.n273 VSS.n272 585
R594 VSS.n278 VSS.n272 585
R595 VSS.n560 VSS.n559 585
R596 VSS.n559 VSS.n558 585
R597 VSS.n277 VSS.n276 585
R598 VSS.n549 VSS.n277 585
R599 VSS.n548 VSS.n547 585
R600 VSS.n550 VSS.n548 585
R601 VSS.n285 VSS.n284 585
R602 VSS.n290 VSS.n284 585
R603 VSS.n542 VSS.n541 585
R604 VSS.n541 VSS.n540 585
R605 VSS.n289 VSS.n288 585
R606 VSS.n531 VSS.n289 585
R607 VSS.n530 VSS.n529 585
R608 VSS.n532 VSS.n530 585
R609 VSS.n298 VSS.n297 585
R610 VSS.n297 VSS.n296 585
R611 VSS.n525 VSS.n524 585
R612 VSS.n524 VSS.n523 585
R613 VSS.n302 VSS.n301 585
R614 VSS.n303 VSS.n302 585
R615 VSS.n514 VSS.n513 585
R616 VSS.n515 VSS.n514 585
R617 VSS.n311 VSS.n310 585
R618 VSS.n310 VSS.n309 585
R619 VSS.n508 VSS.n507 585
R620 VSS.n507 VSS.n506 585
R621 VSS.n315 VSS.n314 585
R622 VSS.n316 VSS.n315 585
R623 VSS.n497 VSS.n496 585
R624 VSS.n498 VSS.n497 585
R625 VSS.n324 VSS.n323 585
R626 VSS.n323 VSS.n322 585
R627 VSS.n491 VSS.n490 585
R628 VSS.n490 VSS.t78 585
R629 VSS.n327 VSS.n326 585
R630 VSS.n328 VSS.n327 585
R631 VSS.n481 VSS.n480 585
R632 VSS.n482 VSS.n481 585
R633 VSS.n333 VSS.n332 585
R634 VSS.n375 VSS.n374 585
R635 VSS.n372 VSS.n371 585
R636 VSS.n371 VSS.n334 585
R637 VSS.n380 VSS.n379 585
R638 VSS.n382 VSS.n370 585
R639 VSS.n385 VSS.n384 585
R640 VSS.n368 VSS.n367 585
R641 VSS.n390 VSS.n389 585
R642 VSS.n392 VSS.n366 585
R643 VSS.n395 VSS.n394 585
R644 VSS.n364 VSS.n363 585
R645 VSS.n400 VSS.n399 585
R646 VSS.n402 VSS.n362 585
R647 VSS.n405 VSS.n404 585
R648 VSS.n360 VSS.n359 585
R649 VSS.n410 VSS.n409 585
R650 VSS.n412 VSS.n358 585
R651 VSS.n415 VSS.n414 585
R652 VSS.n356 VSS.n355 585
R653 VSS.n420 VSS.n419 585
R654 VSS.n422 VSS.n354 585
R655 VSS.n425 VSS.n424 585
R656 VSS.n352 VSS.n351 585
R657 VSS.n430 VSS.n429 585
R658 VSS.n432 VSS.n350 585
R659 VSS.n435 VSS.n434 585
R660 VSS.n348 VSS.n347 585
R661 VSS.n440 VSS.n439 585
R662 VSS.n442 VSS.n346 585
R663 VSS.n445 VSS.n444 585
R664 VSS.n344 VSS.n343 585
R665 VSS.n450 VSS.n449 585
R666 VSS.n452 VSS.n342 585
R667 VSS.n455 VSS.n454 585
R668 VSS.n340 VSS.n339 585
R669 VSS.n460 VSS.n459 585
R670 VSS.n462 VSS.n338 585
R671 VSS.n465 VSS.n464 585
R672 VSS.n336 VSS.n335 585
R673 VSS.n1004 VSS.n35 470.337
R674 VSS.n1007 VSS.n13 470.337
R675 VSS.n481 VSS.n335 470.337
R676 VSS.n483 VSS.n333 470.337
R677 VSS.n476 VSS.n475 256.483
R678 VSS.n189 VSS.n188 256.483
R679 VSS.n692 VSS.n691 256.483
R680 VSS.n9 VSS.n8 256.483
R681 VSS.n1006 VSS.n1005 254.01
R682 VSS.n1005 VSS.n17 254.01
R683 VSS.n1005 VSS.n18 254.01
R684 VSS.n1005 VSS.n19 254.01
R685 VSS.n1005 VSS.n20 254.01
R686 VSS.n1005 VSS.n21 254.01
R687 VSS.n1005 VSS.n22 254.01
R688 VSS.n1005 VSS.n23 254.01
R689 VSS.n1005 VSS.n24 254.01
R690 VSS.n1005 VSS.n25 254.01
R691 VSS.n1005 VSS.n26 254.01
R692 VSS.n1005 VSS.n27 254.01
R693 VSS.n1005 VSS.n28 254.01
R694 VSS.n1005 VSS.n29 254.01
R695 VSS.n1005 VSS.n30 254.01
R696 VSS.n1005 VSS.n31 254.01
R697 VSS.n1005 VSS.n32 254.01
R698 VSS.n1005 VSS.n33 254.01
R699 VSS.n1005 VSS.n34 254.01
R700 VSS.n373 VSS.n334 254.01
R701 VSS.n381 VSS.n334 254.01
R702 VSS.n383 VSS.n334 254.01
R703 VSS.n391 VSS.n334 254.01
R704 VSS.n393 VSS.n334 254.01
R705 VSS.n401 VSS.n334 254.01
R706 VSS.n403 VSS.n334 254.01
R707 VSS.n411 VSS.n334 254.01
R708 VSS.n413 VSS.n334 254.01
R709 VSS.n421 VSS.n334 254.01
R710 VSS.n423 VSS.n334 254.01
R711 VSS.n431 VSS.n334 254.01
R712 VSS.n433 VSS.n334 254.01
R713 VSS.n441 VSS.n334 254.01
R714 VSS.n443 VSS.n334 254.01
R715 VSS.n451 VSS.n334 254.01
R716 VSS.n453 VSS.n334 254.01
R717 VSS.n461 VSS.n334 254.01
R718 VSS.n463 VSS.n334 254.01
R719 VSS.n471 VSS.n470 185
R720 VSS.n475 VSS.n474 185
R721 VSS.n184 VSS.n183 185
R722 VSS.n188 VSS.n187 185
R723 VSS.n687 VSS.n686 185
R724 VSS.n691 VSS.n690 185
R725 VSS.n4 VSS.n3 185
R726 VSS.n8 VSS.n7 185
R727 VSS.n472 VSS.t79 180.934
R728 VSS.n185 VSS.t41 180.934
R729 VSS.n688 VSS.t39 180.934
R730 VSS.n5 VSS.t1 180.934
R731 VSS.n1004 VSS.n36 177.3
R732 VSS.n897 VSS.n896 177.3
R733 VSS.n899 VSS.n898 177.3
R734 VSS.n903 VSS.n902 177.3
R735 VSS.n905 VSS.n904 177.3
R736 VSS.n909 VSS.n908 177.3
R737 VSS.n911 VSS.n910 177.3
R738 VSS.n915 VSS.n914 177.3
R739 VSS.n917 VSS.n916 177.3
R740 VSS.n921 VSS.n920 177.3
R741 VSS.n923 VSS.n922 177.3
R742 VSS.n927 VSS.n926 177.3
R743 VSS.n929 VSS.n928 177.3
R744 VSS.n933 VSS.n932 177.3
R745 VSS.n935 VSS.n934 177.3
R746 VSS.n939 VSS.n938 177.3
R747 VSS.n941 VSS.n940 177.3
R748 VSS.n945 VSS.n944 177.3
R749 VSS.n946 VSS.n15 177.3
R750 VSS.n481 VSS.n327 177.3
R751 VSS.n490 VSS.n327 177.3
R752 VSS.n490 VSS.n323 177.3
R753 VSS.n497 VSS.n323 177.3
R754 VSS.n497 VSS.n315 177.3
R755 VSS.n507 VSS.n315 177.3
R756 VSS.n507 VSS.n310 177.3
R757 VSS.n514 VSS.n310 177.3
R758 VSS.n514 VSS.n302 177.3
R759 VSS.n524 VSS.n302 177.3
R760 VSS.n524 VSS.n297 177.3
R761 VSS.n530 VSS.n297 177.3
R762 VSS.n530 VSS.n289 177.3
R763 VSS.n541 VSS.n289 177.3
R764 VSS.n541 VSS.n284 177.3
R765 VSS.n548 VSS.n284 177.3
R766 VSS.n548 VSS.n277 177.3
R767 VSS.n559 VSS.n277 177.3
R768 VSS.n559 VSS.n272 177.3
R769 VSS.n566 VSS.n272 177.3
R770 VSS.n566 VSS.n264 177.3
R771 VSS.n575 VSS.n264 177.3
R772 VSS.n575 VSS.n259 177.3
R773 VSS.n582 VSS.n259 177.3
R774 VSS.n582 VSS.n252 177.3
R775 VSS.n593 VSS.n252 177.3
R776 VSS.n593 VSS.n247 177.3
R777 VSS.n600 VSS.n247 177.3
R778 VSS.n600 VSS.n239 177.3
R779 VSS.n610 VSS.n239 177.3
R780 VSS.n610 VSS.n234 177.3
R781 VSS.n616 VSS.n234 177.3
R782 VSS.n616 VSS.n227 177.3
R783 VSS.n627 VSS.n227 177.3
R784 VSS.n627 VSS.n223 177.3
R785 VSS.n635 VSS.n223 177.3
R786 VSS.n635 VSS.n216 177.3
R787 VSS.n646 VSS.n216 177.3
R788 VSS.n646 VSS.n212 177.3
R789 VSS.n654 VSS.n212 177.3
R790 VSS.n654 VSS.n204 177.3
R791 VSS.n663 VSS.n204 177.3
R792 VSS.n663 VSS.n200 177.3
R793 VSS.n670 VSS.n200 177.3
R794 VSS.n670 VSS.n193 177.3
R795 VSS.n680 VSS.n193 177.3
R796 VSS.n680 VSS.n179 177.3
R797 VSS.n697 VSS.n179 177.3
R798 VSS.n697 VSS.n171 177.3
R799 VSS.n708 VSS.n171 177.3
R800 VSS.n708 VSS.n167 177.3
R801 VSS.n715 VSS.n167 177.3
R802 VSS.n715 VSS.n159 177.3
R803 VSS.n724 VSS.n159 177.3
R804 VSS.n724 VSS.n154 177.3
R805 VSS.n731 VSS.n154 177.3
R806 VSS.n731 VSS.n147 177.3
R807 VSS.n741 VSS.n147 177.3
R808 VSS.n741 VSS.n142 177.3
R809 VSS.n747 VSS.n142 177.3
R810 VSS.n747 VSS.n133 177.3
R811 VSS.n757 VSS.n133 177.3
R812 VSS.n757 VSS.n128 177.3
R813 VSS.n763 VSS.n128 177.3
R814 VSS.n763 VSS.n121 177.3
R815 VSS.n774 VSS.n121 177.3
R816 VSS.n774 VSS.n116 177.3
R817 VSS.n781 VSS.n116 177.3
R818 VSS.n781 VSS.n109 177.3
R819 VSS.n792 VSS.n109 177.3
R820 VSS.n792 VSS.n104 177.3
R821 VSS.n799 VSS.n104 177.3
R822 VSS.n799 VSS.n97 177.3
R823 VSS.n808 VSS.n97 177.3
R824 VSS.n808 VSS.n92 177.3
R825 VSS.n815 VSS.n92 177.3
R826 VSS.n815 VSS.n83 177.3
R827 VSS.n825 VSS.n83 177.3
R828 VSS.n825 VSS.n78 177.3
R829 VSS.n832 VSS.n78 177.3
R830 VSS.n832 VSS.n70 177.3
R831 VSS.n842 VSS.n70 177.3
R832 VSS.n842 VSS.n66 177.3
R833 VSS.n850 VSS.n66 177.3
R834 VSS.n850 VSS.n59 177.3
R835 VSS.n861 VSS.n59 177.3
R836 VSS.n861 VSS.n55 177.3
R837 VSS.n869 VSS.n55 177.3
R838 VSS.n869 VSS.n46 177.3
R839 VSS.n881 VSS.n46 177.3
R840 VSS.n881 VSS.n42 177.3
R841 VSS.n888 VSS.n42 177.3
R842 VSS.n889 VSS.n888 177.3
R843 VSS.n889 VSS.n13 177.3
R844 VSS.n374 VSS.n371 177.3
R845 VSS.n380 VSS.n371 177.3
R846 VSS.n384 VSS.n382 177.3
R847 VSS.n390 VSS.n367 177.3
R848 VSS.n394 VSS.n392 177.3
R849 VSS.n400 VSS.n363 177.3
R850 VSS.n404 VSS.n402 177.3
R851 VSS.n410 VSS.n359 177.3
R852 VSS.n414 VSS.n412 177.3
R853 VSS.n420 VSS.n355 177.3
R854 VSS.n424 VSS.n422 177.3
R855 VSS.n430 VSS.n351 177.3
R856 VSS.n434 VSS.n432 177.3
R857 VSS.n440 VSS.n347 177.3
R858 VSS.n444 VSS.n442 177.3
R859 VSS.n450 VSS.n343 177.3
R860 VSS.n454 VSS.n452 177.3
R861 VSS.n460 VSS.n339 177.3
R862 VSS.n464 VSS.n462 177.3
R863 VSS.n483 VSS.n329 177.3
R864 VSS.n489 VSS.n329 177.3
R865 VSS.n489 VSS.n321 177.3
R866 VSS.n499 VSS.n321 177.3
R867 VSS.n499 VSS.n317 177.3
R868 VSS.n505 VSS.n317 177.3
R869 VSS.n505 VSS.n308 177.3
R870 VSS.n516 VSS.n308 177.3
R871 VSS.n516 VSS.n304 177.3
R872 VSS.n522 VSS.n304 177.3
R873 VSS.n522 VSS.n295 177.3
R874 VSS.n533 VSS.n295 177.3
R875 VSS.n533 VSS.n291 177.3
R876 VSS.n539 VSS.n291 177.3
R877 VSS.n539 VSS.n283 177.3
R878 VSS.n551 VSS.n283 177.3
R879 VSS.n551 VSS.n279 177.3
R880 VSS.n557 VSS.n279 177.3
R881 VSS.n557 VSS.n271 177.3
R882 VSS.n568 VSS.n271 177.3
R883 VSS.n568 VSS.n267 177.3
R884 VSS.n574 VSS.n267 177.3
R885 VSS.n574 VSS.n258 177.3
R886 VSS.n585 VSS.n258 177.3
R887 VSS.n585 VSS.n254 177.3
R888 VSS.n591 VSS.n254 177.3
R889 VSS.n591 VSS.n246 177.3
R890 VSS.n602 VSS.n246 177.3
R891 VSS.n602 VSS.n242 177.3
R892 VSS.n608 VSS.n242 177.3
R893 VSS.n608 VSS.n233 177.3
R894 VSS.n619 VSS.n233 177.3
R895 VSS.n619 VSS.n229 177.3
R896 VSS.n625 VSS.n229 177.3
R897 VSS.n625 VSS.n222 177.3
R898 VSS.n638 VSS.n222 177.3
R899 VSS.n638 VSS.n218 177.3
R900 VSS.n644 VSS.n218 177.3
R901 VSS.n644 VSS.n211 177.3
R902 VSS.n656 VSS.n211 177.3
R903 VSS.n656 VSS.n207 177.3
R904 VSS.n662 VSS.n207 177.3
R905 VSS.n662 VSS.n199 177.3
R906 VSS.n672 VSS.n199 177.3
R907 VSS.n672 VSS.n195 177.3
R908 VSS.n678 VSS.n195 177.3
R909 VSS.n678 VSS.n177 177.3
R910 VSS.n700 VSS.n177 177.3
R911 VSS.n700 VSS.n173 177.3
R912 VSS.n706 VSS.n173 177.3
R913 VSS.n706 VSS.n165 177.3
R914 VSS.n716 VSS.n165 177.3
R915 VSS.n716 VSS.n161 177.3
R916 VSS.n722 VSS.n161 177.3
R917 VSS.n722 VSS.n153 177.3
R918 VSS.n733 VSS.n153 177.3
R919 VSS.n733 VSS.n149 177.3
R920 VSS.n739 VSS.n149 177.3
R921 VSS.n739 VSS.n140 177.3
R922 VSS.n749 VSS.n140 177.3
R923 VSS.n749 VSS.n136 177.3
R924 VSS.n755 VSS.n136 177.3
R925 VSS.n755 VSS.n127 177.3
R926 VSS.n766 VSS.n127 177.3
R927 VSS.n766 VSS.n123 177.3
R928 VSS.n772 VSS.n123 177.3
R929 VSS.n772 VSS.n115 177.3
R930 VSS.n784 VSS.n115 177.3
R931 VSS.n784 VSS.n111 177.3
R932 VSS.n790 VSS.n111 177.3
R933 VSS.n790 VSS.n103 177.3
R934 VSS.n800 VSS.n103 177.3
R935 VSS.n800 VSS.n99 177.3
R936 VSS.n806 VSS.n99 177.3
R937 VSS.n806 VSS.n90 177.3
R938 VSS.n817 VSS.n90 177.3
R939 VSS.n817 VSS.n86 177.3
R940 VSS.n823 VSS.n86 177.3
R941 VSS.n823 VSS.n77 177.3
R942 VSS.n834 VSS.n77 177.3
R943 VSS.n834 VSS.n73 177.3
R944 VSS.n840 VSS.n73 177.3
R945 VSS.n840 VSS.n65 177.3
R946 VSS.n853 VSS.n65 177.3
R947 VSS.n853 VSS.n61 177.3
R948 VSS.n859 VSS.n61 177.3
R949 VSS.n859 VSS.n54 177.3
R950 VSS.n872 VSS.n54 177.3
R951 VSS.n872 VSS.n48 177.3
R952 VSS.n879 VSS.n48 177.3
R953 VSS.n879 VSS.n49 177.3
R954 VSS.n49 VSS.n41 177.3
R955 VSS.n891 VSS.n41 177.3
R956 VSS.n891 VSS.n35 177.3
R957 VSS.n475 VSS.n470 144
R958 VSS.n188 VSS.n183 144
R959 VSS.n691 VSS.n686 144
R960 VSS.n8 VSS.n3 144
R961 VSS.n482 VSS.n334 101.882
R962 VSS.n1005 VSS.n16 101.882
R963 VSS.n896 VSS.n34 76.985
R964 VSS.n898 VSS.n33 76.985
R965 VSS.n902 VSS.n32 76.985
R966 VSS.n904 VSS.n31 76.985
R967 VSS.n908 VSS.n30 76.985
R968 VSS.n910 VSS.n29 76.985
R969 VSS.n914 VSS.n28 76.985
R970 VSS.n916 VSS.n27 76.985
R971 VSS.n920 VSS.n26 76.985
R972 VSS.n922 VSS.n25 76.985
R973 VSS.n926 VSS.n24 76.985
R974 VSS.n928 VSS.n23 76.985
R975 VSS.n932 VSS.n22 76.985
R976 VSS.n934 VSS.n21 76.985
R977 VSS.n938 VSS.n20 76.985
R978 VSS.n940 VSS.n19 76.985
R979 VSS.n944 VSS.n18 76.985
R980 VSS.n946 VSS.n17 76.985
R981 VSS.n1007 VSS.n1006 76.985
R982 VSS.n373 VSS.n333 76.985
R983 VSS.n381 VSS.n380 76.985
R984 VSS.n384 VSS.n383 76.985
R985 VSS.n391 VSS.n390 76.985
R986 VSS.n394 VSS.n393 76.985
R987 VSS.n401 VSS.n400 76.985
R988 VSS.n404 VSS.n403 76.985
R989 VSS.n411 VSS.n410 76.985
R990 VSS.n414 VSS.n413 76.985
R991 VSS.n421 VSS.n420 76.985
R992 VSS.n424 VSS.n423 76.985
R993 VSS.n431 VSS.n430 76.985
R994 VSS.n434 VSS.n433 76.985
R995 VSS.n441 VSS.n440 76.985
R996 VSS.n444 VSS.n443 76.985
R997 VSS.n451 VSS.n450 76.985
R998 VSS.n454 VSS.n453 76.985
R999 VSS.n461 VSS.n460 76.985
R1000 VSS.n464 VSS.n463 76.985
R1001 VSS.n1006 VSS.n15 76.985
R1002 VSS.n945 VSS.n17 76.985
R1003 VSS.n941 VSS.n18 76.985
R1004 VSS.n939 VSS.n19 76.985
R1005 VSS.n935 VSS.n20 76.985
R1006 VSS.n933 VSS.n21 76.985
R1007 VSS.n929 VSS.n22 76.985
R1008 VSS.n927 VSS.n23 76.985
R1009 VSS.n923 VSS.n24 76.985
R1010 VSS.n921 VSS.n25 76.985
R1011 VSS.n917 VSS.n26 76.985
R1012 VSS.n915 VSS.n27 76.985
R1013 VSS.n911 VSS.n28 76.985
R1014 VSS.n909 VSS.n29 76.985
R1015 VSS.n905 VSS.n30 76.985
R1016 VSS.n903 VSS.n31 76.985
R1017 VSS.n899 VSS.n32 76.985
R1018 VSS.n897 VSS.n33 76.985
R1019 VSS.n36 VSS.n34 76.985
R1020 VSS.n374 VSS.n373 76.985
R1021 VSS.n382 VSS.n381 76.985
R1022 VSS.n383 VSS.n367 76.985
R1023 VSS.n392 VSS.n391 76.985
R1024 VSS.n393 VSS.n363 76.985
R1025 VSS.n402 VSS.n401 76.985
R1026 VSS.n403 VSS.n359 76.985
R1027 VSS.n412 VSS.n411 76.985
R1028 VSS.n413 VSS.n355 76.985
R1029 VSS.n422 VSS.n421 76.985
R1030 VSS.n423 VSS.n351 76.985
R1031 VSS.n432 VSS.n431 76.985
R1032 VSS.n433 VSS.n347 76.985
R1033 VSS.n442 VSS.n441 76.985
R1034 VSS.n443 VSS.n343 76.985
R1035 VSS.n452 VSS.n451 76.985
R1036 VSS.n453 VSS.n339 76.985
R1037 VSS.n462 VSS.n461 76.985
R1038 VSS.n463 VSS.n335 76.985
R1039 VSS.n482 VSS.n328 76.4115
R1040 VSS.t78 VSS.n328 76.4115
R1041 VSS.t78 VSS.n322 76.4115
R1042 VSS.n498 VSS.n322 76.4115
R1043 VSS.n506 VSS.n316 76.4115
R1044 VSS.n515 VSS.n309 76.4115
R1045 VSS.n523 VSS.n303 76.4115
R1046 VSS.n532 VSS.n296 76.4115
R1047 VSS.n532 VSS.n531 76.4115
R1048 VSS.n550 VSS.n549 76.4115
R1049 VSS.n558 VSS.n278 76.4115
R1050 VSS.n567 VSS.n265 76.4115
R1051 VSS.t60 VSS.n265 76.4115
R1052 VSS.n609 VSS.n240 76.4115
R1053 VSS.n618 VSS.n617 76.4115
R1054 VSS.n626 VSS.n228 76.4115
R1055 VSS.n637 VSS.n636 76.4115
R1056 VSS.t42 VSS.n205 76.4115
R1057 VSS.n679 VSS.n194 76.4115
R1058 VSS.n679 VSS.n178 76.4115
R1059 VSS.n699 VSS.n178 76.4115
R1060 VSS.n699 VSS.n698 76.4115
R1061 VSS.t36 VSS.n166 76.4115
R1062 VSS.n740 VSS.n148 76.4115
R1063 VSS.n748 VSS.n141 76.4115
R1064 VSS.n756 VSS.n134 76.4115
R1065 VSS.n765 VSS.n764 76.4115
R1066 VSS.t18 VSS.n98 76.4115
R1067 VSS.n807 VSS.n98 76.4115
R1068 VSS.n816 VSS.n91 76.4115
R1069 VSS.n824 VSS.n84 76.4115
R1070 VSS.n841 VSS.n71 76.4115
R1071 VSS.n841 VSS.n72 76.4115
R1072 VSS.n852 VSS.n851 76.4115
R1073 VSS.n860 VSS.n60 76.4115
R1074 VSS.n871 VSS.n870 76.4115
R1075 VSS.n880 VSS.n47 76.4115
R1076 VSS.n47 VSS.t0 76.4115
R1077 VSS.n890 VSS.t0 76.4115
R1078 VSS.n890 VSS.n16 76.4115
R1079 VSS.n655 VSS.t109 73.2277
R1080 VSS.n723 VSS.t102 73.2277
R1081 VSS.t79 VSS.n470 72.0005
R1082 VSS.t41 VSS.n183 72.0005
R1083 VSS.t39 VSS.n686 72.0005
R1084 VSS.t1 VSS.n3 72.0005
R1085 VSS.n523 VSS.t70 67.9214
R1086 VSS.n540 VSS.t68 67.9214
R1087 VSS.n266 VSS.t94 67.9214
R1088 VSS.n626 VSS.t50 67.9214
R1089 VSS.n748 VSS.t28 67.9214
R1090 VSS.n833 VSS.t10 67.9214
R1091 VSS.n852 VSS.t8 67.9214
R1092 VSS.n592 VSS.t93 66.8601
R1093 VSS.n783 VSS.t82 66.8601
R1094 VSS.t81 VSS.n110 66.8601
R1095 VSS.t108 VSS.n206 60.4925
R1096 VSS.n172 VSS.t103 60.4925
R1097 VSS.t76 VSS.n316 59.4313
R1098 VSS.n278 VSS.t62 59.4313
R1099 VSS.t58 VSS.n583 59.4313
R1100 VSS.t26 VSS.t86 59.4313
R1101 VSS.n782 VSS.t20 59.4313
R1102 VSS.t16 VSS.n91 59.4313
R1103 VSS.n870 VSS.t2 59.4313
R1104 VSS.t89 VSS.t52 58.37
R1105 VSS.n217 VSS.t110 54.125
R1106 VSS.t101 VSS.n160 54.125
R1107 VSS.n515 VSS.t72 50.9412
R1108 VSS.n550 VSS.t66 50.9412
R1109 VSS.n601 VSS.t54 50.9412
R1110 VSS.n773 VSS.t24 50.9412
R1111 VSS.n824 VSS.t12 50.9412
R1112 VSS.n860 VSS.t6 50.9412
R1113 VSS.t60 VSS.t95 48.8186
R1114 VSS.t48 VSS.t113 48.8186
R1115 VSS.n756 VSS.t87 48.8186
R1116 VSS.n540 VSS.t96 47.7574
R1117 VSS.n253 VSS.t91 47.7574
R1118 VSS.n618 VSS.t88 47.7574
R1119 VSS.t98 VSS.t30 47.7574
R1120 VSS.t84 VSS.n122 47.7574
R1121 VSS.t18 VSS.t80 47.7574
R1122 VSS.n833 VSS.t97 47.7574
R1123 VSS.t74 VSS.n309 42.4511
R1124 VSS.n549 VSS.t64 42.4511
R1125 VSS.t56 VSS.n253 42.4511
R1126 VSS.n707 VSS.t104 42.4511
R1127 VSS.n122 VSS.t22 42.4511
R1128 VSS.t14 VSS.n84 42.4511
R1129 VSS.n60 VSS.t4 42.4511
R1130 VSS.t111 VSS.n217 41.3898
R1131 VSS.n671 VSS.t107 41.3898
R1132 VSS.n160 VSS.t100 41.3898
R1133 VSS.t40 VSS.t106 37.1447
R1134 VSS.t105 VSS.t38 36.0835
R1135 VSS.n645 VSS.t111 35.0222
R1136 VSS.n206 VSS.t107 35.0222
R1137 VSS.n732 VSS.t100 35.0222
R1138 VSS.n506 VSS.t74 33.9609
R1139 VSS.n558 VSS.t64 33.9609
R1140 VSS.n645 VSS.t46 33.9609
R1141 VSS.t104 VSS.n172 33.9609
R1142 VSS.n732 VSS.t32 33.9609
R1143 VSS.n816 VSS.t14 33.9609
R1144 VSS.n871 VSS.t4 33.9609
R1145 VSS.n484 VSS.n332 30.5605
R1146 VSS.n1003 VSS.n37 30.5605
R1147 VSS.n1009 VSS.n1008 30.5605
R1148 VSS.n480 VSS.n336 30.5605
R1149 VSS.t96 VSS.n290 28.6546
R1150 VSS.n592 VSS.t92 28.6546
R1151 VSS.n601 VSS.t91 28.6546
R1152 VSS.n241 VSS.t88 28.6546
R1153 VSS.n773 VSS.t84 28.6546
R1154 VSS.n783 VSS.t83 28.6546
R1155 VSS.n110 VSS.t80 28.6546
R1156 VSS.n85 VSS.t97 28.6546
R1157 VSS.t95 VSS.n266 27.5934
R1158 VSS.t87 VSS.n135 27.5934
R1159 VSS.n474 VSS.n471 27.1064
R1160 VSS.n474 VSS.n469 27.1064
R1161 VSS.n187 VSS.n184 27.1064
R1162 VSS.n187 VSS.n182 27.1064
R1163 VSS.n690 VSS.n687 27.1064
R1164 VSS.n690 VSS.n685 27.1064
R1165 VSS.n7 VSS.n4 27.1064
R1166 VSS.n7 VSS.n2 27.1064
R1167 VSS.t32 VSS.t99 26.5321
R1168 VSS.n477 VSS.n476 25.7818
R1169 VSS.n190 VSS.n189 25.7818
R1170 VSS.n693 VSS.n692 25.7818
R1171 VSS.n10 VSS.n9 25.7818
R1172 VSS.t72 VSS.n303 25.4708
R1173 VSS.n290 VSS.t66 25.4708
R1174 VSS.n228 VSS.t48 25.4708
R1175 VSS.t112 VSS.t46 25.4708
R1176 VSS.t30 VSS.n141 25.4708
R1177 VSS.t12 VSS.n85 25.4708
R1178 VSS.n851 VSS.t6 25.4708
R1179 VSS.n614 VSS.n236 24.9139
R1180 VSS.n759 VSS.n130 24.9139
R1181 VSS.n313 VSS.n312 24.9139
R1182 VSS.n300 VSS.n299 24.9139
R1183 VSS.n544 VSS.n286 24.9139
R1184 VSS.n562 VSS.n274 24.9139
R1185 VSS.n579 VSS.n261 24.9139
R1186 VSS.n597 VSS.n249 24.9139
R1187 VSS.n632 VSS.n631 24.9139
R1188 VSS.n651 VSS.n650 24.9139
R1189 VSS.n157 VSS.n156 24.9139
R1190 VSS.n145 VSS.n144 24.9139
R1191 VSS.n777 VSS.n118 24.9139
R1192 VSS.n795 VSS.n106 24.9139
R1193 VSS.n812 VSS.n94 24.9139
R1194 VSS.n829 VSS.n80 24.9139
R1195 VSS.n847 VSS.n846 24.9139
R1196 VSS.n866 VSS.n865 24.9139
R1197 VSS.n698 VSS.t105 23.3483
R1198 VSS.t106 VSS.n194 22.287
R1199 VSS.n498 VSS.t76 16.9807
R1200 VSS.n567 VSS.t62 16.9807
R1201 VSS.n584 VSS.t58 16.9807
R1202 VSS.n636 VSS.t112 16.9807
R1203 VSS.n655 VSS.t44 16.9807
R1204 VSS.n671 VSS.t40 16.9807
R1205 VSS.n707 VSS.t38 16.9807
R1206 VSS.n723 VSS.t34 16.9807
R1207 VSS.n791 VSS.t20 16.9807
R1208 VSS.n807 VSS.t16 16.9807
R1209 VSS.n880 VSS.t2 16.9807
R1210 VSS.t54 VSS.t90 15.9195
R1211 VSS.t42 VSS.t108 15.9195
R1212 VSS.t36 VSS.t103 15.9195
R1213 VSS.t99 VSS.n148 15.9195
R1214 VSS.t85 VSS.t24 15.9195
R1215 VSS.n484 VSS.n330 11.5205
R1216 VSS.n488 VSS.n330 11.5205
R1217 VSS.n488 VSS.n320 11.5205
R1218 VSS.n500 VSS.n320 11.5205
R1219 VSS.n500 VSS.n318 11.5205
R1220 VSS.n504 VSS.n318 11.5205
R1221 VSS.n504 VSS.n307 11.5205
R1222 VSS.n517 VSS.n307 11.5205
R1223 VSS.n517 VSS.n305 11.5205
R1224 VSS.n521 VSS.n305 11.5205
R1225 VSS.n521 VSS.n294 11.5205
R1226 VSS.n534 VSS.n294 11.5205
R1227 VSS.n534 VSS.n292 11.5205
R1228 VSS.n538 VSS.n292 11.5205
R1229 VSS.n538 VSS.n282 11.5205
R1230 VSS.n552 VSS.n282 11.5205
R1231 VSS.n552 VSS.n280 11.5205
R1232 VSS.n556 VSS.n280 11.5205
R1233 VSS.n556 VSS.n270 11.5205
R1234 VSS.n569 VSS.n270 11.5205
R1235 VSS.n569 VSS.n268 11.5205
R1236 VSS.n573 VSS.n268 11.5205
R1237 VSS.n573 VSS.n257 11.5205
R1238 VSS.n586 VSS.n257 11.5205
R1239 VSS.n586 VSS.n255 11.5205
R1240 VSS.n590 VSS.n255 11.5205
R1241 VSS.n590 VSS.n245 11.5205
R1242 VSS.n603 VSS.n245 11.5205
R1243 VSS.n603 VSS.n243 11.5205
R1244 VSS.n607 VSS.n243 11.5205
R1245 VSS.n607 VSS.n232 11.5205
R1246 VSS.n620 VSS.n232 11.5205
R1247 VSS.n620 VSS.n230 11.5205
R1248 VSS.n624 VSS.n230 11.5205
R1249 VSS.n624 VSS.n221 11.5205
R1250 VSS.n639 VSS.n221 11.5205
R1251 VSS.n639 VSS.n219 11.5205
R1252 VSS.n643 VSS.n219 11.5205
R1253 VSS.n643 VSS.n210 11.5205
R1254 VSS.n657 VSS.n210 11.5205
R1255 VSS.n657 VSS.n208 11.5205
R1256 VSS.n661 VSS.n208 11.5205
R1257 VSS.n661 VSS.n198 11.5205
R1258 VSS.n673 VSS.n198 11.5205
R1259 VSS.n673 VSS.n196 11.5205
R1260 VSS.n677 VSS.n196 11.5205
R1261 VSS.n677 VSS.n176 11.5205
R1262 VSS.n701 VSS.n176 11.5205
R1263 VSS.n701 VSS.n174 11.5205
R1264 VSS.n705 VSS.n174 11.5205
R1265 VSS.n705 VSS.n164 11.5205
R1266 VSS.n717 VSS.n164 11.5205
R1267 VSS.n717 VSS.n162 11.5205
R1268 VSS.n721 VSS.n162 11.5205
R1269 VSS.n721 VSS.n152 11.5205
R1270 VSS.n734 VSS.n152 11.5205
R1271 VSS.n734 VSS.n150 11.5205
R1272 VSS.n738 VSS.n150 11.5205
R1273 VSS.n738 VSS.n139 11.5205
R1274 VSS.n750 VSS.n139 11.5205
R1275 VSS.n750 VSS.n137 11.5205
R1276 VSS.n754 VSS.n137 11.5205
R1277 VSS.n754 VSS.n126 11.5205
R1278 VSS.n767 VSS.n126 11.5205
R1279 VSS.n767 VSS.n124 11.5205
R1280 VSS.n771 VSS.n124 11.5205
R1281 VSS.n771 VSS.n114 11.5205
R1282 VSS.n785 VSS.n114 11.5205
R1283 VSS.n785 VSS.n112 11.5205
R1284 VSS.n789 VSS.n112 11.5205
R1285 VSS.n789 VSS.n102 11.5205
R1286 VSS.n801 VSS.n102 11.5205
R1287 VSS.n801 VSS.n100 11.5205
R1288 VSS.n805 VSS.n100 11.5205
R1289 VSS.n805 VSS.n89 11.5205
R1290 VSS.n818 VSS.n89 11.5205
R1291 VSS.n818 VSS.n87 11.5205
R1292 VSS.n822 VSS.n87 11.5205
R1293 VSS.n822 VSS.n76 11.5205
R1294 VSS.n835 VSS.n76 11.5205
R1295 VSS.n835 VSS.n74 11.5205
R1296 VSS.n839 VSS.n74 11.5205
R1297 VSS.n839 VSS.n64 11.5205
R1298 VSS.n854 VSS.n64 11.5205
R1299 VSS.n854 VSS.n62 11.5205
R1300 VSS.n858 VSS.n62 11.5205
R1301 VSS.n858 VSS.n53 11.5205
R1302 VSS.n873 VSS.n53 11.5205
R1303 VSS.n873 VSS.n50 11.5205
R1304 VSS.n878 VSS.n50 11.5205
R1305 VSS.n878 VSS.n51 11.5205
R1306 VSS.n51 VSS.n40 11.5205
R1307 VSS.n892 VSS.n40 11.5205
R1308 VSS.n892 VSS.n37 11.5205
R1309 VSS.n1003 VSS.n38 11.5205
R1310 VSS.n999 VSS.n38 11.5205
R1311 VSS.n999 VSS.n998 11.5205
R1312 VSS.n998 VSS.n997 11.5205
R1313 VSS.n997 VSS.n900 11.5205
R1314 VSS.n993 VSS.n900 11.5205
R1315 VSS.n993 VSS.n992 11.5205
R1316 VSS.n992 VSS.n991 11.5205
R1317 VSS.n991 VSS.n906 11.5205
R1318 VSS.n987 VSS.n906 11.5205
R1319 VSS.n987 VSS.n986 11.5205
R1320 VSS.n986 VSS.n985 11.5205
R1321 VSS.n985 VSS.n912 11.5205
R1322 VSS.n981 VSS.n912 11.5205
R1323 VSS.n981 VSS.n980 11.5205
R1324 VSS.n980 VSS.n979 11.5205
R1325 VSS.n979 VSS.n918 11.5205
R1326 VSS.n975 VSS.n918 11.5205
R1327 VSS.n975 VSS.n974 11.5205
R1328 VSS.n974 VSS.n973 11.5205
R1329 VSS.n973 VSS.n924 11.5205
R1330 VSS.n969 VSS.n924 11.5205
R1331 VSS.n969 VSS.n968 11.5205
R1332 VSS.n968 VSS.n967 11.5205
R1333 VSS.n967 VSS.n930 11.5205
R1334 VSS.n963 VSS.n930 11.5205
R1335 VSS.n963 VSS.n962 11.5205
R1336 VSS.n962 VSS.n961 11.5205
R1337 VSS.n961 VSS.n936 11.5205
R1338 VSS.n957 VSS.n936 11.5205
R1339 VSS.n957 VSS.n956 11.5205
R1340 VSS.n956 VSS.n955 11.5205
R1341 VSS.n955 VSS.n942 11.5205
R1342 VSS.n951 VSS.n942 11.5205
R1343 VSS.n951 VSS.n950 11.5205
R1344 VSS.n950 VSS.n949 11.5205
R1345 VSS.n949 VSS.n14 11.5205
R1346 VSS.n1008 VSS.n14 11.5205
R1347 VSS.n480 VSS.n326 11.5205
R1348 VSS.n491 VSS.n326 11.5205
R1349 VSS.n491 VSS.n324 11.5205
R1350 VSS.n496 VSS.n324 11.5205
R1351 VSS.n496 VSS.n314 11.5205
R1352 VSS.n508 VSS.n314 11.5205
R1353 VSS.n508 VSS.n311 11.5205
R1354 VSS.n513 VSS.n311 11.5205
R1355 VSS.n513 VSS.n301 11.5205
R1356 VSS.n525 VSS.n301 11.5205
R1357 VSS.n525 VSS.n298 11.5205
R1358 VSS.n529 VSS.n298 11.5205
R1359 VSS.n529 VSS.n288 11.5205
R1360 VSS.n542 VSS.n288 11.5205
R1361 VSS.n542 VSS.n285 11.5205
R1362 VSS.n547 VSS.n285 11.5205
R1363 VSS.n547 VSS.n276 11.5205
R1364 VSS.n560 VSS.n276 11.5205
R1365 VSS.n560 VSS.n273 11.5205
R1366 VSS.n565 VSS.n273 11.5205
R1367 VSS.n565 VSS.n263 11.5205
R1368 VSS.n576 VSS.n263 11.5205
R1369 VSS.n576 VSS.n260 11.5205
R1370 VSS.n581 VSS.n260 11.5205
R1371 VSS.n581 VSS.n251 11.5205
R1372 VSS.n594 VSS.n251 11.5205
R1373 VSS.n594 VSS.n248 11.5205
R1374 VSS.n599 VSS.n248 11.5205
R1375 VSS.n599 VSS.n238 11.5205
R1376 VSS.n611 VSS.n238 11.5205
R1377 VSS.n611 VSS.n235 11.5205
R1378 VSS.n615 VSS.n235 11.5205
R1379 VSS.n615 VSS.n226 11.5205
R1380 VSS.n628 VSS.n226 11.5205
R1381 VSS.n628 VSS.n224 11.5205
R1382 VSS.n634 VSS.n224 11.5205
R1383 VSS.n634 VSS.n215 11.5205
R1384 VSS.n647 VSS.n215 11.5205
R1385 VSS.n647 VSS.n213 11.5205
R1386 VSS.n653 VSS.n213 11.5205
R1387 VSS.n653 VSS.n203 11.5205
R1388 VSS.n664 VSS.n203 11.5205
R1389 VSS.n664 VSS.n201 11.5205
R1390 VSS.n669 VSS.n201 11.5205
R1391 VSS.n669 VSS.n192 11.5205
R1392 VSS.n681 VSS.n192 11.5205
R1393 VSS.n681 VSS.n180 11.5205
R1394 VSS.n696 VSS.n180 11.5205
R1395 VSS.n696 VSS.n170 11.5205
R1396 VSS.n709 VSS.n170 11.5205
R1397 VSS.n709 VSS.n168 11.5205
R1398 VSS.n714 VSS.n168 11.5205
R1399 VSS.n714 VSS.n158 11.5205
R1400 VSS.n725 VSS.n158 11.5205
R1401 VSS.n725 VSS.n155 11.5205
R1402 VSS.n730 VSS.n155 11.5205
R1403 VSS.n730 VSS.n146 11.5205
R1404 VSS.n742 VSS.n146 11.5205
R1405 VSS.n742 VSS.n143 11.5205
R1406 VSS.n746 VSS.n143 11.5205
R1407 VSS.n746 VSS.n132 11.5205
R1408 VSS.n758 VSS.n132 11.5205
R1409 VSS.n758 VSS.n129 11.5205
R1410 VSS.n762 VSS.n129 11.5205
R1411 VSS.n762 VSS.n120 11.5205
R1412 VSS.n775 VSS.n120 11.5205
R1413 VSS.n775 VSS.n117 11.5205
R1414 VSS.n780 VSS.n117 11.5205
R1415 VSS.n780 VSS.n108 11.5205
R1416 VSS.n793 VSS.n108 11.5205
R1417 VSS.n793 VSS.n105 11.5205
R1418 VSS.n798 VSS.n105 11.5205
R1419 VSS.n798 VSS.n96 11.5205
R1420 VSS.n809 VSS.n96 11.5205
R1421 VSS.n809 VSS.n93 11.5205
R1422 VSS.n814 VSS.n93 11.5205
R1423 VSS.n814 VSS.n82 11.5205
R1424 VSS.n826 VSS.n82 11.5205
R1425 VSS.n826 VSS.n79 11.5205
R1426 VSS.n831 VSS.n79 11.5205
R1427 VSS.n831 VSS.n69 11.5205
R1428 VSS.n843 VSS.n69 11.5205
R1429 VSS.n843 VSS.n67 11.5205
R1430 VSS.n849 VSS.n67 11.5205
R1431 VSS.n849 VSS.n58 11.5205
R1432 VSS.n862 VSS.n58 11.5205
R1433 VSS.n862 VSS.n56 11.5205
R1434 VSS.n868 VSS.n56 11.5205
R1435 VSS.n868 VSS.n45 11.5205
R1436 VSS.n882 VSS.n45 11.5205
R1437 VSS.n882 VSS.n43 11.5205
R1438 VSS.n887 VSS.n43 11.5205
R1439 VSS.n887 VSS.n12 11.5205
R1440 VSS.n1009 VSS.n12 11.5205
R1441 VSS.n375 VSS.n332 11.5205
R1442 VSS.n375 VSS.n372 11.5205
R1443 VSS.n379 VSS.n372 11.5205
R1444 VSS.n379 VSS.n370 11.5205
R1445 VSS.n385 VSS.n370 11.5205
R1446 VSS.n385 VSS.n368 11.5205
R1447 VSS.n389 VSS.n368 11.5205
R1448 VSS.n389 VSS.n366 11.5205
R1449 VSS.n395 VSS.n366 11.5205
R1450 VSS.n395 VSS.n364 11.5205
R1451 VSS.n399 VSS.n364 11.5205
R1452 VSS.n399 VSS.n362 11.5205
R1453 VSS.n405 VSS.n362 11.5205
R1454 VSS.n405 VSS.n360 11.5205
R1455 VSS.n409 VSS.n360 11.5205
R1456 VSS.n409 VSS.n358 11.5205
R1457 VSS.n415 VSS.n358 11.5205
R1458 VSS.n415 VSS.n356 11.5205
R1459 VSS.n419 VSS.n356 11.5205
R1460 VSS.n419 VSS.n354 11.5205
R1461 VSS.n425 VSS.n354 11.5205
R1462 VSS.n425 VSS.n352 11.5205
R1463 VSS.n429 VSS.n352 11.5205
R1464 VSS.n429 VSS.n350 11.5205
R1465 VSS.n435 VSS.n350 11.5205
R1466 VSS.n435 VSS.n348 11.5205
R1467 VSS.n439 VSS.n348 11.5205
R1468 VSS.n439 VSS.n346 11.5205
R1469 VSS.n445 VSS.n346 11.5205
R1470 VSS.n445 VSS.n344 11.5205
R1471 VSS.n449 VSS.n344 11.5205
R1472 VSS.n449 VSS.n342 11.5205
R1473 VSS.n455 VSS.n342 11.5205
R1474 VSS.n455 VSS.n340 11.5205
R1475 VSS.n459 VSS.n340 11.5205
R1476 VSS.n459 VSS.n338 11.5205
R1477 VSS.n465 VSS.n338 11.5205
R1478 VSS.n465 VSS.n336 11.5205
R1479 VSS.n583 VSS.t93 9.55188
R1480 VSS.t90 VSS.n240 9.55188
R1481 VSS.n609 VSS.t89 9.55188
R1482 VSS.n764 VSS.t85 9.55188
R1483 VSS.t82 VSS.n782 9.55188
R1484 VSS.n791 VSS.t81 9.55188
R1485 VSS.n474 VSS.n473 9.3005
R1486 VSS.n469 VSS.n468 9.3005
R1487 VSS.n187 VSS.n186 9.3005
R1488 VSS.n182 VSS.n181 9.3005
R1489 VSS.n690 VSS.n689 9.3005
R1490 VSS.n685 VSS.n684 9.3005
R1491 VSS.n7 VSS.n6 9.3005
R1492 VSS.n2 VSS.n1 9.3005
R1493 VSS.n332 VSS.n331 9.3005
R1494 VSS.n376 VSS.n375 9.3005
R1495 VSS.n377 VSS.n372 9.3005
R1496 VSS.n379 VSS.n378 9.3005
R1497 VSS.n370 VSS.n369 9.3005
R1498 VSS.n386 VSS.n385 9.3005
R1499 VSS.n387 VSS.n368 9.3005
R1500 VSS.n389 VSS.n388 9.3005
R1501 VSS.n366 VSS.n365 9.3005
R1502 VSS.n396 VSS.n395 9.3005
R1503 VSS.n397 VSS.n364 9.3005
R1504 VSS.n399 VSS.n398 9.3005
R1505 VSS.n362 VSS.n361 9.3005
R1506 VSS.n406 VSS.n405 9.3005
R1507 VSS.n407 VSS.n360 9.3005
R1508 VSS.n409 VSS.n408 9.3005
R1509 VSS.n358 VSS.n357 9.3005
R1510 VSS.n416 VSS.n415 9.3005
R1511 VSS.n417 VSS.n356 9.3005
R1512 VSS.n419 VSS.n418 9.3005
R1513 VSS.n354 VSS.n353 9.3005
R1514 VSS.n426 VSS.n425 9.3005
R1515 VSS.n427 VSS.n352 9.3005
R1516 VSS.n429 VSS.n428 9.3005
R1517 VSS.n350 VSS.n349 9.3005
R1518 VSS.n436 VSS.n435 9.3005
R1519 VSS.n437 VSS.n348 9.3005
R1520 VSS.n439 VSS.n438 9.3005
R1521 VSS.n346 VSS.n345 9.3005
R1522 VSS.n446 VSS.n445 9.3005
R1523 VSS.n447 VSS.n344 9.3005
R1524 VSS.n449 VSS.n448 9.3005
R1525 VSS.n342 VSS.n341 9.3005
R1526 VSS.n456 VSS.n455 9.3005
R1527 VSS.n457 VSS.n340 9.3005
R1528 VSS.n459 VSS.n458 9.3005
R1529 VSS.n338 VSS.n337 9.3005
R1530 VSS.n466 VSS.n465 9.3005
R1531 VSS.n467 VSS.n336 9.3005
R1532 VSS.n485 VSS.n484 9.3005
R1533 VSS.n486 VSS.n330 9.3005
R1534 VSS.n488 VSS.n487 9.3005
R1535 VSS.n320 VSS.n319 9.3005
R1536 VSS.n501 VSS.n500 9.3005
R1537 VSS.n502 VSS.n318 9.3005
R1538 VSS.n504 VSS.n503 9.3005
R1539 VSS.n307 VSS.n306 9.3005
R1540 VSS.n518 VSS.n517 9.3005
R1541 VSS.n519 VSS.n305 9.3005
R1542 VSS.n521 VSS.n520 9.3005
R1543 VSS.n294 VSS.n293 9.3005
R1544 VSS.n535 VSS.n534 9.3005
R1545 VSS.n536 VSS.n292 9.3005
R1546 VSS.n538 VSS.n537 9.3005
R1547 VSS.n282 VSS.n281 9.3005
R1548 VSS.n553 VSS.n552 9.3005
R1549 VSS.n554 VSS.n280 9.3005
R1550 VSS.n556 VSS.n555 9.3005
R1551 VSS.n270 VSS.n269 9.3005
R1552 VSS.n570 VSS.n569 9.3005
R1553 VSS.n571 VSS.n268 9.3005
R1554 VSS.n573 VSS.n572 9.3005
R1555 VSS.n257 VSS.n256 9.3005
R1556 VSS.n587 VSS.n586 9.3005
R1557 VSS.n588 VSS.n255 9.3005
R1558 VSS.n590 VSS.n589 9.3005
R1559 VSS.n245 VSS.n244 9.3005
R1560 VSS.n604 VSS.n603 9.3005
R1561 VSS.n605 VSS.n243 9.3005
R1562 VSS.n607 VSS.n606 9.3005
R1563 VSS.n232 VSS.n231 9.3005
R1564 VSS.n621 VSS.n620 9.3005
R1565 VSS.n622 VSS.n230 9.3005
R1566 VSS.n624 VSS.n623 9.3005
R1567 VSS.n221 VSS.n220 9.3005
R1568 VSS.n640 VSS.n639 9.3005
R1569 VSS.n641 VSS.n219 9.3005
R1570 VSS.n643 VSS.n642 9.3005
R1571 VSS.n210 VSS.n209 9.3005
R1572 VSS.n658 VSS.n657 9.3005
R1573 VSS.n659 VSS.n208 9.3005
R1574 VSS.n661 VSS.n660 9.3005
R1575 VSS.n198 VSS.n197 9.3005
R1576 VSS.n674 VSS.n673 9.3005
R1577 VSS.n675 VSS.n196 9.3005
R1578 VSS.n677 VSS.n676 9.3005
R1579 VSS.n176 VSS.n175 9.3005
R1580 VSS.n702 VSS.n701 9.3005
R1581 VSS.n703 VSS.n174 9.3005
R1582 VSS.n705 VSS.n704 9.3005
R1583 VSS.n164 VSS.n163 9.3005
R1584 VSS.n718 VSS.n717 9.3005
R1585 VSS.n719 VSS.n162 9.3005
R1586 VSS.n721 VSS.n720 9.3005
R1587 VSS.n152 VSS.n151 9.3005
R1588 VSS.n735 VSS.n734 9.3005
R1589 VSS.n736 VSS.n150 9.3005
R1590 VSS.n738 VSS.n737 9.3005
R1591 VSS.n139 VSS.n138 9.3005
R1592 VSS.n751 VSS.n750 9.3005
R1593 VSS.n752 VSS.n137 9.3005
R1594 VSS.n754 VSS.n753 9.3005
R1595 VSS.n126 VSS.n125 9.3005
R1596 VSS.n768 VSS.n767 9.3005
R1597 VSS.n769 VSS.n124 9.3005
R1598 VSS.n771 VSS.n770 9.3005
R1599 VSS.n114 VSS.n113 9.3005
R1600 VSS.n786 VSS.n785 9.3005
R1601 VSS.n787 VSS.n112 9.3005
R1602 VSS.n789 VSS.n788 9.3005
R1603 VSS.n102 VSS.n101 9.3005
R1604 VSS.n802 VSS.n801 9.3005
R1605 VSS.n803 VSS.n100 9.3005
R1606 VSS.n805 VSS.n804 9.3005
R1607 VSS.n89 VSS.n88 9.3005
R1608 VSS.n819 VSS.n818 9.3005
R1609 VSS.n820 VSS.n87 9.3005
R1610 VSS.n822 VSS.n821 9.3005
R1611 VSS.n76 VSS.n75 9.3005
R1612 VSS.n836 VSS.n835 9.3005
R1613 VSS.n837 VSS.n74 9.3005
R1614 VSS.n839 VSS.n838 9.3005
R1615 VSS.n64 VSS.n63 9.3005
R1616 VSS.n855 VSS.n854 9.3005
R1617 VSS.n856 VSS.n62 9.3005
R1618 VSS.n858 VSS.n857 9.3005
R1619 VSS.n53 VSS.n52 9.3005
R1620 VSS.n874 VSS.n873 9.3005
R1621 VSS.n875 VSS.n50 9.3005
R1622 VSS.n878 VSS.n877 9.3005
R1623 VSS.n876 VSS.n51 9.3005
R1624 VSS.n40 VSS.n39 9.3005
R1625 VSS.n893 VSS.n892 9.3005
R1626 VSS.n894 VSS.n37 9.3005
R1627 VSS.n1008 VSS.n0 9.3005
R1628 VSS.n947 VSS.n14 9.3005
R1629 VSS.n949 VSS.n948 9.3005
R1630 VSS.n950 VSS.n943 9.3005
R1631 VSS.n952 VSS.n951 9.3005
R1632 VSS.n953 VSS.n942 9.3005
R1633 VSS.n955 VSS.n954 9.3005
R1634 VSS.n956 VSS.n937 9.3005
R1635 VSS.n958 VSS.n957 9.3005
R1636 VSS.n959 VSS.n936 9.3005
R1637 VSS.n961 VSS.n960 9.3005
R1638 VSS.n962 VSS.n931 9.3005
R1639 VSS.n964 VSS.n963 9.3005
R1640 VSS.n965 VSS.n930 9.3005
R1641 VSS.n967 VSS.n966 9.3005
R1642 VSS.n968 VSS.n925 9.3005
R1643 VSS.n970 VSS.n969 9.3005
R1644 VSS.n971 VSS.n924 9.3005
R1645 VSS.n973 VSS.n972 9.3005
R1646 VSS.n974 VSS.n919 9.3005
R1647 VSS.n976 VSS.n975 9.3005
R1648 VSS.n977 VSS.n918 9.3005
R1649 VSS.n979 VSS.n978 9.3005
R1650 VSS.n980 VSS.n913 9.3005
R1651 VSS.n982 VSS.n981 9.3005
R1652 VSS.n983 VSS.n912 9.3005
R1653 VSS.n985 VSS.n984 9.3005
R1654 VSS.n986 VSS.n907 9.3005
R1655 VSS.n988 VSS.n987 9.3005
R1656 VSS.n989 VSS.n906 9.3005
R1657 VSS.n991 VSS.n990 9.3005
R1658 VSS.n992 VSS.n901 9.3005
R1659 VSS.n994 VSS.n993 9.3005
R1660 VSS.n995 VSS.n900 9.3005
R1661 VSS.n997 VSS.n996 9.3005
R1662 VSS.n998 VSS.n895 9.3005
R1663 VSS.n1000 VSS.n999 9.3005
R1664 VSS.n1001 VSS.n38 9.3005
R1665 VSS.n1003 VSS.n1002 9.3005
R1666 VSS.n1010 VSS.n1009 9.3005
R1667 VSS.n885 VSS.n12 9.3005
R1668 VSS.n887 VSS.n886 9.3005
R1669 VSS.n884 VSS.n43 9.3005
R1670 VSS.n883 VSS.n882 9.3005
R1671 VSS.n45 VSS.n44 9.3005
R1672 VSS.n868 VSS.n867 9.3005
R1673 VSS.n864 VSS.n56 9.3005
R1674 VSS.n863 VSS.n862 9.3005
R1675 VSS.n58 VSS.n57 9.3005
R1676 VSS.n849 VSS.n848 9.3005
R1677 VSS.n845 VSS.n67 9.3005
R1678 VSS.n844 VSS.n843 9.3005
R1679 VSS.n69 VSS.n68 9.3005
R1680 VSS.n831 VSS.n830 9.3005
R1681 VSS.n828 VSS.n79 9.3005
R1682 VSS.n827 VSS.n826 9.3005
R1683 VSS.n82 VSS.n81 9.3005
R1684 VSS.n814 VSS.n813 9.3005
R1685 VSS.n811 VSS.n93 9.3005
R1686 VSS.n810 VSS.n809 9.3005
R1687 VSS.n96 VSS.n95 9.3005
R1688 VSS.n798 VSS.n797 9.3005
R1689 VSS.n796 VSS.n105 9.3005
R1690 VSS.n794 VSS.n793 9.3005
R1691 VSS.n108 VSS.n107 9.3005
R1692 VSS.n780 VSS.n779 9.3005
R1693 VSS.n778 VSS.n117 9.3005
R1694 VSS.n776 VSS.n775 9.3005
R1695 VSS.n120 VSS.n119 9.3005
R1696 VSS.n762 VSS.n761 9.3005
R1697 VSS.n760 VSS.n129 9.3005
R1698 VSS.n759 VSS.n758 9.3005
R1699 VSS.n132 VSS.n131 9.3005
R1700 VSS.n746 VSS.n745 9.3005
R1701 VSS.n744 VSS.n143 9.3005
R1702 VSS.n743 VSS.n742 9.3005
R1703 VSS.n728 VSS.n146 9.3005
R1704 VSS.n730 VSS.n729 9.3005
R1705 VSS.n727 VSS.n155 9.3005
R1706 VSS.n726 VSS.n725 9.3005
R1707 VSS.n712 VSS.n158 9.3005
R1708 VSS.n714 VSS.n713 9.3005
R1709 VSS.n711 VSS.n168 9.3005
R1710 VSS.n710 VSS.n709 9.3005
R1711 VSS.n170 VSS.n169 9.3005
R1712 VSS.n696 VSS.n695 9.3005
R1713 VSS.n683 VSS.n180 9.3005
R1714 VSS.n682 VSS.n681 9.3005
R1715 VSS.n667 VSS.n192 9.3005
R1716 VSS.n669 VSS.n668 9.3005
R1717 VSS.n666 VSS.n201 9.3005
R1718 VSS.n665 VSS.n664 9.3005
R1719 VSS.n203 VSS.n202 9.3005
R1720 VSS.n653 VSS.n652 9.3005
R1721 VSS.n649 VSS.n213 9.3005
R1722 VSS.n648 VSS.n647 9.3005
R1723 VSS.n215 VSS.n214 9.3005
R1724 VSS.n634 VSS.n633 9.3005
R1725 VSS.n630 VSS.n224 9.3005
R1726 VSS.n629 VSS.n628 9.3005
R1727 VSS.n226 VSS.n225 9.3005
R1728 VSS.n615 VSS.n614 9.3005
R1729 VSS.n613 VSS.n235 9.3005
R1730 VSS.n612 VSS.n611 9.3005
R1731 VSS.n238 VSS.n237 9.3005
R1732 VSS.n599 VSS.n598 9.3005
R1733 VSS.n596 VSS.n248 9.3005
R1734 VSS.n595 VSS.n594 9.3005
R1735 VSS.n251 VSS.n250 9.3005
R1736 VSS.n581 VSS.n580 9.3005
R1737 VSS.n578 VSS.n260 9.3005
R1738 VSS.n577 VSS.n576 9.3005
R1739 VSS.n263 VSS.n262 9.3005
R1740 VSS.n565 VSS.n564 9.3005
R1741 VSS.n563 VSS.n273 9.3005
R1742 VSS.n561 VSS.n560 9.3005
R1743 VSS.n276 VSS.n275 9.3005
R1744 VSS.n547 VSS.n546 9.3005
R1745 VSS.n545 VSS.n285 9.3005
R1746 VSS.n543 VSS.n542 9.3005
R1747 VSS.n288 VSS.n287 9.3005
R1748 VSS.n529 VSS.n528 9.3005
R1749 VSS.n527 VSS.n298 9.3005
R1750 VSS.n526 VSS.n525 9.3005
R1751 VSS.n511 VSS.n301 9.3005
R1752 VSS.n513 VSS.n512 9.3005
R1753 VSS.n510 VSS.n311 9.3005
R1754 VSS.n509 VSS.n508 9.3005
R1755 VSS.n494 VSS.n314 9.3005
R1756 VSS.n496 VSS.n495 9.3005
R1757 VSS.n493 VSS.n324 9.3005
R1758 VSS.n492 VSS.n491 9.3005
R1759 VSS.n326 VSS.n325 9.3005
R1760 VSS.n480 VSS.n479 9.3005
R1761 VSS.n476 VSS.n469 9.2683
R1762 VSS.n189 VSS.n182 9.2683
R1763 VSS.n692 VSS.n685 9.2683
R1764 VSS.n9 VSS.n2 9.2683
R1765 VSS.t70 VSS.n296 8.49061
R1766 VSS.n531 VSS.t68 8.49061
R1767 VSS.n584 VSS.t94 8.49061
R1768 VSS.t52 VSS.n241 8.49061
R1769 VSS.n617 VSS.t50 8.49061
R1770 VSS.t28 VSS.n134 8.49061
R1771 VSS.n135 VSS.t26 8.49061
R1772 VSS.n765 VSS.t86 8.49061
R1773 VSS.t10 VSS.n71 8.49061
R1774 VSS.n72 VSS.t8 8.49061
R1775 VSS.n472 VSS.n471 6.31055
R1776 VSS.n185 VSS.n184 6.31055
R1777 VSS.n688 VSS.n687 6.31055
R1778 VSS.n5 VSS.n4 6.31055
R1779 VSS.n236 VSS.t53 6.0005
R1780 VSS.n236 VSS.t51 6.0005
R1781 VSS.n130 VSS.t29 6.0005
R1782 VSS.n130 VSS.t27 6.0005
R1783 VSS.n312 VSS.t77 6.0005
R1784 VSS.n312 VSS.t75 6.0005
R1785 VSS.n299 VSS.t73 6.0005
R1786 VSS.n299 VSS.t71 6.0005
R1787 VSS.n286 VSS.t69 6.0005
R1788 VSS.n286 VSS.t67 6.0005
R1789 VSS.n274 VSS.t65 6.0005
R1790 VSS.n274 VSS.t63 6.0005
R1791 VSS.n261 VSS.t61 6.0005
R1792 VSS.n261 VSS.t59 6.0005
R1793 VSS.n249 VSS.t57 6.0005
R1794 VSS.n249 VSS.t55 6.0005
R1795 VSS.n631 VSS.t49 6.0005
R1796 VSS.n631 VSS.t47 6.0005
R1797 VSS.n650 VSS.t45 6.0005
R1798 VSS.n650 VSS.t43 6.0005
R1799 VSS.n156 VSS.t37 6.0005
R1800 VSS.n156 VSS.t35 6.0005
R1801 VSS.n144 VSS.t33 6.0005
R1802 VSS.n144 VSS.t31 6.0005
R1803 VSS.n118 VSS.t25 6.0005
R1804 VSS.n118 VSS.t23 6.0005
R1805 VSS.n106 VSS.t21 6.0005
R1806 VSS.n106 VSS.t19 6.0005
R1807 VSS.n94 VSS.t17 6.0005
R1808 VSS.n94 VSS.t15 6.0005
R1809 VSS.n80 VSS.t13 6.0005
R1810 VSS.n80 VSS.t11 6.0005
R1811 VSS.n846 VSS.t9 6.0005
R1812 VSS.n846 VSS.t7 6.0005
R1813 VSS.n865 VSS.t5 6.0005
R1814 VSS.n865 VSS.t3 6.0005
R1815 VSS.t92 VSS.t56 5.30682
R1816 VSS.t110 VSS.t44 5.30682
R1817 VSS.t34 VSS.t101 5.30682
R1818 VSS.t22 VSS.t83 5.30682
R1819 VSS.t109 VSS.n205 3.18429
R1820 VSS.n166 VSS.t102 3.18429
R1821 VSS.n740 VSS.t98 3.18429
R1822 VSS.n637 VSS.t113 2.12303
R1823 VSS.n473 VSS.n472 1.16652
R1824 VSS.n186 VSS.n185 1.16652
R1825 VSS.n689 VSS.n688 1.16652
R1826 VSS.n6 VSS.n5 1.16652
R1827 VSS.n485 VSS.n331 0.298938
R1828 VSS.n1002 VSS.n894 0.298938
R1829 VSS.n478 VSS.n477 0.296333
R1830 VSS.n191 VSS.n190 0.296333
R1831 VSS.n694 VSS.n693 0.296333
R1832 VSS.n11 VSS.n10 0.296333
R1833 VSS.n479 VSS.n467 0.180516
R1834 VSS.n1012 VSS 0.15675
R1835 VSS.n473 VSS.n468 0.1505
R1836 VSS.n477 VSS.n468 0.1505
R1837 VSS.n186 VSS.n181 0.1505
R1838 VSS.n190 VSS.n181 0.1505
R1839 VSS.n689 VSS.n684 0.1505
R1840 VSS.n693 VSS.n684 0.1505
R1841 VSS.n6 VSS.n1 0.1505
R1842 VSS.n10 VSS.n1 0.1505
R1843 VSS.n1011 VSS.n0 0.148938
R1844 VSS.n376 VSS.n331 0.113
R1845 VSS.n377 VSS.n376 0.113
R1846 VSS.n378 VSS.n377 0.113
R1847 VSS.n378 VSS.n369 0.113
R1848 VSS.n386 VSS.n369 0.113
R1849 VSS.n387 VSS.n386 0.113
R1850 VSS.n388 VSS.n387 0.113
R1851 VSS.n388 VSS.n365 0.113
R1852 VSS.n396 VSS.n365 0.113
R1853 VSS.n397 VSS.n396 0.113
R1854 VSS.n398 VSS.n397 0.113
R1855 VSS.n398 VSS.n361 0.113
R1856 VSS.n406 VSS.n361 0.113
R1857 VSS.n407 VSS.n406 0.113
R1858 VSS.n408 VSS.n407 0.113
R1859 VSS.n408 VSS.n357 0.113
R1860 VSS.n416 VSS.n357 0.113
R1861 VSS.n417 VSS.n416 0.113
R1862 VSS.n418 VSS.n417 0.113
R1863 VSS.n418 VSS.n353 0.113
R1864 VSS.n426 VSS.n353 0.113
R1865 VSS.n427 VSS.n426 0.113
R1866 VSS.n428 VSS.n427 0.113
R1867 VSS.n428 VSS.n349 0.113
R1868 VSS.n436 VSS.n349 0.113
R1869 VSS.n437 VSS.n436 0.113
R1870 VSS.n438 VSS.n437 0.113
R1871 VSS.n438 VSS.n345 0.113
R1872 VSS.n446 VSS.n345 0.113
R1873 VSS.n447 VSS.n446 0.113
R1874 VSS.n448 VSS.n447 0.113
R1875 VSS.n448 VSS.n341 0.113
R1876 VSS.n456 VSS.n341 0.113
R1877 VSS.n457 VSS.n456 0.113
R1878 VSS.n458 VSS.n457 0.113
R1879 VSS.n458 VSS.n337 0.113
R1880 VSS.n466 VSS.n337 0.113
R1881 VSS.n467 VSS.n466 0.113
R1882 VSS.n486 VSS.n485 0.113
R1883 VSS.n487 VSS.n486 0.113
R1884 VSS.n487 VSS.n319 0.113
R1885 VSS.n501 VSS.n319 0.113
R1886 VSS.n502 VSS.n501 0.113
R1887 VSS.n503 VSS.n502 0.113
R1888 VSS.n503 VSS.n306 0.113
R1889 VSS.n518 VSS.n306 0.113
R1890 VSS.n519 VSS.n518 0.113
R1891 VSS.n520 VSS.n519 0.113
R1892 VSS.n520 VSS.n293 0.113
R1893 VSS.n535 VSS.n293 0.113
R1894 VSS.n536 VSS.n535 0.113
R1895 VSS.n537 VSS.n536 0.113
R1896 VSS.n537 VSS.n281 0.113
R1897 VSS.n553 VSS.n281 0.113
R1898 VSS.n554 VSS.n553 0.113
R1899 VSS.n555 VSS.n554 0.113
R1900 VSS.n555 VSS.n269 0.113
R1901 VSS.n570 VSS.n269 0.113
R1902 VSS.n571 VSS.n570 0.113
R1903 VSS.n572 VSS.n571 0.113
R1904 VSS.n572 VSS.n256 0.113
R1905 VSS.n587 VSS.n256 0.113
R1906 VSS.n588 VSS.n587 0.113
R1907 VSS.n589 VSS.n588 0.113
R1908 VSS.n589 VSS.n244 0.113
R1909 VSS.n604 VSS.n244 0.113
R1910 VSS.n605 VSS.n604 0.113
R1911 VSS.n606 VSS.n605 0.113
R1912 VSS.n606 VSS.n231 0.113
R1913 VSS.n621 VSS.n231 0.113
R1914 VSS.n622 VSS.n621 0.113
R1915 VSS.n623 VSS.n622 0.113
R1916 VSS.n623 VSS.n220 0.113
R1917 VSS.n640 VSS.n220 0.113
R1918 VSS.n641 VSS.n640 0.113
R1919 VSS.n642 VSS.n641 0.113
R1920 VSS.n642 VSS.n209 0.113
R1921 VSS.n658 VSS.n209 0.113
R1922 VSS.n659 VSS.n658 0.113
R1923 VSS.n660 VSS.n659 0.113
R1924 VSS.n660 VSS.n197 0.113
R1925 VSS.n674 VSS.n197 0.113
R1926 VSS.n675 VSS.n674 0.113
R1927 VSS.n676 VSS.n675 0.113
R1928 VSS.n676 VSS.n175 0.113
R1929 VSS.n702 VSS.n175 0.113
R1930 VSS.n703 VSS.n702 0.113
R1931 VSS.n704 VSS.n703 0.113
R1932 VSS.n704 VSS.n163 0.113
R1933 VSS.n718 VSS.n163 0.113
R1934 VSS.n719 VSS.n718 0.113
R1935 VSS.n720 VSS.n719 0.113
R1936 VSS.n720 VSS.n151 0.113
R1937 VSS.n735 VSS.n151 0.113
R1938 VSS.n736 VSS.n735 0.113
R1939 VSS.n737 VSS.n736 0.113
R1940 VSS.n737 VSS.n138 0.113
R1941 VSS.n751 VSS.n138 0.113
R1942 VSS.n752 VSS.n751 0.113
R1943 VSS.n753 VSS.n752 0.113
R1944 VSS.n753 VSS.n125 0.113
R1945 VSS.n768 VSS.n125 0.113
R1946 VSS.n769 VSS.n768 0.113
R1947 VSS.n770 VSS.n769 0.113
R1948 VSS.n770 VSS.n113 0.113
R1949 VSS.n786 VSS.n113 0.113
R1950 VSS.n787 VSS.n786 0.113
R1951 VSS.n788 VSS.n787 0.113
R1952 VSS.n788 VSS.n101 0.113
R1953 VSS.n802 VSS.n101 0.113
R1954 VSS.n803 VSS.n802 0.113
R1955 VSS.n804 VSS.n803 0.113
R1956 VSS.n804 VSS.n88 0.113
R1957 VSS.n819 VSS.n88 0.113
R1958 VSS.n820 VSS.n819 0.113
R1959 VSS.n821 VSS.n820 0.113
R1960 VSS.n821 VSS.n75 0.113
R1961 VSS.n836 VSS.n75 0.113
R1962 VSS.n837 VSS.n836 0.113
R1963 VSS.n838 VSS.n837 0.113
R1964 VSS.n838 VSS.n63 0.113
R1965 VSS.n855 VSS.n63 0.113
R1966 VSS.n856 VSS.n855 0.113
R1967 VSS.n857 VSS.n856 0.113
R1968 VSS.n857 VSS.n52 0.113
R1969 VSS.n874 VSS.n52 0.113
R1970 VSS.n875 VSS.n874 0.113
R1971 VSS.n877 VSS.n875 0.113
R1972 VSS.n877 VSS.n876 0.113
R1973 VSS.n876 VSS.n39 0.113
R1974 VSS.n893 VSS.n39 0.113
R1975 VSS.n894 VSS.n893 0.113
R1976 VSS.n1002 VSS.n1001 0.113
R1977 VSS.n1001 VSS.n1000 0.113
R1978 VSS.n1000 VSS.n895 0.113
R1979 VSS.n996 VSS.n895 0.113
R1980 VSS.n996 VSS.n995 0.113
R1981 VSS.n995 VSS.n994 0.113
R1982 VSS.n994 VSS.n901 0.113
R1983 VSS.n990 VSS.n901 0.113
R1984 VSS.n990 VSS.n989 0.113
R1985 VSS.n989 VSS.n988 0.113
R1986 VSS.n988 VSS.n907 0.113
R1987 VSS.n984 VSS.n907 0.113
R1988 VSS.n984 VSS.n983 0.113
R1989 VSS.n983 VSS.n982 0.113
R1990 VSS.n982 VSS.n913 0.113
R1991 VSS.n978 VSS.n913 0.113
R1992 VSS.n978 VSS.n977 0.113
R1993 VSS.n977 VSS.n976 0.113
R1994 VSS.n976 VSS.n919 0.113
R1995 VSS.n972 VSS.n919 0.113
R1996 VSS.n972 VSS.n971 0.113
R1997 VSS.n971 VSS.n970 0.113
R1998 VSS.n970 VSS.n925 0.113
R1999 VSS.n966 VSS.n925 0.113
R2000 VSS.n966 VSS.n965 0.113
R2001 VSS.n965 VSS.n964 0.113
R2002 VSS.n964 VSS.n931 0.113
R2003 VSS.n960 VSS.n931 0.113
R2004 VSS.n960 VSS.n959 0.113
R2005 VSS.n959 VSS.n958 0.113
R2006 VSS.n958 VSS.n937 0.113
R2007 VSS.n954 VSS.n937 0.113
R2008 VSS.n954 VSS.n953 0.113
R2009 VSS.n953 VSS.n952 0.113
R2010 VSS.n952 VSS.n943 0.113
R2011 VSS.n948 VSS.n943 0.113
R2012 VSS.n948 VSS.n947 0.113
R2013 VSS.n947 VSS.n0 0.113
R2014 VSS VSS.n1012 0.0399737
R2015 VSS.n1011 VSS.n1010 0.0320789
R2016 VSS.n492 VSS.n325 0.0241842
R2017 VSS.n493 VSS.n492 0.0241842
R2018 VSS.n495 VSS.n493 0.0241842
R2019 VSS.n495 VSS.n494 0.0241842
R2020 VSS.n510 VSS.n509 0.0241842
R2021 VSS.n512 VSS.n510 0.0241842
R2022 VSS.n512 VSS.n511 0.0241842
R2023 VSS.n527 VSS.n526 0.0241842
R2024 VSS.n528 VSS.n527 0.0241842
R2025 VSS.n528 VSS.n287 0.0241842
R2026 VSS.n543 VSS.n287 0.0241842
R2027 VSS.n546 VSS.n545 0.0241842
R2028 VSS.n546 VSS.n275 0.0241842
R2029 VSS.n561 VSS.n275 0.0241842
R2030 VSS.n564 VSS.n563 0.0241842
R2031 VSS.n564 VSS.n262 0.0241842
R2032 VSS.n577 VSS.n262 0.0241842
R2033 VSS.n578 VSS.n577 0.0241842
R2034 VSS.n580 VSS.n250 0.0241842
R2035 VSS.n595 VSS.n250 0.0241842
R2036 VSS.n596 VSS.n595 0.0241842
R2037 VSS.n598 VSS.n237 0.0241842
R2038 VSS.n612 VSS.n237 0.0241842
R2039 VSS.n613 VSS.n612 0.0241842
R2040 VSS.n614 VSS.n613 0.0241842
R2041 VSS.n614 VSS.n225 0.0241842
R2042 VSS.n629 VSS.n225 0.0241842
R2043 VSS.n630 VSS.n629 0.0241842
R2044 VSS.n633 VSS.n630 0.0241842
R2045 VSS.n648 VSS.n214 0.0241842
R2046 VSS.n649 VSS.n648 0.0241842
R2047 VSS.n652 VSS.n649 0.0241842
R2048 VSS.n665 VSS.n202 0.0241842
R2049 VSS.n666 VSS.n665 0.0241842
R2050 VSS.n668 VSS.n666 0.0241842
R2051 VSS.n668 VSS.n667 0.0241842
R2052 VSS.n683 VSS.n682 0.0241842
R2053 VSS.n695 VSS.n683 0.0241842
R2054 VSS.n710 VSS.n169 0.0241842
R2055 VSS.n711 VSS.n710 0.0241842
R2056 VSS.n713 VSS.n711 0.0241842
R2057 VSS.n713 VSS.n712 0.0241842
R2058 VSS.n727 VSS.n726 0.0241842
R2059 VSS.n729 VSS.n727 0.0241842
R2060 VSS.n729 VSS.n728 0.0241842
R2061 VSS.n744 VSS.n743 0.0241842
R2062 VSS.n745 VSS.n744 0.0241842
R2063 VSS.n745 VSS.n131 0.0241842
R2064 VSS.n759 VSS.n131 0.0241842
R2065 VSS.n760 VSS.n759 0.0241842
R2066 VSS.n761 VSS.n760 0.0241842
R2067 VSS.n761 VSS.n119 0.0241842
R2068 VSS.n776 VSS.n119 0.0241842
R2069 VSS.n779 VSS.n778 0.0241842
R2070 VSS.n779 VSS.n107 0.0241842
R2071 VSS.n794 VSS.n107 0.0241842
R2072 VSS.n797 VSS.n796 0.0241842
R2073 VSS.n797 VSS.n95 0.0241842
R2074 VSS.n810 VSS.n95 0.0241842
R2075 VSS.n811 VSS.n810 0.0241842
R2076 VSS.n813 VSS.n81 0.0241842
R2077 VSS.n827 VSS.n81 0.0241842
R2078 VSS.n828 VSS.n827 0.0241842
R2079 VSS.n830 VSS.n68 0.0241842
R2080 VSS.n844 VSS.n68 0.0241842
R2081 VSS.n845 VSS.n844 0.0241842
R2082 VSS.n848 VSS.n845 0.0241842
R2083 VSS.n863 VSS.n57 0.0241842
R2084 VSS.n864 VSS.n863 0.0241842
R2085 VSS.n867 VSS.n864 0.0241842
R2086 VSS.n883 VSS.n44 0.0241842
R2087 VSS.n884 VSS.n883 0.0241842
R2088 VSS.n886 VSS.n884 0.0241842
R2089 VSS.n886 VSS.n885 0.0241842
R2090 VSS.n479 VSS.n478 0.0215526
R2091 VSS.n580 VSS.n579 0.0215526
R2092 VSS.n652 VSS.n651 0.0215526
R2093 VSS.n726 VSS.n157 0.0215526
R2094 VSS.n795 VSS.n794 0.0215526
R2095 VSS.n1010 VSS.n11 0.0215526
R2096 VSS.n511 VSS.n300 0.0189211
R2097 VSS.n545 VSS.n544 0.0189211
R2098 VSS.n829 VSS.n828 0.0189211
R2099 VSS.n847 VSS.n57 0.0189211
R2100 VSS.n509 VSS.n313 0.0162895
R2101 VSS.n562 VSS.n561 0.0162895
R2102 VSS.n682 VSS.n191 0.0162895
R2103 VSS.n695 VSS.n694 0.0162895
R2104 VSS.n813 VSS.n812 0.0162895
R2105 VSS.n867 VSS.n866 0.0162895
R2106 VSS.n597 VSS.n596 0.0136579
R2107 VSS.n632 VSS.n214 0.0136579
R2108 VSS.n728 VSS.n145 0.0136579
R2109 VSS.n778 VSS.n777 0.0136579
R2110 VSS.n1012 VSS.n1011 0.0136579
R2111 VSS.n598 VSS.n597 0.0110263
R2112 VSS.n633 VSS.n632 0.0110263
R2113 VSS.n743 VSS.n145 0.0110263
R2114 VSS.n777 VSS.n776 0.0110263
R2115 VSS.n494 VSS.n313 0.00839474
R2116 VSS.n563 VSS.n562 0.00839474
R2117 VSS.n667 VSS.n191 0.00839474
R2118 VSS.n694 VSS.n169 0.00839474
R2119 VSS.n812 VSS.n811 0.00839474
R2120 VSS.n866 VSS.n44 0.00839474
R2121 VSS.n526 VSS.n300 0.00576316
R2122 VSS.n544 VSS.n543 0.00576316
R2123 VSS.n830 VSS.n829 0.00576316
R2124 VSS.n848 VSS.n847 0.00576316
R2125 VSS.n478 VSS.n325 0.00313158
R2126 VSS.n579 VSS.n578 0.00313158
R2127 VSS.n651 VSS.n202 0.00313158
R2128 VSS.n712 VSS.n157 0.00313158
R2129 VSS.n796 VSS.n795 0.00313158
R2130 VSS.n885 VSS.n11 0.00313158
C0 nb inn 0.09026f
C1 outp nb 0.15139f
C2 inp outn 1.59618f
C3 tail outn 14.5785f
C4 outn VDD 1.32683f
C5 inp tail 1.31292f
C6 inn outn 0.16323f
C7 outp outn 2.58466f
C8 inp VDD 0.53864f
C9 tail VDD 0.0077f
C10 inp inn 1.89027f
C11 inn tail 1.28748f
C12 inp outp 0.06069f
C13 outp tail 14.8521f
C14 inn VDD 0.618f
C15 outp VDD 0.34853f
C16 nb outn 0.14159f
C17 outp inn 1.22345f
C18 inp nb 0.08466f
C19 nb tail 7.61336f
C20 nb VDD 0
C21 nb VSS 17.58823f
C22 outp VSS 4.12551f
C23 outn VSS 4.29316f
C24 inn VSS 4.90422f
C25 inp VSS 4.55702f
C26 VDD VSS 12.54029f
C27 tail VSS 17.6523f
C28 VDD.t0 VSS 0.60387f
C29 VDD.t1 VSS 0.60387f
C30 VDD.n0 VSS 1.17541f
C31 inp.t0 VSS 0.09886f
C32 inp.t1 VSS 0.09105f
C33 inp.n0 VSS 0.21962f
C34 inp.t2 VSS 0.09885f
C35 inp.n1 VSS 0.11655f
C36 inp.t3 VSS 0.09105f
C37 inp.n2 VSS 0.09283f
C38 inp.t7 VSS 0.09105f
C39 inp.t6 VSS 0.09885f
C40 inp.n3 VSS 0.21997f
C41 inp.t5 VSS 0.09105f
C42 inp.n4 VSS 0.10874f
C43 inp.t4 VSS 0.09885f
C44 inp.n5 VSS 0.10099f
C45 inp.n6 VSS 0.43003f
C46 inp.t8 VSS 0.09886f
C47 inp.t9 VSS 0.09105f
C48 inp.n7 VSS 0.21962f
C49 inp.t10 VSS 0.09885f
C50 inp.n8 VSS 0.11655f
C51 inp.t11 VSS 0.09105f
C52 inp.n9 VSS 0.09283f
C53 inp.t15 VSS 0.09105f
C54 inp.t14 VSS 0.09885f
C55 inp.n10 VSS 0.21997f
C56 inp.t13 VSS 0.09105f
C57 inp.n11 VSS 0.10874f
C58 inp.t12 VSS 0.09885f
C59 inp.n12 VSS 0.10064f
C60 inp.n13 VSS 0.02172f
C61 inp.n14 VSS 1.02571f
C62 inn.t0 VSS 0.10179f
C63 inn.t1 VSS 0.09374f
C64 inn.n0 VSS 0.22612f
C65 inn.t2 VSS 0.10178f
C66 inn.n1 VSS 0.12f
C67 inn.t3 VSS 0.09374f
C68 inn.n2 VSS 0.11196f
C69 inn.t4 VSS 0.10178f
C70 inn.n3 VSS 0.12036f
C71 inn.t5 VSS 0.09374f
C72 inn.n4 VSS 0.11196f
C73 inn.t6 VSS 0.10178f
C74 inn.n5 VSS 0.12036f
C75 inn.t7 VSS 0.09374f
C76 inn.n6 VSS 0.13963f
C77 inn.t15 VSS 0.09375f
C78 inn.t14 VSS 0.10178f
C79 inn.n7 VSS 0.22649f
C80 inn.t13 VSS 0.09374f
C81 inn.n8 VSS 0.11196f
C82 inn.t12 VSS 0.10178f
C83 inn.n9 VSS 0.12036f
C84 inn.t11 VSS 0.09374f
C85 inn.n10 VSS 0.11196f
C86 inn.t10 VSS 0.10178f
C87 inn.n11 VSS 0.12f
C88 inn.t9 VSS 0.09374f
C89 inn.n12 VSS 0.11159f
C90 inn.t8 VSS 0.10178f
C91 inn.n13 VSS 0.14766f
C92 inn.n14 VSS 0.43302f
C93 outn.t16 VSS 2.73159f
C94 outn.t15 VSS 0.1187f
C95 outn.t14 VSS 0.1187f
C96 outn.n0 VSS 0.38991f
C97 outn.n1 VSS 2.29686f
C98 outn.t8 VSS 0.1187f
C99 outn.t2 VSS 0.1187f
C100 outn.n2 VSS 0.38991f
C101 outn.n3 VSS 0.61704f
C102 outn.t10 VSS 0.12265f
C103 outn.t3 VSS 0.11474f
C104 outn.n4 VSS 0.38991f
C105 outn.n5 VSS 0.61704f
C106 outn.t7 VSS 0.1187f
C107 outn.t5 VSS 0.1187f
C108 outn.n6 VSS 0.38991f
C109 outn.n7 VSS 1.64353f
C110 outn.t11 VSS 0.1187f
C111 outn.t13 VSS 0.1187f
C112 outn.n8 VSS 0.38991f
C113 outn.n9 VSS 1.64353f
C114 outn.t0 VSS 0.1187f
C115 outn.t9 VSS 0.1187f
C116 outn.n10 VSS 0.38991f
C117 outn.n11 VSS 0.61704f
C118 outn.t12 VSS 0.12265f
C119 outn.t1 VSS 0.11474f
C120 outn.n12 VSS 0.38991f
C121 outn.n13 VSS 0.61704f
C122 outn.t4 VSS 0.1187f
C123 outn.t6 VSS 0.1187f
C124 outn.n14 VSS 0.38991f
C125 outn.n15 VSS 2.13155f
C126 outp.t10 VSS 0.12313f
C127 outp.t0 VSS 0.12313f
C128 outp.n0 VSS 0.41145f
C129 outp.t8 VSS 0.12313f
C130 outp.t1 VSS 0.12313f
C131 outp.n1 VSS 0.40514f
C132 outp.n2 VSS 1.30257f
C133 outp.t5 VSS 0.12723f
C134 outp.t13 VSS 0.11902f
C135 outp.n3 VSS 0.40514f
C136 outp.n4 VSS 0.63942f
C137 outp.t7 VSS 0.12313f
C138 outp.t4 VSS 0.12313f
C139 outp.n5 VSS 0.40514f
C140 outp.n6 VSS 0.75861f
C141 outp.t2 VSS 0.12313f
C142 outp.t12 VSS 0.12313f
C143 outp.n7 VSS 0.40514f
C144 outp.n8 VSS 0.75861f
C145 outp.t11 VSS 0.12313f
C146 outp.t15 VSS 0.12313f
C147 outp.n9 VSS 0.40514f
C148 outp.n10 VSS 0.63942f
C149 outp.t3 VSS 0.12723f
C150 outp.t9 VSS 0.11902f
C151 outp.n11 VSS 0.40514f
C152 outp.n12 VSS 0.63942f
C153 outp.t6 VSS 0.12313f
C154 outp.t14 VSS 0.12313f
C155 outp.n13 VSS 0.40514f
C156 outp.n14 VSS 1.2924f
C157 outp.t16 VSS 1.86247f
C158 outp.n15 VSS 3.89962f
C159 nb.t0 VSS 0.1153f
C160 nb.n0 VSS 0.08658f
C161 nb.t1 VSS 0.10062f
C162 nb.n1 VSS 0.07726f
C163 nb.t2 VSS 0.1153f
C164 nb.n2 VSS 0.09036f
C165 nb.t3 VSS 0.10062f
C166 nb.n3 VSS 0.07947f
C167 nb.t4 VSS 0.1153f
C168 nb.n4 VSS 0.09036f
C169 nb.t5 VSS 0.10062f
C170 nb.n5 VSS 0.07947f
C171 nb.t6 VSS 0.1153f
C172 nb.n6 VSS 0.09036f
C173 nb.t7 VSS 0.10062f
C174 nb.n7 VSS 0.07947f
C175 nb.t8 VSS 0.1153f
C176 nb.n8 VSS 0.09036f
C177 nb.t9 VSS 0.10062f
C178 nb.n9 VSS 0.07947f
C179 nb.t10 VSS 0.1153f
C180 nb.n10 VSS 0.09036f
C181 nb.t11 VSS 0.10062f
C182 nb.n11 VSS 0.07947f
C183 nb.t12 VSS 0.1153f
C184 nb.n12 VSS 0.09036f
C185 nb.t13 VSS 0.10062f
C186 nb.n13 VSS 0.07947f
C187 nb.t14 VSS 0.1153f
C188 nb.n14 VSS 0.09036f
C189 nb.t15 VSS 0.10062f
C190 nb.n15 VSS 0.07947f
C191 nb.t16 VSS 0.1153f
C192 nb.n16 VSS 0.09036f
C193 nb.t17 VSS 0.10062f
C194 nb.n17 VSS 0.07947f
C195 nb.t18 VSS 0.1153f
C196 nb.n18 VSS 0.09036f
C197 nb.t19 VSS 0.10062f
C198 nb.n19 VSS 0.12023f
C199 nb.t20 VSS 0.1153f
C200 nb.n20 VSS 0.13112f
C201 nb.t21 VSS 0.10062f
C202 nb.n21 VSS 0.07947f
C203 nb.t22 VSS 0.1153f
C204 nb.n22 VSS 0.09036f
C205 nb.t23 VSS 0.10062f
C206 nb.n23 VSS 0.07947f
C207 nb.t24 VSS 0.1153f
C208 nb.n24 VSS 0.09036f
C209 nb.t25 VSS 0.10062f
C210 nb.n25 VSS 0.07947f
C211 nb.t26 VSS 0.1153f
C212 nb.n26 VSS 0.09036f
C213 nb.t27 VSS 0.10062f
C214 nb.n27 VSS 0.07947f
C215 nb.t28 VSS 0.1153f
C216 nb.n28 VSS 0.09036f
C217 nb.t29 VSS 0.10062f
C218 nb.n29 VSS 0.07947f
C219 nb.t30 VSS 0.1153f
C220 nb.n30 VSS 0.09036f
C221 nb.t31 VSS 0.10062f
C222 nb.n31 VSS 0.07947f
C223 nb.t32 VSS 0.1153f
C224 nb.n32 VSS 0.09036f
C225 nb.t33 VSS 0.10062f
C226 nb.n33 VSS 0.07947f
C227 nb.t34 VSS 0.1153f
C228 nb.n34 VSS 0.09036f
C229 nb.t35 VSS 0.10062f
C230 nb.n35 VSS 0.07947f
C231 nb.t36 VSS 0.1153f
C232 nb.n36 VSS 0.09036f
C233 nb.t37 VSS 0.10062f
C234 nb.n37 VSS 0.07947f
C235 nb.t38 VSS 0.1153f
C236 nb.n38 VSS 0.08815f
C237 nb.t39 VSS 0.10062f
C238 nb.n39 VSS 0.08067f
.ends
