* amp_dp: magic R+C extraction of layout/amp_dp.gds (layout/pex.sh)
.subckt amp_dp inp inn nb outp outn VDD VSS
X0 outn inp tail VSS.t51 sky130_fd_pr__nfet_01v8 ad=0.75 pd=5.3 as=0.7375 ps=5.295 w=5 l=0.15
X1 outn inp tail VSS.t55 sky130_fd_pr__nfet_01v8 ad=0.75 pd=5.3 as=0.75 ps=5.3 w=5 l=0.15
X2 tail nb VSS VSS.t11 sky130_fd_pr__nfet_01v8 ad=0.45 pd=3.3 as=0.45 ps=3.3 w=3 l=0.5
X3 VSS.t25 nb tail VSS.t41 sky130_fd_pr__nfet_01v8 ad=0.45 pd=3.3 as=0.45 ps=3.3 w=3 l=0.5
X4 tail nb VSS.t23 VSS.t22 sky130_fd_pr__nfet_01v8 ad=0.45 pd=3.3 as=0.9 ps=6.6 w=3 l=0.5
X5 tail nb VSS VSS.t19 sky130_fd_pr__nfet_01v8 ad=0.45 pd=3.3 as=0.45 ps=3.3 w=3 l=0.5
X6 VSS nb tail VSS.t2 sky130_fd_pr__nfet_01v8 ad=0.45 pd=3.3 as=0.45 ps=3.3 w=3 l=0.5
X7 VSS nb tail VSS.t12 sky130_fd_pr__nfet_01v8 ad=0.45 pd=3.3 as=0.45 ps=3.3 w=3 l=0.5
X8 VSS.t25 nb tail VSS.t39 sky130_fd_pr__nfet_01v8 ad=0.45 pd=3.3 as=0.45 ps=3.3 w=3 l=0.5
X9 tail nb VSS.t25 VSS.t42 sky130_fd_pr__nfet_01v8 ad=0.45 pd=3.3 as=0.45 ps=3.3 w=3 l=0.5
X10 tail nb VSS.t25 VSS.t32 sky130_fd_pr__nfet_01v8 ad=0.45 pd=3.3 as=0.45 ps=3.3 w=3 l=0.5
X11 VSS.t25 nb tail VSS.t35 sky130_fd_pr__nfet_01v8 ad=0.45 pd=3.3 as=0.45 ps=3.3 w=3 l=0.5
X12 outp inn tail VSS.t67 sky130_fd_pr__nfet_01v8 ad=0.75 pd=5.3 as=0.75 ps=5.3 w=5 l=0.15
X13 tail nb VSS VSS.t3 sky130_fd_pr__nfet_01v8 ad=0.45 pd=3.3 as=0.45 ps=3.3 w=3 l=0.5
X14 VSS.t21 nb tail VSS.t20 sky130_fd_pr__nfet_01v8 ad=0.9 pd=6.6 as=0.45 ps=3.3 w=3 l=0.5
X15 tail nb VSS.t25 VSS.t28 sky130_fd_pr__nfet_01v8 ad=0.45 pd=3.3 as=0.45 ps=3.3 w=3 l=0.5
X16 VSS.t25 nb tail VSS.t31 sky130_fd_pr__nfet_01v8 ad=0.45 pd=3.3 as=0.45 ps=3.3 w=3 l=0.5
X17 tail inp outn VSS.t52 sky130_fd_pr__nfet_01v8 ad=1.525 pd=10.61 as=0.75 ps=5.3 w=5 l=0.15
X18 tail inn outp VSS.t68 sky130_fd_pr__nfet_01v8 ad=0.7375 pd=5.295 as=0.75 ps=5.3 w=5 l=0.15
X19 tail inn outp VSS.t74 sky130_fd_pr__nfet_01v8 ad=0.75 pd=5.3 as=0.75 ps=5.3 w=5 l=0.15
X20 tail nb VSS VSS.t13 sky130_fd_pr__nfet_01v8 ad=0.45 pd=3.3 as=0.45 ps=3.3 w=3 l=0.5
X21 outn inp tail VSS.t45 sky130_fd_pr__nfet_01v8 ad=0.75 pd=5.3 as=1.5 ps=10.6 w=5 l=0.15
X22 outp inn tail VSS.t75 sky130_fd_pr__nfet_01v8 ad=0.75 pd=5.3 as=0.75 ps=5.3 w=5 l=0.15
X23 VSS nb tail VSS.t16 sky130_fd_pr__nfet_01v8 ad=0.45 pd=3.3 as=0.45 ps=3.3 w=3 l=0.5
X24 tail inp outn VSS.t46 sky130_fd_pr__nfet_01v8 ad=0.75 pd=5.3 as=0.75 ps=5.3 w=5 l=0.15
X25 outp inn tail VSS.t69 sky130_fd_pr__nfet_01v8 ad=0.75 pd=5.3 as=0.7375 ps=5.295 w=5 l=0.15
X26 VSS nb tail VSS.t6 sky130_fd_pr__nfet_01v8 ad=0.45 pd=3.3 as=0.45 ps=3.3 w=3 l=0.5
X27 tail inn outp VSS.t70 sky130_fd_pr__nfet_01v8 ad=1.525 pd=10.61 as=0.75 ps=5.3 w=5 l=0.15
X28 tail inn outp VSS.t76 sky130_fd_pr__nfet_01v8 ad=0.7375 pd=5.295 as=0.75 ps=5.3 w=5 l=0.15
X29 tail inp outn VSS.t56 sky130_fd_pr__nfet_01v8 ad=0.75 pd=5.3 as=0.75 ps=5.3 w=5 l=0.15
X30 tail nb VSS VSS.t9 sky130_fd_pr__nfet_01v8 ad=0.45 pd=3.3 as=0.45 ps=3.3 w=3 l=0.5
X31 outp inn tail VSS.t63 sky130_fd_pr__nfet_01v8 ad=0.75 pd=5.3 as=1.5 ps=10.6 w=5 l=0.15
X32 VSS.t25 nb tail VSS.t29 sky130_fd_pr__nfet_01v8 ad=0.45 pd=3.3 as=0.45 ps=3.3 w=3 l=0.5
X33 outp inn tail VSS.t77 sky130_fd_pr__nfet_01v8 ad=0.75 pd=5.3 as=0.7375 ps=5.295 w=5 l=0.15
X34 outn inp tail VSS.t57 sky130_fd_pr__nfet_01v8 ad=0.75 pd=5.3 as=0.75 ps=5.3 w=5 l=0.15
X35 tail inn outp VSS.t64 sky130_fd_pr__nfet_01v8 ad=0.75 pd=5.3 as=0.75 ps=5.3 w=5 l=0.15
X36 VSS.t25 nb tail VSS.t24 sky130_fd_pr__nfet_01v8 ad=0.45 pd=3.3 as=0.45 ps=3.3 w=3 l=0.5
X37 tail inn outp VSS.t78 sky130_fd_pr__nfet_01v8 ad=1.525 pd=10.61 as=0.75 ps=5.3 w=5 l=0.15
X38 tail inp outn VSS.t58 sky130_fd_pr__nfet_01v8 ad=0.7375 pd=5.295 as=0.75 ps=5.3 w=5 l=0.15
X39 VSS nb tail VSS.t10 sky130_fd_pr__nfet_01v8 ad=0.45 pd=3.3 as=0.45 ps=3.3 w=3 l=0.5
X40 tail nb VSS.t25 VSS.t40 sky130_fd_pr__nfet_01v8 ad=0.45 pd=3.3 as=0.45 ps=3.3 w=3 l=0.5
X41 VSS.t44 nb tail VSS.t43 sky130_fd_pr__nfet_01v8 ad=0.9 pd=6.6 as=0.45 ps=3.3 w=3 l=0.5
X42 VDD outp VSS.t61 sky130_fd_pr__res_high_po_1p41 l=3.14
X43 VSS.t25 nb tail VSS.t33 sky130_fd_pr__nfet_01v8 ad=0.45 pd=3.3 as=0.45 ps=3.3 w=3 l=0.5
X44 tail nb VSS.t25 VSS.t36 sky130_fd_pr__nfet_01v8 ad=0.45 pd=3.3 as=0.45 ps=3.3 w=3 l=0.5
X45 tail nb VSS.t1 VSS.t0 sky130_fd_pr__nfet_01v8 ad=0.45 pd=3.3 as=0.9 ps=6.6 w=3 l=0.5
X46 VSS nb tail VSS.t18 sky130_fd_pr__nfet_01v8 ad=0.45 pd=3.3 as=0.45 ps=3.3 w=3 l=0.5
X47 tail nb VSS.t25 VSS.t26 sky130_fd_pr__nfet_01v8 ad=0.45 pd=3.3 as=0.45 ps=3.3 w=3 l=0.5
X48 VSS nb tail VSS.t4 sky130_fd_pr__nfet_01v8 ad=0.45 pd=3.3 as=0.45 ps=3.3 w=3 l=0.5
X49 VDD outn VSS.t62 sky130_fd_pr__res_high_po_1p41 l=3.14
X50 VSS nb tail VSS.t14 sky130_fd_pr__nfet_01v8 ad=0.45 pd=3.3 as=0.45 ps=3.3 w=3 l=0.5
X51 outn inp tail VSS.t47 sky130_fd_pr__nfet_01v8 ad=0.75 pd=5.3 as=0.75 ps=5.3 w=5 l=0.15
X52 outp inn tail VSS.t71 sky130_fd_pr__nfet_01v8 ad=0.75 pd=5.3 as=1.5 ps=10.6 w=5 l=0.15
X53 tail nb VSS VSS.t17 sky130_fd_pr__nfet_01v8 ad=0.45 pd=3.3 as=0.45 ps=3.3 w=3 l=0.5
X54 tail nb VSS.t25 VSS.t34 sky130_fd_pr__nfet_01v8 ad=0.45 pd=3.3 as=0.45 ps=3.3 w=3 l=0.5
X55 outn inp tail VSS.t59 sky130_fd_pr__nfet_01v8 ad=0.75 pd=5.3 as=0.7375 ps=5.295 w=5 l=0.15
X56 tail nb VSS VSS.t7 sky130_fd_pr__nfet_01v8 ad=0.45 pd=3.3 as=0.45 ps=3.3 w=3 l=0.5
X57 VSS.t25 nb tail VSS.t37 sky130_fd_pr__nfet_01v8 ad=0.45 pd=3.3 as=0.45 ps=3.3 w=3 l=0.5
X58 tail inp outn VSS.t48 sky130_fd_pr__nfet_01v8 ad=0.75 pd=5.3 as=0.75 ps=5.3 w=5 l=0.15
X59 tail inn outp VSS.t72 sky130_fd_pr__nfet_01v8 ad=0.75 pd=5.3 as=0.75 ps=5.3 w=5 l=0.15
X60 VSS.t25 nb tail VSS.t27 sky130_fd_pr__nfet_01v8 ad=0.45 pd=3.3 as=0.45 ps=3.3 w=3 l=0.5
X61 tail nb VSS.t25 VSS.t30 sky130_fd_pr__nfet_01v8 ad=0.45 pd=3.3 as=0.45 ps=3.3 w=3 l=0.5
X62 outp inn tail VSS.t65 sky130_fd_pr__nfet_01v8 ad=0.75 pd=5.3 as=0.75 ps=5.3 w=5 l=0.15
X63 tail inp outn VSS.t60 sky130_fd_pr__nfet_01v8 ad=1.525 pd=10.61 as=0.75 ps=5.3 w=5 l=0.15
X64 tail nb VSS VSS.t5 sky130_fd_pr__nfet_01v8 ad=0.45 pd=3.3 as=0.45 ps=3.3 w=3 l=0.5
X65 outn inp tail VSS.t49 sky130_fd_pr__nfet_01v8 ad=0.75 pd=5.3 as=0.75 ps=5.3 w=5 l=0.15
X66 outp inn tail VSS.t73 sky130_fd_pr__nfet_01v8 ad=0.75 pd=5.3 as=0.75 ps=5.3 w=5 l=0.15
X67 outn inp tail VSS.t53 sky130_fd_pr__nfet_01v8 ad=0.75 pd=5.3 as=1.5 ps=10.6 w=5 l=0.15
X68 tail nb VSS VSS.t15 sky130_fd_pr__nfet_01v8 ad=0.45 pd=3.3 as=0.45 ps=3.3 w=3 l=0.5
X69 tail inp outn VSS.t50 sky130_fd_pr__nfet_01v8 ad=0.7375 pd=5.295 as=0.75 ps=5.3 w=5 l=0.15
X70 tail inn outp VSS.t66 sky130_fd_pr__nfet_01v8 ad=0.75 pd=5.3 as=0.75 ps=5.3 w=5 l=0.15
X71 tail inp outn VSS.t54 sky130_fd_pr__nfet_01v8 ad=0.75 pd=5.3 as=0.75 ps=5.3 w=5 l=0.15
X72 VSS nb tail VSS.t8 sky130_fd_pr__nfet_01v8 ad=0.45 pd=3.3 as=0.45 ps=3.3 w=3 l=0.5
X73 tail nb VSS.t25 VSS.t38 sky130_fd_pr__nfet_01v8 ad=0.45 pd=3.3 as=0.45 ps=3.3 w=3 l=0.5
R0 VSS.n13 VSS.n395 585
R1 VSS.n487 VSS.n486 585
R2 VSS.n484 VSS.n396 585
R3 VSS.n482 VSS.n481 585
R4 VSS.n398 VSS.n397 585
R5 VSS.n480 VSS.n479 585
R6 VSS.n477 VSS.n399 585
R7 VSS.n475 VSS.n474 585
R8 VSS.n401 VSS.n400 585
R9 VSS.n473 VSS.n472 585
R10 VSS.n470 VSS.n402 585
R11 VSS.n468 VSS.n467 585
R12 VSS.n404 VSS.n403 585
R13 VSS.n466 VSS.n465 585
R14 VSS.n463 VSS.n394 585
R15 VSS.n463 VSS.n405 585
R16 VSS.n462 VSS.n461 585
R17 VSS.n458 VSS.n407 585
R18 VSS.n460 VSS.n459 585
R19 VSS.n456 VSS.n408 585
R20 VSS.n455 VSS.n454 585
R21 VSS.n412 VSS.n410 585
R22 VSS.n453 VSS.n452 585
R23 VSS.n450 VSS.n411 585
R24 VSS.n449 VSS.n413 585
R25 VSS.n447 VSS.n446 585
R26 VSS.n415 VSS.n414 585
R27 VSS.n445 VSS.n444 585
R28 VSS.n442 VSS.n416 585
R29 VSS.n440 VSS.n439 585
R30 VSS.n418 VSS.n417 585
R31 VSS.n438 VSS.n437 585
R32 VSS.n435 VSS.n394 585
R33 VSS.n435 VSS.n419 585
R34 VSS.n434 VSS.n433 585
R35 VSS.n430 VSS.n421 585
R36 VSS.n431 VSS.n394 585
R37 VSS.n432 VSS.n431 585
R38 VSS.n429 VSS.n422 585
R39 VSS.n427 VSS.n426 585
R40 VSS.n425 VSS.n424 585
R41 VSS.n393 VSS.n392 585
R42 VSS.n490 VSS.n489 585
R43 VSS.n489 VSS.n488 585
R44 VSS.n389 VSS.n388 585
R45 VSS.n388 VSS.n387 585
R46 VSS.n495 VSS.t43 585
R47 VSS.n496 VSS.n495 585
R48 VSS.n385 VSS.n384 585
R49 VSS.n386 VSS.n385 585
R50 VSS.n499 VSS.n498 585
R51 VSS.n498 VSS.n497 585
R52 VSS.n379 VSS.n378 585
R53 VSS.n378 VSS.n377 585
R54 VSS.n505 VSS.n504 585
R55 VSS.n506 VSS.n505 585
R56 VSS.n376 VSS.n375 585
R57 VSS.n131 VSS.n376 585
R58 VSS.n509 VSS.n508 585
R59 VSS.n508 VSS.n507 585
R60 VSS.n370 VSS.n369 585
R61 VSS.n369 VSS.n368 585
R62 VSS.n515 VSS.n514 585
R63 VSS.n516 VSS.n515 585
R64 VSS.n366 VSS.n365 585
R65 VSS.n367 VSS.n366 585
R66 VSS.n520 VSS.n518 585
R67 VSS.n518 VSS.n517 585
R68 VSS.n519 VSS.n359 585
R69 VSS.n359 VSS.n358 585
R70 VSS.n526 VSS.n525 585
R71 VSS.n527 VSS.n526 585
R72 VSS.n360 VSS.n356 585
R73 VSS.n357 VSS.n356 585
R74 VSS.n531 VSS.n529 585
R75 VSS.n529 VSS.n528 585
R76 VSS.n530 VSS.n350 585
R77 VSS.n350 VSS.n349 585
R78 VSS.n537 VSS.n536 585
R79 VSS.n538 VSS.n537 585
R80 VSS.n351 VSS.n347 585
R81 VSS.n348 VSS.n347 585
R82 VSS.n541 VSS.n540 585
R83 VSS.n540 VSS.n539 585
R84 VSS.n341 VSS.n340 585
R85 VSS.n340 VSS.n339 585
R86 VSS.n546 VSS.t34 585
R87 VSS.n547 VSS.n546 585
R88 VSS.n342 VSS.n337 585
R89 VSS.n338 VSS.n337 585
R90 VSS.n551 VSS.n549 585
R91 VSS.n549 VSS.n548 585
R92 VSS.n550 VSS.n331 585
R93 VSS.n331 VSS.n330 585
R94 VSS.n557 VSS.n556 585
R95 VSS.n558 VSS.n557 585
R96 VSS.n332 VSS.n329 585
R97 VSS.n104 VSS.n329 585
R98 VSS.n561 VSS.n560 585
R99 VSS.n560 VSS.n559 585
R100 VSS.n323 VSS.n322 585
R101 VSS.n322 VSS.n321 585
R102 VSS.n567 VSS.n566 585
R103 VSS.n568 VSS.n567 585
R104 VSS.n324 VSS.n319 585
R105 VSS.n320 VSS.n319 585
R106 VSS.n572 VSS.n570 585
R107 VSS.n570 VSS.n569 585
R108 VSS.n571 VSS.n313 585
R109 VSS.n313 VSS.n312 585
R110 VSS.n578 VSS.n577 585
R111 VSS.n579 VSS.n578 585
R112 VSS.n314 VSS.n310 585
R113 VSS.n311 VSS.n310 585
R114 VSS.n583 VSS.n581 585
R115 VSS.n581 VSS.n580 585
R116 VSS.n582 VSS.n304 585
R117 VSS.n304 VSS.n303 585
R118 VSS.n589 VSS.n588 585
R119 VSS.n590 VSS.n589 585
R120 VSS.n305 VSS.n302 585
R121 VSS.n101 VSS.n302 585
R122 VSS.n593 VSS.n592 585
R123 VSS.n592 VSS.n591 585
R124 VSS.n296 VSS.n295 585
R125 VSS.n295 VSS.n294 585
R126 VSS.n598 VSS.t24 585
R127 VSS.n599 VSS.n598 585
R128 VSS.n297 VSS.n292 585
R129 VSS.n293 VSS.n292 585
R130 VSS.n602 VSS.n601 585
R131 VSS.n601 VSS.n600 585
R132 VSS.n287 VSS.n286 585
R133 VSS.n286 VSS.n145 585
R134 VSS.n608 VSS.n607 585
R135 VSS.n609 VSS.n608 585
R136 VSS.n285 VSS.n284 585
R137 VSS.n100 VSS.n285 585
R138 VSS.n613 VSS.n611 585
R139 VSS.n611 VSS.n610 585
R140 VSS.n612 VSS.n278 585
R141 VSS.n278 VSS.n277 585
R142 VSS.n619 VSS.n618 585
R143 VSS.n620 VSS.n619 585
R144 VSS.n279 VSS.n275 585
R145 VSS.n276 VSS.n275 585
R146 VSS.t19 VSS.n622 585
R147 VSS.n622 VSS.n621 585
R148 VSS.n274 VSS.n268 585
R149 VSS.n268 VSS.n267 585
R150 VSS.n628 VSS.n627 585
R151 VSS.n629 VSS.n628 585
R152 VSS.n269 VSS.n266 585
R153 VSS.n117 VSS.n266 585
R154 VSS.n632 VSS.n631 585
R155 VSS.n631 VSS.n630 585
R156 VSS.n261 VSS.n260 585
R157 VSS.n260 VSS.n259 585
R158 VSS.n638 VSS.n637 585
R159 VSS.n639 VSS.n638 585
R160 VSS.n257 VSS.n256 585
R161 VSS.n258 VSS.n257 585
R162 VSS.n642 VSS.n641 585
R163 VSS.n641 VSS.n640 585
R164 VSS.n250 VSS.n249 585
R165 VSS.n249 VSS.n248 585
R166 VSS.n648 VSS.n647 585
R167 VSS.n649 VSS.n648 585
R168 VSS.n251 VSS.n246 585
R169 VSS.n247 VSS.n246 585
R170 VSS.n653 VSS.n651 585
R171 VSS.n651 VSS.n650 585
R172 VSS.n652 VSS.n240 585
R173 VSS.n240 VSS.n239 585
R174 VSS.n659 VSS.n658 585
R175 VSS.n660 VSS.n659 585
R176 VSS.n241 VSS.n237 585
R177 VSS.n238 VSS.n237 585
R178 VSS.n664 VSS.n662 585
R179 VSS.n662 VSS.n661 585
R180 VSS.n663 VSS.n231 585
R181 VSS.n231 VSS.n230 585
R182 VSS.n670 VSS.n669 585
R183 VSS.n671 VSS.n670 585
R184 VSS.n232 VSS.n228 585
R185 VSS.n229 VSS.n228 585
R186 VSS.t10 VSS.n673 585
R187 VSS.n673 VSS.n672 585
R188 VSS.n223 VSS.n222 585
R189 VSS.n222 VSS.n221 585
R190 VSS.n679 VSS.n678 585
R191 VSS.n680 VSS.n679 585
R192 VSS.n219 VSS.n218 585
R193 VSS.n220 VSS.n219 585
R194 VSS.n683 VSS.n682 585
R195 VSS.n682 VSS.n681 585
R196 VSS.n212 VSS.n211 585
R197 VSS.n211 VSS.n210 585
R198 VSS.n689 VSS.n688 585
R199 VSS.n690 VSS.n689 585
R200 VSS.n213 VSS.n209 585
R201 VSS.n103 VSS.n209 585
R202 VSS.n693 VSS.n692 585
R203 VSS.n692 VSS.n691 585
R204 VSS.n203 VSS.n202 585
R205 VSS.n202 VSS.n201 585
R206 VSS.n699 VSS.n698 585
R207 VSS.n700 VSS.n699 585
R208 VSS.n204 VSS.n199 585
R209 VSS.n200 VSS.n199 585
R210 VSS.n704 VSS.n702 585
R211 VSS.n702 VSS.n701 585
R212 VSS.n703 VSS.n193 585
R213 VSS.n193 VSS.n192 585
R214 VSS.n710 VSS.n709 585
R215 VSS.n711 VSS.n710 585
R216 VSS.n194 VSS.n191 585
R217 VSS.n102 VSS.n191 585
R218 VSS.n715 VSS.n713 585
R219 VSS.n713 VSS.n712 585
R220 VSS.n714 VSS.n183 585
R221 VSS.n183 VSS.n182 585
R222 VSS.n721 VSS.n720 585
R223 VSS.n722 VSS.n721 585
R224 VSS.n184 VSS.n180 585
R225 VSS.n181 VSS.n180 585
R226 VSS.n724 VSS.t0 585
R227 VSS.n724 VSS.n723 585
R228 VSS.n726 VSS.n725 585
R229 VSS.n725 VSS.n146 585
R230 VSS.n156 VSS.n153 585
R231 VSS.n805 VSS.n153 585
R232 VSS.n801 VSS.n800 585
R233 VSS.n800 VSS.n799 585
R234 VSS.n177 VSS.n176 585
R235 VSS.n798 VSS.n729 585
R236 VSS.n797 VSS.n730 585
R237 VSS.n796 VSS.n731 585
R238 VSS.n733 VSS.n732 585
R239 VSS.n795 VSS.n734 585
R240 VSS.n794 VSS.n735 585
R241 VSS.n793 VSS.n736 585
R242 VSS.n738 VSS.n737 585
R243 VSS.n792 VSS.n739 585
R244 VSS.n791 VSS.n740 585
R245 VSS.n790 VSS.n741 585
R246 VSS.n743 VSS.n742 585
R247 VSS.n789 VSS.n744 585
R248 VSS.n788 VSS.n745 585
R249 VSS.n787 VSS.n746 585
R250 VSS.n748 VSS.n747 585
R251 VSS.n786 VSS.n749 585
R252 VSS.n785 VSS.n750 585
R253 VSS.n784 VSS.n751 585
R254 VSS.n753 VSS.n752 585
R255 VSS.n783 VSS.n754 585
R256 VSS.n782 VSS.n755 585
R257 VSS.n781 VSS.n756 585
R258 VSS.n758 VSS.n757 585
R259 VSS.n780 VSS.n759 585
R260 VSS.n779 VSS.n760 585
R261 VSS.n778 VSS.n761 585
R262 VSS.n763 VSS.n762 585
R263 VSS.n777 VSS.n764 585
R264 VSS.n776 VSS.n765 585
R265 VSS.n775 VSS.n766 585
R266 VSS.n768 VSS.n767 585
R267 VSS.n774 VSS.n769 585
R268 VSS.n773 VSS.n770 585
R269 VSS.n772 VSS.n771 585
R270 VSS.n155 VSS.n154 585
R271 VSS.n804 VSS.n803 585
R272 VSS.n175 VSS.n156 585
R273 VSS.n12 VSS.n175 585
R274 VSS.n727 VSS.n726 585
R275 VSS.n728 VSS.n727 585
R276 VSS.t0 VSS.n179 585
R277 VSS.n179 VSS.n178 585
R278 VSS.n186 VSS.n184 585
R279 VSS.n188 VSS.n186 585
R280 VSS.n720 VSS.n719 585
R281 VSS.n719 VSS.n718 585
R282 VSS.n714 VSS.n185 585
R283 VSS.n187 VSS.n185 585
R284 VSS.n716 VSS.n715 585
R285 VSS.n717 VSS.n716 585
R286 VSS.n194 VSS.n190 585
R287 VSS.n190 VSS.n189 585
R288 VSS.n709 VSS.n708 585
R289 VSS.n708 VSS.n707 585
R290 VSS.n703 VSS.n195 585
R291 VSS.n196 VSS.n195 585
R292 VSS.n705 VSS.n704 585
R293 VSS.n706 VSS.n705 585
R294 VSS.n204 VSS.n198 585
R295 VSS.n198 VSS.n197 585
R296 VSS.n698 VSS.n697 585
R297 VSS.n697 VSS.n696 585
R298 VSS.n205 VSS.n203 585
R299 VSS.n206 VSS.n205 585
R300 VSS.n694 VSS.n693 585
R301 VSS.n695 VSS.n694 585
R302 VSS.n213 VSS.n208 585
R303 VSS.n208 VSS.n207 585
R304 VSS.n688 VSS.n687 585
R305 VSS.n687 VSS.n686 585
R306 VSS.n214 VSS.n212 585
R307 VSS.n215 VSS.n214 585
R308 VSS.n684 VSS.n683 585
R309 VSS.n685 VSS.n684 585
R310 VSS.n218 VSS.n217 585
R311 VSS.n217 VSS.n216 585
R312 VSS.n678 VSS.n677 585
R313 VSS.n677 VSS.n676 585
R314 VSS.n224 VSS.n223 585
R315 VSS.n225 VSS.n224 585
R316 VSS.n674 VSS.t10 585
R317 VSS.n675 VSS.n674 585
R318 VSS.n232 VSS.n227 585
R319 VSS.n227 VSS.n226 585
R320 VSS.n669 VSS.n668 585
R321 VSS.n668 VSS.n667 585
R322 VSS.n663 VSS.n233 585
R323 VSS.n234 VSS.n233 585
R324 VSS.n665 VSS.n664 585
R325 VSS.n666 VSS.n665 585
R326 VSS.n241 VSS.n236 585
R327 VSS.n236 VSS.n235 585
R328 VSS.n658 VSS.n657 585
R329 VSS.n657 VSS.n656 585
R330 VSS.n652 VSS.n242 585
R331 VSS.n243 VSS.n242 585
R332 VSS.n654 VSS.n653 585
R333 VSS.n655 VSS.n654 585
R334 VSS.n251 VSS.n245 585
R335 VSS.n245 VSS.n244 585
R336 VSS.n647 VSS.n646 585
R337 VSS.n646 VSS.n645 585
R338 VSS.n252 VSS.n250 585
R339 VSS.n253 VSS.n252 585
R340 VSS.n643 VSS.n642 585
R341 VSS.n644 VSS.n643 585
R342 VSS.n256 VSS.n255 585
R343 VSS.n255 VSS.n254 585
R344 VSS.n637 VSS.n636 585
R345 VSS.n636 VSS.n635 585
R346 VSS.n262 VSS.n261 585
R347 VSS.n263 VSS.n262 585
R348 VSS.n633 VSS.n632 585
R349 VSS.n634 VSS.n633 585
R350 VSS.n269 VSS.n265 585
R351 VSS.n265 VSS.n264 585
R352 VSS.n627 VSS.n626 585
R353 VSS.n626 VSS.n625 585
R354 VSS.n274 VSS.n270 585
R355 VSS.n271 VSS.n270 585
R356 VSS.n623 VSS.t19 585
R357 VSS.n624 VSS.n623 585
R358 VSS.n279 VSS.n273 585
R359 VSS.n273 VSS.n272 585
R360 VSS.n618 VSS.n617 585
R361 VSS.n617 VSS.n616 585
R362 VSS.n612 VSS.n280 585
R363 VSS.n281 VSS.n280 585
R364 VSS.n614 VSS.n613 585
R365 VSS.n615 VSS.n614 585
R366 VSS.n284 VSS.n283 585
R367 VSS.n283 VSS.n282 585
R368 VSS.n607 VSS.n606 585
R369 VSS.n606 VSS.n605 585
R370 VSS.n288 VSS.n287 585
R371 VSS.n289 VSS.n288 585
R372 VSS.n603 VSS.n602 585
R373 VSS.n604 VSS.n603 585
R374 VSS.n297 VSS.n291 585
R375 VSS.n291 VSS.n290 585
R376 VSS.t24 VSS.n597 585
R377 VSS.n597 VSS.n596 585
R378 VSS.n298 VSS.n296 585
R379 VSS.n299 VSS.n298 585
R380 VSS.n594 VSS.n593 585
R381 VSS.n595 VSS.n594 585
R382 VSS.n305 VSS.n301 585
R383 VSS.n301 VSS.n300 585
R384 VSS.n588 VSS.n587 585
R385 VSS.n587 VSS.n586 585
R386 VSS.n582 VSS.n306 585
R387 VSS.n307 VSS.n306 585
R388 VSS.n584 VSS.n583 585
R389 VSS.n585 VSS.n584 585
R390 VSS.n314 VSS.n309 585
R391 VSS.n309 VSS.n308 585
R392 VSS.n577 VSS.n576 585
R393 VSS.n576 VSS.n575 585
R394 VSS.n571 VSS.n315 585
R395 VSS.n316 VSS.n315 585
R396 VSS.n573 VSS.n572 585
R397 VSS.n574 VSS.n573 585
R398 VSS.n324 VSS.n318 585
R399 VSS.n318 VSS.n317 585
R400 VSS.n566 VSS.n565 585
R401 VSS.n565 VSS.n564 585
R402 VSS.n325 VSS.n323 585
R403 VSS.n326 VSS.n325 585
R404 VSS.n562 VSS.n561 585
R405 VSS.n563 VSS.n562 585
R406 VSS.n332 VSS.n328 585
R407 VSS.n328 VSS.n327 585
R408 VSS.n556 VSS.n555 585
R409 VSS.n555 VSS.n554 585
R410 VSS.n550 VSS.n333 585
R411 VSS.n334 VSS.n333 585
R412 VSS.n552 VSS.n551 585
R413 VSS.n553 VSS.n552 585
R414 VSS.n342 VSS.n336 585
R415 VSS.n336 VSS.n335 585
R416 VSS.t34 VSS.n545 585
R417 VSS.n545 VSS.n544 585
R418 VSS.n343 VSS.n341 585
R419 VSS.n344 VSS.n343 585
R420 VSS.n542 VSS.n541 585
R421 VSS.n543 VSS.n542 585
R422 VSS.n351 VSS.n346 585
R423 VSS.n346 VSS.n345 585
R424 VSS.n536 VSS.n535 585
R425 VSS.n535 VSS.n534 585
R426 VSS.n530 VSS.n352 585
R427 VSS.n353 VSS.n352 585
R428 VSS.n532 VSS.n531 585
R429 VSS.n533 VSS.n532 585
R430 VSS.n360 VSS.n355 585
R431 VSS.n355 VSS.n354 585
R432 VSS.n525 VSS.n524 585
R433 VSS.n524 VSS.n523 585
R434 VSS.n519 VSS.n361 585
R435 VSS.n362 VSS.n361 585
R436 VSS.n521 VSS.n520 585
R437 VSS.n522 VSS.n521 585
R438 VSS.n365 VSS.n364 585
R439 VSS.n364 VSS.n363 585
R440 VSS.n514 VSS.n513 585
R441 VSS.n513 VSS.n512 585
R442 VSS.n371 VSS.n370 585
R443 VSS.n372 VSS.n371 585
R444 VSS.n510 VSS.n509 585
R445 VSS.n511 VSS.n510 585
R446 VSS.n375 VSS.n374 585
R447 VSS.n374 VSS.n373 585
R448 VSS.n504 VSS.n503 585
R449 VSS.n503 VSS.n502 585
R450 VSS.n380 VSS.n379 585
R451 VSS.n381 VSS.n380 585
R452 VSS.n500 VSS.n499 585
R453 VSS.n501 VSS.n500 585
R454 VSS.n384 VSS.n383 585
R455 VSS.n383 VSS.n382 585
R456 VSS.t43 VSS.n494 585
R457 VSS.n494 VSS.n493 585
R458 VSS.n390 VSS.n389 585
R459 VSS.n391 VSS.n390 585
R460 VSS.n491 VSS.n490 585
R461 VSS.n492 VSS.n491 585
R462 VSS.n491 VSS.n393 470.337
R463 VSS.n489 VSS.n395 470.337
R464 VSS.n803 VSS.n153 470.337
R465 VSS.n800 VSS.n175 470.337
R466 VSS.n152 VSS.n151 256.483
R467 VSS.n485 VSS.n394 254.01
R468 VSS.n483 VSS.n394 254.01
R469 VSS.n478 VSS.n394 254.01
R470 VSS.n476 VSS.n394 254.01
R471 VSS.n471 VSS.n394 254.01
R472 VSS.n469 VSS.n394 254.01
R473 VSS.n464 VSS.n394 254.01
R474 VSS.n406 VSS.n394 254.01
R475 VSS.n457 VSS.n394 254.01
R476 VSS.n409 VSS.n394 254.01
R477 VSS.n451 VSS.n394 254.01
R478 VSS.n448 VSS.n394 254.01
R479 VSS.n443 VSS.n394 254.01
R480 VSS.n441 VSS.n394 254.01
R481 VSS.n436 VSS.n394 254.01
R482 VSS.n420 VSS.n394 254.01
R483 VSS.n428 VSS.n394 254.01
R484 VSS.n423 VSS.n394 254.01
R485 VSS.n801 VSS.n174 254.01
R486 VSS.n801 VSS.n173 254.01
R487 VSS.n801 VSS.n172 254.01
R488 VSS.n801 VSS.n171 254.01
R489 VSS.n801 VSS.n170 254.01
R490 VSS.n801 VSS.n169 254.01
R491 VSS.n801 VSS.n168 254.01
R492 VSS.n801 VSS.n167 254.01
R493 VSS.n801 VSS.n166 254.01
R494 VSS.n801 VSS.n165 254.01
R495 VSS.n801 VSS.n164 254.01
R496 VSS.n801 VSS.n163 254.01
R497 VSS.n801 VSS.n162 254.01
R498 VSS.n801 VSS.n161 254.01
R499 VSS.n801 VSS.n160 254.01
R500 VSS.n801 VSS.n159 254.01
R501 VSS.n801 VSS.n158 254.01
R502 VSS.n801 VSS.n157 254.01
R503 VSS.n802 VSS.n801 254.01
R504 VSS.n151 VSS.n150 185
R505 VSS.n148 VSS.n147 185
R506 VSS.n149 VSS.t1 180.934
R507 VSS.n727 VSS.n175 177.3
R508 VSS.n727 VSS.n179 177.3
R509 VSS.n186 VSS.n179 177.3
R510 VSS.n719 VSS.n186 177.3
R511 VSS.n719 VSS.n185 177.3
R512 VSS.n716 VSS.n185 177.3
R513 VSS.n716 VSS.n190 177.3
R514 VSS.n708 VSS.n190 177.3
R515 VSS.n708 VSS.n195 177.3
R516 VSS.n705 VSS.n195 177.3
R517 VSS.n705 VSS.n198 177.3
R518 VSS.n697 VSS.n198 177.3
R519 VSS.n697 VSS.n205 177.3
R520 VSS.n694 VSS.n205 177.3
R521 VSS.n694 VSS.n208 177.3
R522 VSS.n687 VSS.n208 177.3
R523 VSS.n687 VSS.n214 177.3
R524 VSS.n684 VSS.n214 177.3
R525 VSS.n684 VSS.n217 177.3
R526 VSS.n677 VSS.n217 177.3
R527 VSS.n677 VSS.n224 177.3
R528 VSS.n674 VSS.n224 177.3
R529 VSS.n674 VSS.n227 177.3
R530 VSS.n668 VSS.n227 177.3
R531 VSS.n668 VSS.n233 177.3
R532 VSS.n665 VSS.n233 177.3
R533 VSS.n665 VSS.n236 177.3
R534 VSS.n657 VSS.n236 177.3
R535 VSS.n657 VSS.n242 177.3
R536 VSS.n654 VSS.n242 177.3
R537 VSS.n654 VSS.n245 177.3
R538 VSS.n646 VSS.n245 177.3
R539 VSS.n646 VSS.n252 177.3
R540 VSS.n643 VSS.n252 177.3
R541 VSS.n643 VSS.n255 177.3
R542 VSS.n636 VSS.n255 177.3
R543 VSS.n636 VSS.n262 177.3
R544 VSS.n633 VSS.n262 177.3
R545 VSS.n633 VSS.n265 177.3
R546 VSS.n626 VSS.n265 177.3
R547 VSS.n626 VSS.n270 177.3
R548 VSS.n623 VSS.n270 177.3
R549 VSS.n623 VSS.n273 177.3
R550 VSS.n617 VSS.n273 177.3
R551 VSS.n617 VSS.n280 177.3
R552 VSS.n614 VSS.n280 177.3
R553 VSS.n614 VSS.n283 177.3
R554 VSS.n606 VSS.n283 177.3
R555 VSS.n606 VSS.n288 177.3
R556 VSS.n603 VSS.n288 177.3
R557 VSS.n603 VSS.n291 177.3
R558 VSS.n597 VSS.n291 177.3
R559 VSS.n597 VSS.n298 177.3
R560 VSS.n594 VSS.n298 177.3
R561 VSS.n594 VSS.n301 177.3
R562 VSS.n587 VSS.n301 177.3
R563 VSS.n587 VSS.n306 177.3
R564 VSS.n584 VSS.n306 177.3
R565 VSS.n584 VSS.n309 177.3
R566 VSS.n576 VSS.n309 177.3
R567 VSS.n576 VSS.n315 177.3
R568 VSS.n573 VSS.n315 177.3
R569 VSS.n573 VSS.n318 177.3
R570 VSS.n565 VSS.n318 177.3
R571 VSS.n565 VSS.n325 177.3
R572 VSS.n562 VSS.n325 177.3
R573 VSS.n562 VSS.n328 177.3
R574 VSS.n555 VSS.n328 177.3
R575 VSS.n555 VSS.n333 177.3
R576 VSS.n552 VSS.n333 177.3
R577 VSS.n552 VSS.n336 177.3
R578 VSS.n545 VSS.n336 177.3
R579 VSS.n545 VSS.n343 177.3
R580 VSS.n542 VSS.n343 177.3
R581 VSS.n542 VSS.n346 177.3
R582 VSS.n535 VSS.n346 177.3
R583 VSS.n535 VSS.n352 177.3
R584 VSS.n532 VSS.n352 177.3
R585 VSS.n532 VSS.n355 177.3
R586 VSS.n524 VSS.n355 177.3
R587 VSS.n524 VSS.n361 177.3
R588 VSS.n521 VSS.n361 177.3
R589 VSS.n521 VSS.n364 177.3
R590 VSS.n513 VSS.n364 177.3
R591 VSS.n513 VSS.n371 177.3
R592 VSS.n510 VSS.n371 177.3
R593 VSS.n510 VSS.n374 177.3
R594 VSS.n503 VSS.n374 177.3
R595 VSS.n503 VSS.n380 177.3
R596 VSS.n500 VSS.n380 177.3
R597 VSS.n500 VSS.n383 177.3
R598 VSS.n494 VSS.n383 177.3
R599 VSS.n494 VSS.n390 177.3
R600 VSS.n491 VSS.n390 177.3
R601 VSS.n486 VSS.n484 177.3
R602 VSS.n482 VSS.n397 177.3
R603 VSS.n479 VSS.n477 177.3
R604 VSS.n475 VSS.n400 177.3
R605 VSS.n472 VSS.n470 177.3
R606 VSS.n468 VSS.n403 177.3
R607 VSS.n465 VSS.n463 177.3
R608 VSS.n463 VSS.n462 177.3
R609 VSS.n459 VSS.n458 177.3
R610 VSS.n456 VSS.n455 177.3
R611 VSS.n452 VSS.n412 177.3
R612 VSS.n450 VSS.n449 177.3
R613 VSS.n447 VSS.n414 177.3
R614 VSS.n444 VSS.n442 177.3
R615 VSS.n440 VSS.n417 177.3
R616 VSS.n437 VSS.n435 177.3
R617 VSS.n435 VSS.n434 177.3
R618 VSS.n431 VSS.n430 177.3
R619 VSS.n431 VSS.n429 177.3
R620 VSS.n427 VSS.n424 177.3
R621 VSS.n725 VSS.n153 177.3
R622 VSS.n725 VSS.n724 177.3
R623 VSS.n724 VSS.n180 177.3
R624 VSS.n721 VSS.n180 177.3
R625 VSS.n721 VSS.n183 177.3
R626 VSS.n713 VSS.n183 177.3
R627 VSS.n713 VSS.n191 177.3
R628 VSS.n710 VSS.n191 177.3
R629 VSS.n710 VSS.n193 177.3
R630 VSS.n702 VSS.n193 177.3
R631 VSS.n702 VSS.n199 177.3
R632 VSS.n699 VSS.n199 177.3
R633 VSS.n699 VSS.n202 177.3
R634 VSS.n692 VSS.n202 177.3
R635 VSS.n692 VSS.n209 177.3
R636 VSS.n689 VSS.n209 177.3
R637 VSS.n689 VSS.n211 177.3
R638 VSS.n682 VSS.n211 177.3
R639 VSS.n682 VSS.n219 177.3
R640 VSS.n679 VSS.n219 177.3
R641 VSS.n679 VSS.n222 177.3
R642 VSS.n673 VSS.n222 177.3
R643 VSS.n673 VSS.n228 177.3
R644 VSS.n670 VSS.n228 177.3
R645 VSS.n670 VSS.n231 177.3
R646 VSS.n662 VSS.n231 177.3
R647 VSS.n662 VSS.n237 177.3
R648 VSS.n659 VSS.n237 177.3
R649 VSS.n659 VSS.n240 177.3
R650 VSS.n651 VSS.n240 177.3
R651 VSS.n651 VSS.n246 177.3
R652 VSS.n648 VSS.n246 177.3
R653 VSS.n648 VSS.n249 177.3
R654 VSS.n641 VSS.n249 177.3
R655 VSS.n641 VSS.n257 177.3
R656 VSS.n638 VSS.n257 177.3
R657 VSS.n638 VSS.n260 177.3
R658 VSS.n631 VSS.n260 177.3
R659 VSS.n631 VSS.n266 177.3
R660 VSS.n628 VSS.n266 177.3
R661 VSS.n628 VSS.n268 177.3
R662 VSS.n622 VSS.n268 177.3
R663 VSS.n622 VSS.n275 177.3
R664 VSS.n619 VSS.n275 177.3
R665 VSS.n619 VSS.n278 177.3
R666 VSS.n611 VSS.n278 177.3
R667 VSS.n611 VSS.n285 177.3
R668 VSS.n608 VSS.n285 177.3
R669 VSS.n608 VSS.n286 177.3
R670 VSS.n601 VSS.n286 177.3
R671 VSS.n601 VSS.n292 177.3
R672 VSS.n598 VSS.n292 177.3
R673 VSS.n598 VSS.n295 177.3
R674 VSS.n592 VSS.n295 177.3
R675 VSS.n592 VSS.n302 177.3
R676 VSS.n589 VSS.n302 177.3
R677 VSS.n589 VSS.n304 177.3
R678 VSS.n581 VSS.n304 177.3
R679 VSS.n581 VSS.n310 177.3
R680 VSS.n578 VSS.n310 177.3
R681 VSS.n578 VSS.n313 177.3
R682 VSS.n570 VSS.n313 177.3
R683 VSS.n570 VSS.n319 177.3
R684 VSS.n567 VSS.n319 177.3
R685 VSS.n567 VSS.n322 177.3
R686 VSS.n560 VSS.n322 177.3
R687 VSS.n560 VSS.n329 177.3
R688 VSS.n557 VSS.n329 177.3
R689 VSS.n557 VSS.n331 177.3
R690 VSS.n549 VSS.n331 177.3
R691 VSS.n549 VSS.n337 177.3
R692 VSS.n546 VSS.n337 177.3
R693 VSS.n546 VSS.n340 177.3
R694 VSS.n540 VSS.n340 177.3
R695 VSS.n540 VSS.n347 177.3
R696 VSS.n537 VSS.n347 177.3
R697 VSS.n537 VSS.n350 177.3
R698 VSS.n529 VSS.n350 177.3
R699 VSS.n529 VSS.n356 177.3
R700 VSS.n526 VSS.n356 177.3
R701 VSS.n526 VSS.n359 177.3
R702 VSS.n518 VSS.n359 177.3
R703 VSS.n518 VSS.n366 177.3
R704 VSS.n515 VSS.n366 177.3
R705 VSS.n515 VSS.n369 177.3
R706 VSS.n508 VSS.n369 177.3
R707 VSS.n508 VSS.n376 177.3
R708 VSS.n505 VSS.n376 177.3
R709 VSS.n505 VSS.n378 177.3
R710 VSS.n498 VSS.n378 177.3
R711 VSS.n498 VSS.n385 177.3
R712 VSS.n495 VSS.n385 177.3
R713 VSS.n495 VSS.n388 177.3
R714 VSS.n489 VSS.n388 177.3
R715 VSS.n771 VSS.n155 177.3
R716 VSS.n770 VSS.n769 177.3
R717 VSS.n767 VSS.n766 177.3
R718 VSS.n765 VSS.n764 177.3
R719 VSS.n762 VSS.n761 177.3
R720 VSS.n760 VSS.n759 177.3
R721 VSS.n757 VSS.n756 177.3
R722 VSS.n755 VSS.n754 177.3
R723 VSS.n752 VSS.n751 177.3
R724 VSS.n750 VSS.n749 177.3
R725 VSS.n747 VSS.n746 177.3
R726 VSS.n745 VSS.n744 177.3
R727 VSS.n742 VSS.n741 177.3
R728 VSS.n740 VSS.n739 177.3
R729 VSS.n737 VSS.n736 177.3
R730 VSS.n735 VSS.n734 177.3
R731 VSS.n732 VSS.n731 177.3
R732 VSS.n730 VSS.n729 177.3
R733 VSS.n800 VSS.n176 177.3
R734 VSS.n151 VSS.n147 144
R735 VSS.n801 VSS.n156 101.882
R736 VSS.n490 VSS.n394 101.882
R737 VSS.n485 VSS.n395 76.985
R738 VSS.n483 VSS.n482 76.985
R739 VSS.n479 VSS.n478 76.985
R740 VSS.n476 VSS.n475 76.985
R741 VSS.n471 VSS.n400 76.985
R742 VSS.n469 VSS.n468 76.985
R743 VSS.n465 VSS.n464 76.985
R744 VSS.n458 VSS.n406 76.985
R745 VSS.n457 VSS.n456 76.985
R746 VSS.n412 VSS.n409 76.985
R747 VSS.n452 VSS.n451 76.985
R748 VSS.n449 VSS.n448 76.985
R749 VSS.n444 VSS.n443 76.985
R750 VSS.n441 VSS.n440 76.985
R751 VSS.n437 VSS.n436 76.985
R752 VSS.n430 VSS.n420 76.985
R753 VSS.n428 VSS.n427 76.985
R754 VSS.n424 VSS.n423 76.985
R755 VSS.n176 VSS.n174 76.985
R756 VSS.n730 VSS.n173 76.985
R757 VSS.n732 VSS.n172 76.985
R758 VSS.n735 VSS.n171 76.985
R759 VSS.n737 VSS.n170 76.985
R760 VSS.n740 VSS.n169 76.985
R761 VSS.n742 VSS.n168 76.985
R762 VSS.n745 VSS.n167 76.985
R763 VSS.n747 VSS.n166 76.985
R764 VSS.n750 VSS.n165 76.985
R765 VSS.n752 VSS.n164 76.985
R766 VSS.n755 VSS.n163 76.985
R767 VSS.n757 VSS.n162 76.985
R768 VSS.n760 VSS.n161 76.985
R769 VSS.n762 VSS.n160 76.985
R770 VSS.n765 VSS.n159 76.985
R771 VSS.n767 VSS.n158 76.985
R772 VSS.n770 VSS.n157 76.985
R773 VSS.n802 VSS.n155 76.985
R774 VSS.n486 VSS.n485 76.985
R775 VSS.n484 VSS.n483 76.985
R776 VSS.n478 VSS.n397 76.985
R777 VSS.n477 VSS.n476 76.985
R778 VSS.n472 VSS.n471 76.985
R779 VSS.n470 VSS.n469 76.985
R780 VSS.n464 VSS.n403 76.985
R781 VSS.n462 VSS.n406 76.985
R782 VSS.n459 VSS.n457 76.985
R783 VSS.n455 VSS.n409 76.985
R784 VSS.n451 VSS.n450 76.985
R785 VSS.n448 VSS.n447 76.985
R786 VSS.n443 VSS.n414 76.985
R787 VSS.n442 VSS.n441 76.985
R788 VSS.n436 VSS.n417 76.985
R789 VSS.n434 VSS.n420 76.985
R790 VSS.n429 VSS.n428 76.985
R791 VSS.n423 VSS.n393 76.985
R792 VSS.n803 VSS.n802 76.985
R793 VSS.n771 VSS.n157 76.985
R794 VSS.n769 VSS.n158 76.985
R795 VSS.n766 VSS.n159 76.985
R796 VSS.n764 VSS.n160 76.985
R797 VSS.n761 VSS.n161 76.985
R798 VSS.n759 VSS.n162 76.985
R799 VSS.n756 VSS.n163 76.985
R800 VSS.n754 VSS.n164 76.985
R801 VSS.n751 VSS.n165 76.985
R802 VSS.n749 VSS.n166 76.985
R803 VSS.n746 VSS.n167 76.985
R804 VSS.n744 VSS.n168 76.985
R805 VSS.n741 VSS.n169 76.985
R806 VSS.n739 VSS.n170 76.985
R807 VSS.n736 VSS.n171 76.985
R808 VSS.n734 VSS.n172 76.985
R809 VSS.n731 VSS.n173 76.985
R810 VSS.n729 VSS.n174 76.985
R811 VSS.n726 VSS.n156 76.4115
R812 VSS.n726 VSS.t0 76.4115
R813 VSS.n184 VSS.t0 76.4115
R814 VSS.n720 VSS.n184 76.4115
R815 VSS.n715 VSS.n714 76.4115
R816 VSS.n709 VSS.n194 76.4115
R817 VSS.n704 VSS.n703 76.4115
R818 VSS.n698 VSS.n204 76.4115
R819 VSS.n698 VSS.n203 76.4115
R820 VSS.n688 VSS.n212 76.4115
R821 VSS.n683 VSS.n218 76.4115
R822 VSS.n678 VSS.n223 76.4115
R823 VSS.t10 VSS.n223 76.4115
R824 VSS.n653 VSS.n652 76.4115
R825 VSS.n647 VSS.n250 76.4115
R826 VSS.n642 VSS.n256 76.4115
R827 VSS.n637 VSS.n261 76.4115
R828 VSS.t19 VSS.n274 76.4115
R829 VSS.n613 VSS.n612 76.4115
R830 VSS.n613 VSS.n284 76.4115
R831 VSS.n607 VSS.n284 76.4115
R832 VSS.n607 VSS.n287 76.4115
R833 VSS.t24 VSS.n296 76.4115
R834 VSS.n583 VSS.n582 76.4115
R835 VSS.n577 VSS.n314 76.4115
R836 VSS.n572 VSS.n571 76.4115
R837 VSS.n566 VSS.n323 76.4115
R838 VSS.t34 VSS.n341 76.4115
R839 VSS.n541 VSS.n341 76.4115
R840 VSS.n536 VSS.n351 76.4115
R841 VSS.n531 VSS.n530 76.4115
R842 VSS.n520 VSS.n519 76.4115
R843 VSS.n520 VSS.n365 76.4115
R844 VSS.n514 VSS.n370 76.4115
R845 VSS.n509 VSS.n375 76.4115
R846 VSS.n504 VSS.n379 76.4115
R847 VSS.n499 VSS.n384 76.4115
R848 VSS.t43 VSS.n384 76.4115
R849 VSS.t43 VSS.n389 76.4115
R850 VSS.n490 VSS.n389 76.4115
R851 VSS.n627 VSS.t67 73.2277
R852 VSS.n593 VSS.t74 73.2277
R853 VSS.t1 VSS.n147 72.0005
R854 VSS.n704 VSS.t5 67.9214
R855 VSS.n693 VSS.t6 67.9214
R856 VSS.n642 VSS.t15 67.9214
R857 VSS.n577 VSS.t29 67.9214
R858 VSS.n342 VSS.t59 67.9214
R859 VSS.n525 VSS.t38 67.9214
R860 VSS.n514 VSS.t39 67.9214
R861 VSS.t46 VSS.n232 66.8601
R862 VSS.n664 VSS.t47 66.8601
R863 VSS.n556 VSS.t58 66.8601
R864 VSS.n279 VSS.t68 60.4925
R865 VSS.t73 VSS.n297 60.4925
R866 VSS.n714 VSS.t2 59.4313
R867 VSS.t9 VSS.n218 59.4313
R868 VSS.n663 VSS.t11 59.4313
R869 VSS.t14 VSS.t51 59.4313
R870 VSS.t33 VSS.n550 59.4313
R871 VSS.n351 VSS.t35 59.4313
R872 VSS.t42 VSS.n379 59.4313
R873 VSS.t54 VSS.t30 58.37
R874 VSS.t66 VSS.n269 54.125
R875 VSS.n305 VSS.t75 54.125
R876 VSS.n709 VSS.t4 50.9412
R877 VSS.n688 VSS.t7 50.9412
R878 VSS.n658 VSS.t13 50.9412
R879 VSS.n561 VSS.t31 50.9412
R880 VSS.n531 VSS.t37 50.9412
R881 VSS.n509 VSS.t40 50.9412
R882 VSS.n647 VSS.t52 48.8186
R883 VSS.t28 VSS.t78 48.8186
R884 VSS.t34 VSS.t60 48.8186
R885 VSS.n693 VSS.t62 47.7574
R886 VSS.t10 VSS.t45 47.7574
R887 VSS.t49 VSS.n241 47.7574
R888 VSS.t63 VSS.t16 47.7574
R889 VSS.n572 VSS.t53 47.7574
R890 VSS.n332 VSS.t56 47.7574
R891 VSS.n525 VSS.t61 47.7574
R892 VSS.n194 VSS.t3 42.4511
R893 VSS.t8 VSS.n212 42.4511
R894 VSS.n241 VSS.t12 42.4511
R895 VSS.n618 VSS.t69 42.4511
R896 VSS.t32 VSS.n332 42.4511
R897 VSS.n530 VSS.t36 42.4511
R898 VSS.t41 VSS.n375 42.4511
R899 VSS.n269 VSS.t65 41.3898
R900 VSS.n602 VSS.t72 41.3898
R901 VSS.t76 VSS.n305 41.3898
R902 VSS.t22 VSS.t71 37.1447
R903 VSS.t70 VSS.t20 36.0835
R904 VSS.n632 VSS.t65 35.0222
R905 VSS.n297 VSS.t72 35.0222
R906 VSS.n588 VSS.t76 35.0222
R907 VSS.n715 VSS.t3 33.9609
R908 VSS.n683 VSS.t8 33.9609
R909 VSS.n632 VSS.t17 33.9609
R910 VSS.t69 VSS.n279 33.9609
R911 VSS.n588 VSS.t27 33.9609
R912 VSS.n536 VSS.t36 33.9609
R913 VSS.n504 VSS.t41 33.9609
R914 VSS.n488 VSS.n13 30.5605
R915 VSS.n805 VSS.n804 30.5605
R916 VSS.n799 VSS.n12 30.5605
R917 VSS.n492 VSS.n392 30.5605
R918 VSS.n213 VSS.t62 28.6546
R919 VSS.n232 VSS.t45 28.6546
R920 VSS.n664 VSS.t48 28.6546
R921 VSS.n658 VSS.t49 28.6546
R922 VSS.n324 VSS.t53 28.6546
R923 VSS.n561 VSS.t56 28.6546
R924 VSS.n556 VSS.t57 28.6546
R925 VSS.t61 VSS.n360 28.6546
R926 VSS.t52 VSS.n251 27.5934
R927 VSS.t60 VSS.n342 27.5934
R928 VSS.n150 VSS.n14 5.51637
R929 VSS.n150 VSS.n148 27.1064
R930 VSS VSS.t21 92.0331
R931 VSS.t25 VSS.t23 91.2715
R932 VSS.n10 VSS.t44 91.2715
R933 VSS.t17 VSS.t64 26.5321
R934 VSS VSS.n152 25.7818
R935 VSS.n703 VSS.t4 25.4708
R936 VSS.t7 VSS.n213 25.4708
R937 VSS.t16 VSS.n256 25.4708
R938 VSS.t77 VSS.t27 25.4708
R939 VSS.n314 VSS.t28 25.4708
R940 VSS.n360 VSS.t37 25.4708
R941 VSS.t40 VSS.n370 25.4708
R942 VSS.n612 VSS.t70 23.3483
R943 VSS.t71 VSS.n287 22.287
R944 VSS.n720 VSS.t2 16.9807
R945 VSS.n678 VSS.t9 16.9807
R946 VSS.n669 VSS.t11 16.9807
R947 VSS.n627 VSS.t18 16.9807
R948 VSS.n618 VSS.t20 16.9807
R949 VSS.n602 VSS.t22 16.9807
R950 VSS.n593 VSS.t26 16.9807
R951 VSS.n582 VSS.t77 16.9807
R952 VSS.n551 VSS.t33 16.9807
R953 VSS.n541 VSS.t35 16.9807
R954 VSS.n499 VSS.t42 16.9807
R955 VSS.t50 VSS.t13 15.9195
R956 VSS.t64 VSS.n261 15.9195
R957 VSS.t19 VSS.t68 15.9195
R958 VSS.t24 VSS.t73 15.9195
R959 VSS.t31 VSS.t55 15.9195
R960 VSS.n487 VSS.n13 11.5205
R961 VSS.n81 VSS.n396 3.55797
R962 VSS.n481 VSS.n396 11.5205
R963 VSS.n82 VSS.n398 3.55797
R964 VSS.n480 VSS.n398 11.5205
R965 VSS.n83 VSS.n399 3.55797
R966 VSS.n474 VSS.n399 11.5205
R967 VSS.n84 VSS.n401 3.55797
R968 VSS.n473 VSS.n401 11.5205
R969 VSS.n85 VSS.n402 3.55797
R970 VSS.n467 VSS.n402 11.5205
R971 VSS.n86 VSS.n404 3.55797
R972 VSS.n466 VSS.n404 11.5205
R973 VSS.n87 VSS.n405 3.55797
R974 VSS.n461 VSS.n405 11.5205
R975 VSS.n88 VSS.n407 3.55797
R976 VSS.n460 VSS.n407 11.5205
R977 VSS.n89 VSS.n408 3.55797
R978 VSS.n454 VSS.n408 11.5205
R979 VSS.n90 VSS.n410 3.55797
R980 VSS.n453 VSS.n410 11.5205
R981 VSS.n91 VSS.n411 3.55797
R982 VSS.n413 VSS.n411 11.5205
R983 VSS.n446 VSS.n92 3.55797
R984 VSS.n446 VSS.n415 11.5205
R985 VSS.n445 VSS.n93 3.55797
R986 VSS.n445 VSS.n416 11.5205
R987 VSS.n439 VSS.n94 3.55797
R988 VSS.n439 VSS.n418 11.5205
R989 VSS.n438 VSS.n95 3.55797
R990 VSS.n438 VSS.n419 11.5205
R991 VSS.n433 VSS.n96 3.55797
R992 VSS.n433 VSS.n421 11.5205
R993 VSS.n432 VSS.n97 3.55797
R994 VSS.n432 VSS.n422 11.5205
R995 VSS.n426 VSS.n98 3.55797
R996 VSS.n426 VSS.n425 11.5205
R997 VSS.n99 VSS.n392 3.55797
R998 VSS.n805 VSS.n142 3.55797
R999 VSS.n723 VSS.n146 11.5205
R1000 VSS.n105 VSS.n181 3.55797
R1001 VSS.n722 VSS.n181 11.5205
R1002 VSS.n722 VSS.n182 11.5205
R1003 VSS.n133 VSS.n182 3.55797
R1004 VSS.n712 VSS.n102 11.5205
R1005 VSS.n711 VSS.n102 11.5205
R1006 VSS.n106 VSS.n192 3.55797
R1007 VSS.n701 VSS.n192 11.5205
R1008 VSS.n701 VSS.n200 11.5205
R1009 VSS.n700 VSS.n107 3.55797
R1010 VSS.n700 VSS.n201 11.5205
R1011 VSS.n691 VSS.n108 3.55797
R1012 VSS.n691 VSS.n103 11.5205
R1013 VSS.n690 VSS.n103 11.5205
R1014 VSS.n109 VSS.n210 3.55797
R1015 VSS.n681 VSS.n210 11.5205
R1016 VSS.n134 VSS.n220 3.55797
R1017 VSS.n680 VSS.n220 11.5205
R1018 VSS.n680 VSS.n221 11.5205
R1019 VSS.n672 VSS.n110 3.55797
R1020 VSS.n672 VSS.n229 11.5205
R1021 VSS.n671 VSS.n135 3.55797
R1022 VSS.n671 VSS.n230 11.5205
R1023 VSS.n661 VSS.n230 11.5205
R1024 VSS.n111 VSS.n238 3.55797
R1025 VSS.n660 VSS.n238 11.5205
R1026 VSS.n660 VSS.n239 11.5205
R1027 VSS.n650 VSS.n112 3.55797
R1028 VSS.n650 VSS.n247 11.5205
R1029 VSS.n649 VSS.n113 3.55797
R1030 VSS.n649 VSS.n248 11.5205
R1031 VSS.n640 VSS.n114 3.55797
R1032 VSS.n640 VSS.n258 11.5205
R1033 VSS.n639 VSS.n115 3.55797
R1034 VSS.n639 VSS.n259 11.5205
R1035 VSS.n630 VSS.n116 3.55797
R1036 VSS.n630 VSS.n117 11.5205
R1037 VSS.n629 VSS.n117 11.5205
R1038 VSS.n629 VSS.n140 3.55797
R1039 VSS.n621 VSS.n267 11.5205
R1040 VSS.n118 VSS.n276 3.55797
R1041 VSS.n620 VSS.n276 11.5205
R1042 VSS.n620 VSS.n277 11.5205
R1043 VSS.n144 VSS.n277 3.55797
R1044 VSS.n610 VSS.n100 11.5205
R1045 VSS.n609 VSS.n100 11.5205
R1046 VSS.n143 VSS.n145 3.55797
R1047 VSS.n600 VSS.n145 11.5205
R1048 VSS.n119 VSS.n293 3.55797
R1049 VSS.n599 VSS.n293 11.5205
R1050 VSS.n599 VSS.n294 11.5205
R1051 VSS.n136 VSS.n294 3.55797
R1052 VSS.n591 VSS.n101 11.5205
R1053 VSS.n590 VSS.n101 11.5205
R1054 VSS.n120 VSS.n303 3.55797
R1055 VSS.n580 VSS.n303 11.5205
R1056 VSS.n580 VSS.n311 11.5205
R1057 VSS.n579 VSS.n121 3.55797
R1058 VSS.n579 VSS.n312 11.5205
R1059 VSS.n569 VSS.n122 3.55797
R1060 VSS.n569 VSS.n320 11.5205
R1061 VSS.n568 VSS.n123 3.55797
R1062 VSS.n568 VSS.n321 11.5205
R1063 VSS.n559 VSS.n124 3.55797
R1064 VSS.n559 VSS.n104 11.5205
R1065 VSS.n558 VSS.n104 11.5205
R1066 VSS.n125 VSS.n330 3.55797
R1067 VSS.n548 VSS.n330 11.5205
R1068 VSS.n137 VSS.n338 3.55797
R1069 VSS.n547 VSS.n338 11.5205
R1070 VSS.n547 VSS.n339 11.5205
R1071 VSS.n539 VSS.n126 3.55797
R1072 VSS.n539 VSS.n348 11.5205
R1073 VSS.n538 VSS.n138 3.55797
R1074 VSS.n538 VSS.n349 11.5205
R1075 VSS.n528 VSS.n349 11.5205
R1076 VSS.n127 VSS.n357 3.55797
R1077 VSS.n527 VSS.n357 11.5205
R1078 VSS.n527 VSS.n358 11.5205
R1079 VSS.n517 VSS.n128 3.55797
R1080 VSS.n517 VSS.n367 11.5205
R1081 VSS.n516 VSS.n129 3.55797
R1082 VSS.n516 VSS.n368 11.5205
R1083 VSS.n507 VSS.n130 3.55797
R1084 VSS.n507 VSS.n131 11.5205
R1085 VSS.n506 VSS.n131 11.5205
R1086 VSS.n506 VSS.n139 3.55797
R1087 VSS.n497 VSS.n377 11.5205
R1088 VSS.n497 VSS.n386 11.5205
R1089 VSS.n496 VSS.n132 3.55797
R1090 VSS.n496 VSS.n387 11.5205
R1091 VSS.n488 VSS.n141 3.55797
R1092 VSS.n804 VSS.n154 11.5205
R1093 VSS.n772 VSS.n15 3.55797
R1094 VSS.n773 VSS.n772 11.5205
R1095 VSS.n774 VSS.n16 3.55797
R1096 VSS.n774 VSS.n768 11.5205
R1097 VSS.n775 VSS.n17 3.55797
R1098 VSS.n776 VSS.n775 11.5205
R1099 VSS.n777 VSS.n18 3.55797
R1100 VSS.n777 VSS.n763 11.5205
R1101 VSS.n778 VSS.n19 3.55797
R1102 VSS.n779 VSS.n778 11.5205
R1103 VSS.n780 VSS.n20 3.55797
R1104 VSS.n780 VSS.n758 11.5205
R1105 VSS.n781 VSS.n21 3.55797
R1106 VSS.n782 VSS.n781 11.5205
R1107 VSS.n783 VSS.n22 3.55797
R1108 VSS.n783 VSS.n753 11.5205
R1109 VSS.n784 VSS.n23 3.55797
R1110 VSS.n785 VSS.n784 11.5205
R1111 VSS.n786 VSS.n24 3.55797
R1112 VSS.n786 VSS.n748 11.5205
R1113 VSS.n787 VSS.n25 3.55797
R1114 VSS.n788 VSS.n787 11.5205
R1115 VSS.n789 VSS.n26 3.55797
R1116 VSS.n789 VSS.n743 11.5205
R1117 VSS.n790 VSS.n27 3.55797
R1118 VSS.n791 VSS.n790 11.5205
R1119 VSS.n792 VSS.n28 3.55797
R1120 VSS.n792 VSS.n738 11.5205
R1121 VSS.n793 VSS.n29 3.55797
R1122 VSS.n794 VSS.n793 11.5205
R1123 VSS.n795 VSS.n30 3.55797
R1124 VSS.n795 VSS.n733 11.5205
R1125 VSS.n796 VSS.n31 3.55797
R1126 VSS.n797 VSS.n796 11.5205
R1127 VSS.n798 VSS.n32 3.55797
R1128 VSS.n798 VSS.n177 11.5205
R1129 VSS.n799 VSS.n33 3.55797
R1130 VSS.n728 VSS.n12 11.5205
R1131 VSS.n34 VSS.n178 3.55797
R1132 VSS.n188 VSS.n178 11.5205
R1133 VSS.n718 VSS.n35 3.55797
R1134 VSS.n718 VSS.n187 11.5205
R1135 VSS.n717 VSS.n36 3.55797
R1136 VSS.n717 VSS.n189 11.5205
R1137 VSS.n707 VSS.n37 3.55797
R1138 VSS.n707 VSS.n196 11.5205
R1139 VSS.n706 VSS.n38 3.55797
R1140 VSS.n706 VSS.n197 11.5205
R1141 VSS.n696 VSS.n39 3.55797
R1142 VSS.n696 VSS.n206 11.5205
R1143 VSS.n695 VSS.n40 3.55797
R1144 VSS.n695 VSS.n207 11.5205
R1145 VSS.n686 VSS.n41 3.55797
R1146 VSS.n686 VSS.n215 11.5205
R1147 VSS.n685 VSS.n42 3.55797
R1148 VSS.n685 VSS.n216 11.5205
R1149 VSS.n676 VSS.n43 3.55797
R1150 VSS.n676 VSS.n225 11.5205
R1151 VSS.n675 VSS.n44 3.55797
R1152 VSS.n675 VSS.n226 11.5205
R1153 VSS.n667 VSS.n45 3.55797
R1154 VSS.n667 VSS.n234 11.5205
R1155 VSS.n666 VSS.n46 3.55797
R1156 VSS.n666 VSS.n235 11.5205
R1157 VSS.n656 VSS.n47 3.55797
R1158 VSS.n656 VSS.n243 11.5205
R1159 VSS.n655 VSS.n48 3.55797
R1160 VSS.n655 VSS.n244 11.5205
R1161 VSS.n645 VSS.n49 3.55797
R1162 VSS.n645 VSS.n253 11.5205
R1163 VSS.n644 VSS.n50 3.55797
R1164 VSS.n644 VSS.n254 11.5205
R1165 VSS.n635 VSS.n51 3.55797
R1166 VSS.n635 VSS.n263 11.5205
R1167 VSS.n634 VSS.n52 3.55797
R1168 VSS.n634 VSS.n264 11.5205
R1169 VSS.n625 VSS.n53 3.55797
R1170 VSS.n625 VSS.n271 11.5205
R1171 VSS.n624 VSS.n54 3.55797
R1172 VSS.n624 VSS.n272 11.5205
R1173 VSS.n616 VSS.n55 3.55797
R1174 VSS.n616 VSS.n281 11.5205
R1175 VSS.n615 VSS.n56 3.55797
R1176 VSS.n615 VSS.n282 11.5205
R1177 VSS.n605 VSS.n57 3.55797
R1178 VSS.n605 VSS.n289 11.5205
R1179 VSS.n604 VSS.n58 3.55797
R1180 VSS.n604 VSS.n290 11.5205
R1181 VSS.n596 VSS.n59 3.55797
R1182 VSS.n596 VSS.n299 11.5205
R1183 VSS.n595 VSS.n60 3.55797
R1184 VSS.n595 VSS.n300 11.5205
R1185 VSS.n586 VSS.n61 3.55797
R1186 VSS.n586 VSS.n307 11.5205
R1187 VSS.n585 VSS.n62 3.55797
R1188 VSS.n585 VSS.n308 11.5205
R1189 VSS.n575 VSS.n63 3.55797
R1190 VSS.n575 VSS.n316 11.5205
R1191 VSS.n574 VSS.n64 3.55797
R1192 VSS.n574 VSS.n317 11.5205
R1193 VSS.n564 VSS.n65 3.55797
R1194 VSS.n564 VSS.n326 11.5205
R1195 VSS.n563 VSS.n66 3.55797
R1196 VSS.n563 VSS.n327 11.5205
R1197 VSS.n554 VSS.n67 3.55797
R1198 VSS.n554 VSS.n334 11.5205
R1199 VSS.n553 VSS.n68 3.55797
R1200 VSS.n553 VSS.n335 11.5205
R1201 VSS.n544 VSS.n69 3.55797
R1202 VSS.n544 VSS.n344 11.5205
R1203 VSS.n543 VSS.n70 3.55797
R1204 VSS.n543 VSS.n345 11.5205
R1205 VSS.n534 VSS.n71 3.55797
R1206 VSS.n534 VSS.n353 11.5205
R1207 VSS.n533 VSS.n72 3.55797
R1208 VSS.n533 VSS.n354 11.5205
R1209 VSS.n523 VSS.n73 3.55797
R1210 VSS.n523 VSS.n362 11.5205
R1211 VSS.n522 VSS.n74 3.55797
R1212 VSS.n522 VSS.n363 11.5205
R1213 VSS.n512 VSS.n75 3.55797
R1214 VSS.n512 VSS.n372 11.5205
R1215 VSS.n511 VSS.n76 3.55797
R1216 VSS.n511 VSS.n373 11.5205
R1217 VSS.n502 VSS.n77 3.55797
R1218 VSS.n502 VSS.n381 11.5205
R1219 VSS.n501 VSS.n78 3.55797
R1220 VSS.n501 VSS.n382 11.5205
R1221 VSS.n493 VSS.n79 3.55797
R1222 VSS.n493 VSS.n391 11.5205
R1223 VSS.n492 VSS.n80 3.55797
R1224 VSS.n669 VSS.t46 9.55188
R1225 VSS.t47 VSS.n663 9.55188
R1226 VSS.n652 VSS.t50 9.55188
R1227 VSS.n566 VSS.t54 9.55188
R1228 VSS.t55 VSS.n323 9.55188
R1229 VSS.n550 VSS.t58 9.55188
R1230 VSS.n141 VSS.n10 2.87251
R1231 VSS.n387 VSS.n141 3.55797
R1232 VSS.n10 VSS.n132 2.87251
R1233 VSS.n132 VSS.n386 3.55797
R1234 VSS.n497 VSS.n10 9.3005
R1235 VSS.n139 VSS.n377 3.55797
R1236 VSS.t25 VSS.n139 2.87251
R1237 VSS.t25 VSS.n131 9.3005
R1238 VSS.n130 VSS.t25 2.87251
R1239 VSS.n130 VSS.n368 3.55797
R1240 VSS.t25 VSS.n129 2.87251
R1241 VSS.n129 VSS.n367 3.55797
R1242 VSS.n128 VSS.t25 2.87251
R1243 VSS.n358 VSS.n128 3.55797
R1244 VSS.t25 VSS.n527 9.3005
R1245 VSS.t25 VSS.n127 2.87251
R1246 VSS.n528 VSS.n127 3.55797
R1247 VSS.n349 VSS.t25 9.3005
R1248 VSS.t25 VSS.n138 2.87251
R1249 VSS.n138 VSS.n348 3.55797
R1250 VSS.n126 VSS.t25 2.87251
R1251 VSS.n339 VSS.n126 3.55797
R1252 VSS.t25 VSS.n547 9.3005
R1253 VSS.t25 VSS.n137 2.87251
R1254 VSS.n548 VSS.n137 3.55797
R1255 VSS.n125 VSS.t25 2.87251
R1256 VSS.n125 VSS.n558 3.55797
R1257 VSS.t25 VSS.n104 9.3005
R1258 VSS.n124 VSS.t25 2.87251
R1259 VSS.n321 VSS.n124 3.55797
R1260 VSS.t25 VSS.n123 2.87251
R1261 VSS.n123 VSS.n320 3.55797
R1262 VSS.n122 VSS.t25 2.87251
R1263 VSS.n312 VSS.n122 3.55797
R1264 VSS.t25 VSS.n121 2.87251
R1265 VSS.n121 VSS.n311 3.55797
R1266 VSS.n580 VSS.t25 9.3005
R1267 VSS.n120 VSS.t25 2.87251
R1268 VSS.n120 VSS.n590 3.55797
R1269 VSS.t25 VSS.n101 9.3005
R1270 VSS.n591 VSS.n136 3.55797
R1271 VSS.n136 VSS.t25 2.87251
R1272 VSS.t25 VSS.n599 9.3005
R1273 VSS.t25 VSS.n119 2.87251
R1274 VSS.n600 VSS.n119 3.55797
R1275 VSS.t25 VSS.n143 2.87251
R1276 VSS.n143 VSS.n609 3.55797
R1277 VSS.t25 VSS.n100 9.3005
R1278 VSS.n610 VSS.n144 3.55797
R1279 VSS.n144 VSS 2.87251
R1280 VSS VSS.n620 9.3005
R1281 VSS VSS.n118 2.87251
R1282 VSS.n621 VSS.n118 3.55797
R1283 VSS.n140 VSS.n267 3.55797
R1284 VSS VSS.n140 2.87251
R1285 VSS VSS.n117 9.3005
R1286 VSS.n116 VSS 2.87251
R1287 VSS.n116 VSS.n259 3.55797
R1288 VSS VSS.n115 2.87251
R1289 VSS.n115 VSS.n258 3.55797
R1290 VSS.n114 VSS 2.87251
R1291 VSS.n248 VSS.n114 3.55797
R1292 VSS VSS.n113 2.87251
R1293 VSS.n113 VSS.n247 3.55797
R1294 VSS.n112 VSS 2.87251
R1295 VSS.n239 VSS.n112 3.55797
R1296 VSS VSS.n660 9.3005
R1297 VSS VSS.n111 2.87251
R1298 VSS.n661 VSS.n111 3.55797
R1299 VSS.n230 VSS 9.3005
R1300 VSS VSS.n135 2.87251
R1301 VSS.n135 VSS.n229 3.55797
R1302 VSS.n110 VSS 2.87251
R1303 VSS.n221 VSS.n110 3.55797
R1304 VSS VSS.n680 9.3005
R1305 VSS VSS.n134 2.87251
R1306 VSS.n681 VSS.n134 3.55797
R1307 VSS.n109 VSS 2.87251
R1308 VSS.n109 VSS.n690 3.55797
R1309 VSS VSS.n103 9.3005
R1310 VSS.n108 VSS 2.87251
R1311 VSS.n201 VSS.n108 3.55797
R1312 VSS VSS.n107 2.87251
R1313 VSS.n107 VSS.n200 3.55797
R1314 VSS.n701 VSS 9.3005
R1315 VSS.n106 VSS 2.87251
R1316 VSS.n106 VSS.n711 3.55797
R1317 VSS VSS.n102 9.3005
R1318 VSS.n712 VSS.n133 3.55797
R1319 VSS.n133 VSS 2.87251
R1320 VSS VSS.n722 9.3005
R1321 VSS VSS.n105 2.87251
R1322 VSS.n723 VSS.n105 3.55797
R1323 VSS.n142 VSS.n146 3.55797
R1324 VSS VSS.n142 2.87251
R1325 VSS.n33 VSS.n8 2.87251
R1326 VSS.n33 VSS.n177 3.55797
R1327 VSS.n8 VSS.n32 2.87251
R1328 VSS.n797 VSS.n32 3.55797
R1329 VSS.n31 VSS.n8 2.87251
R1330 VSS.n31 VSS.n733 3.55797
R1331 VSS.n8 VSS.n30 2.87251
R1332 VSS.n794 VSS.n30 3.55797
R1333 VSS.n29 VSS.n8 2.87251
R1334 VSS.n29 VSS.n738 3.55797
R1335 VSS.n8 VSS.n28 2.87251
R1336 VSS.n791 VSS.n28 3.55797
R1337 VSS.n27 VSS.n8 2.87251
R1338 VSS.n27 VSS.n743 3.55797
R1339 VSS.n8 VSS.n26 2.87251
R1340 VSS.n788 VSS.n26 3.55797
R1341 VSS.n25 VSS.n9 2.87251
R1342 VSS.n25 VSS.n748 3.55797
R1343 VSS.n9 VSS.n24 2.87251
R1344 VSS.n785 VSS.n24 3.55797
R1345 VSS.n23 VSS.n9 2.87251
R1346 VSS.n23 VSS.n753 3.55797
R1347 VSS.n9 VSS.n22 2.87251
R1348 VSS.n782 VSS.n22 3.55797
R1349 VSS.n21 VSS.n9 2.87251
R1350 VSS.n21 VSS.n758 3.55797
R1351 VSS.n9 VSS.n20 2.87251
R1352 VSS.n779 VSS.n20 3.55797
R1353 VSS.n19 VSS.n9 2.87251
R1354 VSS.n19 VSS.n763 3.55797
R1355 VSS.n9 VSS.n18 2.87251
R1356 VSS.n776 VSS.n18 3.55797
R1357 VSS.n17 VSS 2.87251
R1358 VSS.n17 VSS.n768 3.55797
R1359 VSS VSS.n16 2.87251
R1360 VSS.n773 VSS.n16 3.55797
R1361 VSS.n15 VSS 2.87251
R1362 VSS.n15 VSS.n154 3.55797
R1363 VSS.n804 VSS 9.3005
R1364 VSS.n7 VSS.n12 9.3005
R1365 VSS.n34 VSS.n728 3.55797
R1366 VSS.n34 VSS.n7 2.87251
R1367 VSS.n35 VSS.n188 3.55797
R1368 VSS.n35 VSS.n7 2.87251
R1369 VSS.n36 VSS.n187 3.55797
R1370 VSS.n7 VSS.n36 2.87251
R1371 VSS.n189 VSS.n37 3.55797
R1372 VSS.n37 VSS.n7 2.87251
R1373 VSS.n38 VSS.n196 3.55797
R1374 VSS.n7 VSS.n38 2.87251
R1375 VSS.n197 VSS.n39 3.55797
R1376 VSS.n39 VSS.n7 2.87251
R1377 VSS.n40 VSS.n206 3.55797
R1378 VSS.n7 VSS.n40 2.87251
R1379 VSS.n207 VSS.n41 3.55797
R1380 VSS.n41 VSS.n6 2.87251
R1381 VSS.n42 VSS.n215 3.55797
R1382 VSS.n6 VSS.n42 2.87251
R1383 VSS.n216 VSS.n43 3.55797
R1384 VSS.n43 VSS.n6 2.87251
R1385 VSS.n44 VSS.n225 3.55797
R1386 VSS.n6 VSS.n44 2.87251
R1387 VSS.n226 VSS.n45 3.55797
R1388 VSS.n45 VSS.n6 2.87251
R1389 VSS.n46 VSS.n234 3.55797
R1390 VSS.n6 VSS.n46 2.87251
R1391 VSS.n235 VSS.n47 3.55797
R1392 VSS.n47 VSS.n6 2.87251
R1393 VSS.n48 VSS.n243 3.55797
R1394 VSS.n6 VSS.n48 2.87251
R1395 VSS.n244 VSS.n49 3.55797
R1396 VSS.n49 VSS.n5 2.87251
R1397 VSS.n50 VSS.n253 3.55797
R1398 VSS.n5 VSS.n50 2.87251
R1399 VSS.n254 VSS.n51 3.55797
R1400 VSS.n51 VSS.n5 2.87251
R1401 VSS.n52 VSS.n263 3.55797
R1402 VSS.n5 VSS.n52 2.87251
R1403 VSS.n264 VSS.n53 3.55797
R1404 VSS.n53 VSS.n5 2.87251
R1405 VSS.n54 VSS.n271 3.55797
R1406 VSS.n5 VSS.n54 2.87251
R1407 VSS.n272 VSS.n55 3.55797
R1408 VSS.n55 VSS.n5 2.87251
R1409 VSS.n56 VSS.n281 3.55797
R1410 VSS.n5 VSS.n56 2.87251
R1411 VSS.n282 VSS.n57 3.55797
R1412 VSS.n57 VSS.n4 2.87251
R1413 VSS.n58 VSS.n289 3.55797
R1414 VSS.n4 VSS.n58 2.87251
R1415 VSS.n290 VSS.n59 3.55797
R1416 VSS.n59 VSS.n4 2.87251
R1417 VSS.n60 VSS.n299 3.55797
R1418 VSS.n4 VSS.n60 2.87251
R1419 VSS.n300 VSS.n61 3.55797
R1420 VSS.n61 VSS.n4 2.87251
R1421 VSS.n62 VSS.n307 3.55797
R1422 VSS.n4 VSS.n62 2.87251
R1423 VSS.n308 VSS.n63 3.55797
R1424 VSS.n63 VSS.n4 2.87251
R1425 VSS.n64 VSS.n316 3.55797
R1426 VSS.n4 VSS.n64 2.87251
R1427 VSS.n317 VSS.n65 3.55797
R1428 VSS.n65 VSS.n3 2.87251
R1429 VSS.n66 VSS.n326 3.55797
R1430 VSS.n3 VSS.n66 2.87251
R1431 VSS.n327 VSS.n67 3.55797
R1432 VSS.n67 VSS.n3 2.87251
R1433 VSS.n68 VSS.n334 3.55797
R1434 VSS.n3 VSS.n68 2.87251
R1435 VSS.n335 VSS.n69 3.55797
R1436 VSS.n69 VSS.n3 2.87251
R1437 VSS.n70 VSS.n344 3.55797
R1438 VSS.n3 VSS.n70 2.87251
R1439 VSS.n345 VSS.n71 3.55797
R1440 VSS.n71 VSS.n3 2.87251
R1441 VSS.n72 VSS.n353 3.55797
R1442 VSS.n3 VSS.n72 2.87251
R1443 VSS.n354 VSS.n73 3.55797
R1444 VSS.n73 VSS.n2 2.87251
R1445 VSS.n74 VSS.n362 3.55797
R1446 VSS.n2 VSS.n74 2.87251
R1447 VSS.n363 VSS.n75 3.55797
R1448 VSS.n75 VSS.n2 2.87251
R1449 VSS.n76 VSS.n372 3.55797
R1450 VSS.n2 VSS.n76 2.87251
R1451 VSS.n373 VSS.n77 3.55797
R1452 VSS.n77 VSS.n0 2.87251
R1453 VSS.n78 VSS.n381 3.55797
R1454 VSS.n0 VSS.n78 2.87251
R1455 VSS.n382 VSS.n79 3.55797
R1456 VSS.n79 VSS.n0 2.87251
R1457 VSS.n80 VSS.n391 3.55797
R1458 VSS.n0 VSS.n80 2.87251
R1459 VSS.n10 VSS.n13 9.3005
R1460 VSS.n81 VSS.n487 3.55797
R1461 VSS.n81 VSS.n10 2.87251
R1462 VSS.n481 VSS.n82 3.55797
R1463 VSS.n10 VSS.n82 2.87251
R1464 VSS.n83 VSS.n480 3.55797
R1465 VSS.n83 VSS.n10 2.87251
R1466 VSS.n474 VSS.n84 3.55797
R1467 VSS.n10 VSS.n84 2.87251
R1468 VSS.n85 VSS.n473 3.55797
R1469 VSS.n85 VSS.n1 2.87251
R1470 VSS.n467 VSS.n86 3.55797
R1471 VSS.n1 VSS.n86 2.87251
R1472 VSS.n87 VSS.n466 3.55797
R1473 VSS.n87 VSS.n1 2.87251
R1474 VSS.n461 VSS.n88 3.55797
R1475 VSS.n1 VSS.n88 2.87251
R1476 VSS.n89 VSS.n460 3.55797
R1477 VSS.n89 VSS.n1 2.87251
R1478 VSS.n454 VSS.n90 3.55797
R1479 VSS.n1 VSS.n90 2.87251
R1480 VSS.n91 VSS.n453 3.55797
R1481 VSS.n91 VSS.n1 2.87251
R1482 VSS.n92 VSS.n413 3.55797
R1483 VSS.n92 VSS.n1 2.87251
R1484 VSS.n93 VSS.n415 3.55797
R1485 VSS.n0 VSS.n93 2.87251
R1486 VSS.n416 VSS.n94 3.55797
R1487 VSS.n94 VSS.n0 2.87251
R1488 VSS.n95 VSS.n418 3.55797
R1489 VSS.n0 VSS.n95 2.87251
R1490 VSS.n419 VSS.n96 3.55797
R1491 VSS.n96 VSS.n0 2.87251
R1492 VSS.n97 VSS.n421 3.55797
R1493 VSS.n0 VSS.n97 2.87251
R1494 VSS.n422 VSS.n98 3.55797
R1495 VSS.n98 VSS.n0 2.87251
R1496 VSS.n99 VSS.n425 3.55797
R1497 VSS.n99 VSS.n0 2.87251
R1498 VSS.n14 VSS.n11 1.89332
R1499 VSS.n152 VSS.n14 14.7842
R1500 VSS.n204 VSS.t5 8.49061
R1501 VSS.t6 VSS.n203 8.49061
R1502 VSS.n653 VSS.t51 8.49061
R1503 VSS.n251 VSS.t14 8.49061
R1504 VSS.t15 VSS.n250 8.49061
R1505 VSS.n571 VSS.t29 8.49061
R1506 VSS.t30 VSS.n324 8.49061
R1507 VSS.n551 VSS.t59 8.49061
R1508 VSS.n519 VSS.t38 8.49061
R1509 VSS.t39 VSS.n365 8.49061
R1510 VSS.n149 VSS.n148 6.31055
R1511 VSS.t12 VSS.t48 5.30682
R1512 VSS.t18 VSS.t66 5.30682
R1513 VSS.t75 VSS.t26 5.30682
R1514 VSS.t57 VSS.t32 5.30682
R1515 VSS.n637 VSS.t63 3.18429
R1516 VSS.n274 VSS.t67 3.18429
R1517 VSS.t74 VSS.n296 3.18429
R1518 VSS.n2 VSS.n0 2.32394
R1519 VSS.n583 VSS.t78 2.12303
R1520 VSS.n8 VSS.n7 1.87394
R1521 VSS.n9 VSS.n8 1.8005
R1522 VSS.n7 VSS.n6 1.8005
R1523 VSS.n6 VSS.n5 1.8005
R1524 VSS.n5 VSS.n4 1.8005
R1525 VSS.n4 VSS.n3 1.8005
R1526 VSS.n3 VSS.n2 1.8005
R1527 VSS.n1 VSS.n0 1.8005
R1528 VSS.n10 VSS.n1 1.75552
R1529 VSS.n10 VSS.t25 1.4016
R1530 VSS VSS.n9 1.3505
R1531 VSS VSS.t25 1.33054
R1532 VSS.n11 VSS.n149 1.16652
R1533 VSS VSS.n11 1.16212
C0 VDD inn 0.42575f
C1 VDD inp 0.40868f
C2 outn inn 0.15791f
C3 outn inp 1.42329f
C4 tail VDD 0.0077f
C5 outp inn 1.15516f
C6 outp inp 0.06069f
C7 nb inn 0.06946f
C8 nb inp 0.06665f
C9 outn tail 8.64113f
C10 tail outp 8.49369f
C11 outn VDD 0.92359f
C12 tail nb 7.2538f
C13 outp VDD 0.32514f
C14 nb VDD 0
C15 inp inn 1.29648f
C16 outn outp 1.69009f
C17 outn nb 0.09657f
C18 tail inn 1.21532f
C19 outp nb 0.10551f
C20 tail inp 1.25108f
C21 outp VSS 3.60781f
C22 outn VSS 3.66381f
C23 VDD VSS 11.6768f
C24 tail VSS 24.05867f
.ends
