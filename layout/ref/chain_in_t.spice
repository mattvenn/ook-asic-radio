* chain_in_t: the input section of xschem/lna_chain.sch (Cin, Rb, Mref; values as layout/ref/lna_chain.spice),
* Cin drawn 15.88 x 61 um (chain_in_tall.py)
.subckt chain_in_t inp inn ibias vcm g1p g1n VSS
XMref ibias ibias VSS VSS sky130_fd_pr__nfet_01v8 L=0.5 W=6 nf=2
XCin_p g1p inp sky130_fd_pr__cap_mim_m3_1 W=15.88 L=61
XRb_p g1p vcm VSS sky130_fd_pr__res_high_po_0p35 L=19.1327 mult=1
XCin_n g1n inn sky130_fd_pr__cap_mim_m3_1 W=15.88 L=61
XRb_n g1n vcm VSS sky130_fd_pr__res_high_po_0p35 L=19.1327 mult=1
.ends
