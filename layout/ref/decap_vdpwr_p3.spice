* decap_vdpwr_p3: layout/gen/decap.py
.subckt decap_vdpwr_p3 VDPWR VGND
XM0 VGND VDPWR VGND VGND sky130_fd_pr__nfet_01v8 L=5 W=14.3 nf=2
XM1 VGND VDPWR VGND VGND sky130_fd_pr__nfet_01v8 L=5 W=14.3 nf=2
XM2 VGND VDPWR VGND VGND sky130_fd_pr__nfet_01v8 L=5 W=14.3 nf=2
.ends
