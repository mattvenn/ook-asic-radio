* decap_vdpwr_p1: layout/gen/decap.py
.subckt decap_vdpwr_p1 VDPWR VGND
XM0 VGND VDPWR VGND VGND sky130_fd_pr__nfet_01v8 L=5 W=8.5 nf=1
XM1 VGND VDPWR VGND VGND sky130_fd_pr__nfet_01v8 L=5 W=8.5 nf=1
XM2 VGND VDPWR VGND VGND sky130_fd_pr__nfet_01v8 L=5 W=8.5 nf=1
XM3 VGND VDPWR VGND VGND sky130_fd_pr__nfet_01v8 L=5 W=8.5 nf=1
XM4 VGND VDPWR VGND VGND sky130_fd_pr__nfet_01v8 L=5 W=8.5 nf=1
XM5 VGND VDPWR VGND VGND sky130_fd_pr__nfet_01v8 L=5 W=8.5 nf=1
.ends
