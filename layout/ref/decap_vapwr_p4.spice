* decap_vapwr_p4: layout/gen/decap.py
.subckt decap_vapwr_p4 VAPWR VGND
XM0 VGND VAPWR VGND VGND sky130_fd_pr__nfet_g5v0d10v5 L=5 W=14.7 nf=2
XM1 VGND VAPWR VGND VGND sky130_fd_pr__nfet_g5v0d10v5 L=5 W=14.7 nf=2
XM2 VGND VAPWR VGND VGND sky130_fd_pr__nfet_g5v0d10v5 L=5 W=14.7 nf=2
XM3 VGND VAPWR VGND VGND sky130_fd_pr__nfet_g5v0d10v5 L=5 W=14.7 nf=2
XM4 VGND VAPWR VGND VGND sky130_fd_pr__nfet_g5v0d10v5 L=5 W=14.7 nf=2
XM5 VGND VAPWR VGND VGND sky130_fd_pr__nfet_g5v0d10v5 L=5 W=14.7 nf=2
XM6 VGND VAPWR VGND VGND sky130_fd_pr__nfet_g5v0d10v5 L=5 W=14.7 nf=2
XM7 VGND VAPWR VGND VGND sky130_fd_pr__nfet_g5v0d10v5 L=5 W=14.7 nf=2
XM8 VGND VAPWR VGND VGND sky130_fd_pr__nfet_g5v0d10v5 L=5 W=14.7 nf=2
XM9 VGND VAPWR VGND VGND sky130_fd_pr__nfet_g5v0d10v5 L=5 W=14.7 nf=2
XM10 VGND VAPWR VGND VGND sky130_fd_pr__nfet_g5v0d10v5 L=5 W=14.7 nf=2
XM11 VGND VAPWR VGND VGND sky130_fd_pr__nfet_g5v0d10v5 L=5 W=14.7 nf=2
XC0 VAPWR VGND sky130_fd_pr__cap_mim_m3_1 W=14.44 L=18.97 m=1
XC1 VAPWR VGND sky130_fd_pr__cap_mim_m3_1 W=14.44 L=18.97 m=1
XC2 VAPWR VGND sky130_fd_pr__cap_mim_m3_1 W=14.44 L=18.97 m=1
XC3 VAPWR VGND sky130_fd_pr__cap_mim_m3_1 W=14.44 L=18.97 m=1
XC4 VAPWR VGND sky130_fd_pr__cap_mim_m3_1 W=14.44 L=18.97 m=1
XC5 VAPWR VGND sky130_fd_pr__cap_mim_m3_1 W=14.44 L=18.97 m=1
.ends
